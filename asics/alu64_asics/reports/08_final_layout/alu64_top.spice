* NGSPICE file created from alu64_top.ext - technology: sky130A

* Black-box entry subcircuit for sky130_fd_sc_hd__fill_1 abstract view
.subckt sky130_fd_sc_hd__fill_1 VGND VNB VPB VPWR
.ends

* Black-box entry subcircuit for sky130_fd_sc_hd__tapvpwrvgnd_1 abstract view
.subckt sky130_fd_sc_hd__tapvpwrvgnd_1 VGND VPWR
.ends

* Black-box entry subcircuit for sky130_fd_sc_hd__decap_3 abstract view
.subckt sky130_fd_sc_hd__decap_3 VGND VNB VPB VPWR
.ends

* Black-box entry subcircuit for sky130_fd_sc_hd__a22o_2 abstract view
.subckt sky130_fd_sc_hd__a22o_2 A1 A2 B1 B2 VGND VNB VPB VPWR X
.ends

* Black-box entry subcircuit for sky130_fd_sc_hd__a21o_2 abstract view
.subckt sky130_fd_sc_hd__a21o_2 A1 A2 B1 VGND VNB VPB VPWR X
.ends

* Black-box entry subcircuit for sky130_fd_sc_hd__and3_2 abstract view
.subckt sky130_fd_sc_hd__and3_2 A B C VGND VNB VPB VPWR X
.ends

* Black-box entry subcircuit for sky130_fd_sc_hd__a21oi_2 abstract view
.subckt sky130_fd_sc_hd__a21oi_2 A1 A2 B1 VGND VNB VPB VPWR Y
.ends

* Black-box entry subcircuit for sky130_fd_sc_hd__a221o_2 abstract view
.subckt sky130_fd_sc_hd__a221o_2 A1 A2 B1 B2 C1 VGND VNB VPB VPWR X
.ends

* Black-box entry subcircuit for sky130_fd_sc_hd__fill_2 abstract view
.subckt sky130_fd_sc_hd__fill_2 VGND VNB VPB VPWR
.ends

* Black-box entry subcircuit for sky130_fd_sc_hd__o21ai_2 abstract view
.subckt sky130_fd_sc_hd__o21ai_2 A1 A2 B1 VGND VNB VPB VPWR Y
.ends

* Black-box entry subcircuit for sky130_fd_sc_hd__mux2_2 abstract view
.subckt sky130_fd_sc_hd__mux2_2 A0 A1 S VGND VNB VPB VPWR X
.ends

* Black-box entry subcircuit for sky130_fd_sc_hd__o211ai_2 abstract view
.subckt sky130_fd_sc_hd__o211ai_2 A1 A2 B1 C1 VGND VNB VPB VPWR Y
.ends

* Black-box entry subcircuit for sky130_fd_sc_hd__or2_2 abstract view
.subckt sky130_fd_sc_hd__or2_2 A B VGND VNB VPB VPWR X
.ends

* Black-box entry subcircuit for sky130_fd_sc_hd__mux4_2 abstract view
.subckt sky130_fd_sc_hd__mux4_2 A0 A1 A2 A3 S0 S1 VGND VNB VPB VPWR X
.ends

* Black-box entry subcircuit for sky130_fd_sc_hd__xnor2_2 abstract view
.subckt sky130_fd_sc_hd__xnor2_2 A B VGND VNB VPB VPWR Y
.ends

* Black-box entry subcircuit for sky130_fd_sc_hd__inv_2 abstract view
.subckt sky130_fd_sc_hd__inv_2 A VGND VNB VPB VPWR Y
.ends

* Black-box entry subcircuit for sky130_fd_sc_hd__o21bai_2 abstract view
.subckt sky130_fd_sc_hd__o21bai_2 A1 A2 B1_N VGND VNB VPB VPWR Y
.ends

* Black-box entry subcircuit for sky130_fd_sc_hd__clkdlybuf4s25_1 abstract view
.subckt sky130_fd_sc_hd__clkdlybuf4s25_1 A VGND VNB VPB VPWR X
.ends

* Black-box entry subcircuit for sky130_fd_sc_hd__nand2_2 abstract view
.subckt sky130_fd_sc_hd__nand2_2 A B VGND VNB VPB VPWR Y
.ends

* Black-box entry subcircuit for sky130_fd_sc_hd__a211oi_2 abstract view
.subckt sky130_fd_sc_hd__a211oi_2 A1 A2 B1 C1 VGND VNB VPB VPWR Y
.ends

* Black-box entry subcircuit for sky130_fd_sc_hd__or3_2 abstract view
.subckt sky130_fd_sc_hd__or3_2 A B C VGND VNB VPB VPWR X
.ends

* Black-box entry subcircuit for sky130_fd_sc_hd__a32o_2 abstract view
.subckt sky130_fd_sc_hd__a32o_2 A1 A2 A3 B1 B2 VGND VNB VPB VPWR X
.ends

* Black-box entry subcircuit for sky130_fd_sc_hd__buf_6 abstract view
.subckt sky130_fd_sc_hd__buf_6 A VGND VNB VPB VPWR X
.ends

* Black-box entry subcircuit for sky130_fd_sc_hd__or3b_2 abstract view
.subckt sky130_fd_sc_hd__or3b_2 A B C_N VGND VNB VPB VPWR X
.ends

* Black-box entry subcircuit for sky130_fd_sc_hd__buf_2 abstract view
.subckt sky130_fd_sc_hd__buf_2 A VGND VNB VPB VPWR X
.ends

* Black-box entry subcircuit for sky130_fd_sc_hd__o21a_2 abstract view
.subckt sky130_fd_sc_hd__o21a_2 A1 A2 B1 VGND VNB VPB VPWR X
.ends

* Black-box entry subcircuit for sky130_fd_sc_hd__a31o_2 abstract view
.subckt sky130_fd_sc_hd__a31o_2 A1 A2 A3 B1 VGND VNB VPB VPWR X
.ends

* Black-box entry subcircuit for sky130_fd_sc_hd__nor2_2 abstract view
.subckt sky130_fd_sc_hd__nor2_2 A B VGND VNB VPB VPWR Y
.ends

* Black-box entry subcircuit for sky130_fd_sc_hd__or4bb_2 abstract view
.subckt sky130_fd_sc_hd__or4bb_2 A B C_N D_N VGND VNB VPB VPWR X
.ends

* Black-box entry subcircuit for sky130_fd_sc_hd__o211a_2 abstract view
.subckt sky130_fd_sc_hd__o211a_2 A1 A2 B1 C1 VGND VNB VPB VPWR X
.ends

* Black-box entry subcircuit for sky130_fd_sc_hd__o21ba_2 abstract view
.subckt sky130_fd_sc_hd__o21ba_2 A1 A2 B1_N VGND VNB VPB VPWR X
.ends

* Black-box entry subcircuit for sky130_fd_sc_hd__nor3_1 abstract view
.subckt sky130_fd_sc_hd__nor3_1 A B C VGND VNB VPB VPWR Y
.ends

* Black-box entry subcircuit for sky130_fd_sc_hd__xor2_2 abstract view
.subckt sky130_fd_sc_hd__xor2_2 A B VGND VNB VPB VPWR X
.ends

* Black-box entry subcircuit for sky130_fd_sc_hd__nor2b_2 abstract view
.subckt sky130_fd_sc_hd__nor2b_2 A B_N VGND VNB VPB VPWR Y
.ends

* Black-box entry subcircuit for sky130_fd_sc_hd__or4_2 abstract view
.subckt sky130_fd_sc_hd__or4_2 A B C D VGND VNB VPB VPWR X
.ends

* Black-box entry subcircuit for sky130_fd_sc_hd__buf_1 abstract view
.subckt sky130_fd_sc_hd__buf_1 A VGND VNB VPB VPWR X
.ends

* Black-box entry subcircuit for sky130_fd_sc_hd__diode_2 abstract view
.subckt sky130_fd_sc_hd__diode_2 DIODE VGND VNB VPB VPWR
.ends

* Black-box entry subcircuit for sky130_fd_sc_hd__and2_2 abstract view
.subckt sky130_fd_sc_hd__and2_2 A B VGND VNB VPB VPWR X
.ends

* Black-box entry subcircuit for sky130_fd_sc_hd__o22a_2 abstract view
.subckt sky130_fd_sc_hd__o22a_2 A1 A2 B1 B2 VGND VNB VPB VPWR X
.ends

* Black-box entry subcircuit for sky130_fd_sc_hd__a21boi_2 abstract view
.subckt sky130_fd_sc_hd__a21boi_2 A1 A2 B1_N VGND VNB VPB VPWR Y
.ends

* Black-box entry subcircuit for sky130_fd_sc_hd__buf_4 abstract view
.subckt sky130_fd_sc_hd__buf_4 A VGND VNB VPB VPWR X
.ends

* Black-box entry subcircuit for sky130_fd_sc_hd__and2b_2 abstract view
.subckt sky130_fd_sc_hd__and2b_2 A_N B VGND VNB VPB VPWR X
.ends

* Black-box entry subcircuit for sky130_fd_sc_hd__a21bo_2 abstract view
.subckt sky130_fd_sc_hd__a21bo_2 A1 A2 B1_N VGND VNB VPB VPWR X
.ends

* Black-box entry subcircuit for sky130_fd_sc_hd__and3b_2 abstract view
.subckt sky130_fd_sc_hd__and3b_2 A_N B C VGND VNB VPB VPWR X
.ends

* Black-box entry subcircuit for sky130_fd_sc_hd__a211o_2 abstract view
.subckt sky130_fd_sc_hd__a211o_2 A1 A2 B1 C1 VGND VNB VPB VPWR X
.ends

* Black-box entry subcircuit for sky130_fd_sc_hd__and4_2 abstract view
.subckt sky130_fd_sc_hd__and4_2 A B C D VGND VNB VPB VPWR X
.ends

* Black-box entry subcircuit for sky130_fd_sc_hd__o31a_2 abstract view
.subckt sky130_fd_sc_hd__o31a_2 A1 A2 A3 B1 VGND VNB VPB VPWR X
.ends

* Black-box entry subcircuit for sky130_fd_sc_hd__nor3b_2 abstract view
.subckt sky130_fd_sc_hd__nor3b_2 A B C_N VGND VNB VPB VPWR Y
.ends

* Black-box entry subcircuit for sky130_fd_sc_hd__o2111a_2 abstract view
.subckt sky130_fd_sc_hd__o2111a_2 A1 A2 B1 C1 D1 VGND VNB VPB VPWR X
.ends

* Black-box entry subcircuit for sky130_fd_sc_hd__or4b_2 abstract view
.subckt sky130_fd_sc_hd__or4b_2 A B C D_N VGND VNB VPB VPWR X
.ends

* Black-box entry subcircuit for sky130_fd_sc_hd__or4_4 abstract view
.subckt sky130_fd_sc_hd__or4_4 A B C D VGND VNB VPB VPWR X
.ends

* Black-box entry subcircuit for sky130_fd_sc_hd__o2bb2a_2 abstract view
.subckt sky130_fd_sc_hd__o2bb2a_2 A1_N A2_N B1 B2 VGND VNB VPB VPWR X
.ends

* Black-box entry subcircuit for sky130_fd_sc_hd__and4b_2 abstract view
.subckt sky130_fd_sc_hd__and4b_2 A_N B C D VGND VNB VPB VPWR X
.ends

* Black-box entry subcircuit for sky130_fd_sc_hd__and4bb_2 abstract view
.subckt sky130_fd_sc_hd__and4bb_2 A_N B_N C D VGND VNB VPB VPWR X
.ends

* Black-box entry subcircuit for sky130_fd_sc_hd__or4b_4 abstract view
.subckt sky130_fd_sc_hd__or4b_4 A B C D_N VGND VNB VPB VPWR X
.ends

* Black-box entry subcircuit for sky130_fd_sc_hd__nand2b_2 abstract view
.subckt sky130_fd_sc_hd__nand2b_2 A_N B VGND VNB VPB VPWR Y
.ends

* Black-box entry subcircuit for sky130_fd_sc_hd__clkbuf_2 abstract view
.subckt sky130_fd_sc_hd__clkbuf_2 A VGND VNB VPB VPWR X
.ends

* Black-box entry subcircuit for sky130_fd_sc_hd__clkbuf_1 abstract view
.subckt sky130_fd_sc_hd__clkbuf_1 A VGND VNB VPB VPWR X
.ends

* Black-box entry subcircuit for sky130_fd_sc_hd__a2bb2o_2 abstract view
.subckt sky130_fd_sc_hd__a2bb2o_2 A1_N A2_N B1 B2 VGND VNB VPB VPWR X
.ends

* Black-box entry subcircuit for sky130_fd_sc_hd__a41o_2 abstract view
.subckt sky130_fd_sc_hd__a41o_2 A1 A2 A3 A4 B1 VGND VNB VPB VPWR X
.ends

* Black-box entry subcircuit for sky130_fd_sc_hd__a22oi_2 abstract view
.subckt sky130_fd_sc_hd__a22oi_2 A1 A2 B1 B2 VGND VNB VPB VPWR Y
.ends

* Black-box entry subcircuit for sky130_fd_sc_hd__or2b_2 abstract view
.subckt sky130_fd_sc_hd__or2b_2 A B_N VGND VNB VPB VPWR X
.ends

* Black-box entry subcircuit for sky130_fd_sc_hd__o311a_2 abstract view
.subckt sky130_fd_sc_hd__o311a_2 A1 A2 A3 B1 C1 VGND VNB VPB VPWR X
.ends

* Black-box entry subcircuit for sky130_fd_sc_hd__a31oi_2 abstract view
.subckt sky130_fd_sc_hd__a31oi_2 A1 A2 A3 B1 VGND VNB VPB VPWR Y
.ends

* Black-box entry subcircuit for sky130_fd_sc_hd__o221a_2 abstract view
.subckt sky130_fd_sc_hd__o221a_2 A1 A2 B1 B2 C1 VGND VNB VPB VPWR X
.ends

* Black-box entry subcircuit for sky130_fd_sc_hd__clkbuf_4 abstract view
.subckt sky130_fd_sc_hd__clkbuf_4 A VGND VNB VPB VPWR X
.ends

* Black-box entry subcircuit for sky130_fd_sc_hd__o2111ai_2 abstract view
.subckt sky130_fd_sc_hd__o2111ai_2 A1 A2 B1 C1 D1 VGND VNB VPB VPWR Y
.ends

* Black-box entry subcircuit for sky130_fd_sc_hd__o221ai_2 abstract view
.subckt sky130_fd_sc_hd__o221ai_2 A1 A2 B1 B2 C1 VGND VNB VPB VPWR Y
.ends

* Black-box entry subcircuit for sky130_fd_sc_hd__a2111o_2 abstract view
.subckt sky130_fd_sc_hd__a2111o_2 A1 A2 B1 C1 D1 VGND VNB VPB VPWR X
.ends

* Black-box entry subcircuit for sky130_fd_sc_hd__buf_8 abstract view
.subckt sky130_fd_sc_hd__buf_8 A VGND VNB VPB VPWR X
.ends

* Black-box entry subcircuit for sky130_fd_sc_hd__nand3_2 abstract view
.subckt sky130_fd_sc_hd__nand3_2 A B C VGND VNB VPB VPWR Y
.ends

* Black-box entry subcircuit for sky130_fd_sc_hd__nor3_2 abstract view
.subckt sky130_fd_sc_hd__nor3_2 A B C VGND VNB VPB VPWR Y
.ends

* Black-box entry subcircuit for sky130_fd_sc_hd__o32a_2 abstract view
.subckt sky130_fd_sc_hd__o32a_2 A1 A2 A3 B1 B2 VGND VNB VPB VPWR X
.ends

* Black-box entry subcircuit for sky130_fd_sc_hd__nand3b_2 abstract view
.subckt sky130_fd_sc_hd__nand3b_2 A_N B C VGND VNB VPB VPWR Y
.ends

* Black-box entry subcircuit for sky130_fd_sc_hd__and4bb_4 abstract view
.subckt sky130_fd_sc_hd__and4bb_4 A_N B_N C D VGND VNB VPB VPWR X
.ends

* Black-box entry subcircuit for sky130_fd_sc_hd__a311oi_2 abstract view
.subckt sky130_fd_sc_hd__a311oi_2 A1 A2 A3 B1 C1 VGND VNB VPB VPWR Y
.ends

* Black-box entry subcircuit for sky130_fd_sc_hd__o22ai_2 abstract view
.subckt sky130_fd_sc_hd__o22ai_2 A1 A2 B1 B2 VGND VNB VPB VPWR Y
.ends

* Black-box entry subcircuit for sky130_fd_sc_hd__o31ai_4 abstract view
.subckt sky130_fd_sc_hd__o31ai_4 A1 A2 A3 B1 VGND VNB VPB VPWR Y
.ends

* Black-box entry subcircuit for sky130_fd_sc_hd__a2111oi_2 abstract view
.subckt sky130_fd_sc_hd__a2111oi_2 A1 A2 B1 C1 D1 VGND VNB VPB VPWR Y
.ends

* Black-box entry subcircuit for sky130_fd_sc_hd__or3_4 abstract view
.subckt sky130_fd_sc_hd__or3_4 A B C VGND VNB VPB VPWR X
.ends

* Black-box entry subcircuit for sky130_fd_sc_hd__nor4_2 abstract view
.subckt sky130_fd_sc_hd__nor4_2 A B C D VGND VNB VPB VPWR Y
.ends

* Black-box entry subcircuit for sky130_fd_sc_hd__a311o_2 abstract view
.subckt sky130_fd_sc_hd__a311o_2 A1 A2 A3 B1 C1 VGND VNB VPB VPWR X
.ends

* Black-box entry subcircuit for sky130_fd_sc_hd__nand4_2 abstract view
.subckt sky130_fd_sc_hd__nand4_2 A B C D VGND VNB VPB VPWR Y
.ends

* Black-box entry subcircuit for sky130_fd_sc_hd__o32ai_2 abstract view
.subckt sky130_fd_sc_hd__o32ai_2 A1 A2 A3 B1 B2 VGND VNB VPB VPWR Y
.ends

* Black-box entry subcircuit for sky130_fd_sc_hd__o41a_2 abstract view
.subckt sky130_fd_sc_hd__o41a_2 A1 A2 A3 A4 B1 VGND VNB VPB VPWR X
.ends

* Black-box entry subcircuit for sky130_fd_sc_hd__o31ai_2 abstract view
.subckt sky130_fd_sc_hd__o31ai_2 A1 A2 A3 B1 VGND VNB VPB VPWR Y
.ends

* Black-box entry subcircuit for sky130_fd_sc_hd__nor4b_2 abstract view
.subckt sky130_fd_sc_hd__nor4b_2 A B C D_N VGND VNB VPB VPWR Y
.ends

* Black-box entry subcircuit for sky130_fd_sc_hd__a221oi_2 abstract view
.subckt sky130_fd_sc_hd__a221oi_2 A1 A2 B1 B2 C1 VGND VNB VPB VPWR Y
.ends

* Black-box entry subcircuit for sky130_fd_sc_hd__xnor2_4 abstract view
.subckt sky130_fd_sc_hd__xnor2_4 A B VGND VNB VPB VPWR Y
.ends

* Black-box entry subcircuit for sky130_fd_sc_hd__and3_4 abstract view
.subckt sky130_fd_sc_hd__and3_4 A B C VGND VNB VPB VPWR X
.ends

* Black-box entry subcircuit for sky130_fd_sc_hd__nor4_4 abstract view
.subckt sky130_fd_sc_hd__nor4_4 A B C D VGND VNB VPB VPWR Y
.ends

* Black-box entry subcircuit for sky130_fd_sc_hd__or3b_4 abstract view
.subckt sky130_fd_sc_hd__or3b_4 A B C_N VGND VNB VPB VPWR X
.ends

* Black-box entry subcircuit for sky130_fd_sc_hd__nor3b_4 abstract view
.subckt sky130_fd_sc_hd__nor3b_4 A B C_N VGND VNB VPB VPWR Y
.ends

* Black-box entry subcircuit for sky130_fd_sc_hd__o311ai_2 abstract view
.subckt sky130_fd_sc_hd__o311ai_2 A1 A2 A3 B1 C1 VGND VNB VPB VPWR Y
.ends

* Black-box entry subcircuit for sky130_fd_sc_hd__a41oi_2 abstract view
.subckt sky130_fd_sc_hd__a41oi_2 A1 A2 A3 A4 B1 VGND VNB VPB VPWR Y
.ends

* Black-box entry subcircuit for sky130_fd_sc_hd__nor2b_4 abstract view
.subckt sky130_fd_sc_hd__nor2b_4 A B_N VGND VNB VPB VPWR Y
.ends

* Black-box entry subcircuit for sky130_fd_sc_hd__nand4b_2 abstract view
.subckt sky130_fd_sc_hd__nand4b_2 A_N B C D VGND VNB VPB VPWR Y
.ends

.subckt alu64_top VGND VPWR carry_in carry_out clk cmd[0] cmd[1] cmd[2] cmd[3] negative_flag
+ operand_a[0] operand_a[10] operand_a[11] operand_a[12] operand_a[13] operand_a[14]
+ operand_a[15] operand_a[16] operand_a[17] operand_a[18] operand_a[19] operand_a[1]
+ operand_a[20] operand_a[21] operand_a[22] operand_a[23] operand_a[24] operand_a[25]
+ operand_a[26] operand_a[27] operand_a[28] operand_a[29] operand_a[2] operand_a[30]
+ operand_a[31] operand_a[32] operand_a[33] operand_a[34] operand_a[35] operand_a[36]
+ operand_a[37] operand_a[38] operand_a[39] operand_a[3] operand_a[40] operand_a[41]
+ operand_a[42] operand_a[43] operand_a[44] operand_a[45] operand_a[46] operand_a[47]
+ operand_a[48] operand_a[49] operand_a[4] operand_a[50] operand_a[51] operand_a[52]
+ operand_a[53] operand_a[54] operand_a[55] operand_a[56] operand_a[57] operand_a[58]
+ operand_a[59] operand_a[5] operand_a[60] operand_a[61] operand_a[62] operand_a[63]
+ operand_a[6] operand_a[7] operand_a[8] operand_a[9] operand_b[0] operand_b[10] operand_b[11]
+ operand_b[12] operand_b[13] operand_b[14] operand_b[15] operand_b[16] operand_b[17]
+ operand_b[18] operand_b[19] operand_b[1] operand_b[20] operand_b[21] operand_b[22]
+ operand_b[23] operand_b[24] operand_b[25] operand_b[26] operand_b[27] operand_b[28]
+ operand_b[29] operand_b[2] operand_b[30] operand_b[31] operand_b[32] operand_b[33]
+ operand_b[34] operand_b[35] operand_b[36] operand_b[37] operand_b[38] operand_b[39]
+ operand_b[3] operand_b[40] operand_b[41] operand_b[42] operand_b[43] operand_b[44]
+ operand_b[45] operand_b[46] operand_b[47] operand_b[48] operand_b[49] operand_b[4]
+ operand_b[50] operand_b[51] operand_b[52] operand_b[53] operand_b[54] operand_b[55]
+ operand_b[56] operand_b[57] operand_b[58] operand_b[59] operand_b[5] operand_b[60]
+ operand_b[61] operand_b[62] operand_b[63] operand_b[6] operand_b[7] operand_b[8]
+ operand_b[9] overflow_flag result[0] result[10] result[11] result[12] result[13]
+ result[14] result[15] result[16] result[17] result[18] result[19] result[1] result[20]
+ result[21] result[22] result[23] result[24] result[25] result[26] result[27] result[28]
+ result[29] result[2] result[30] result[31] result[32] result[33] result[34] result[35]
+ result[36] result[37] result[38] result[39] result[3] result[40] result[41] result[42]
+ result[43] result[44] result[45] result[46] result[47] result[48] result[49] result[4]
+ result[50] result[51] result[52] result[53] result[54] result[55] result[56] result[57]
+ result[58] result[59] result[5] result[60] result[61] result[62] result[63] result[6]
+ result[7] result[8] result[9] rst_n zero_flag
XFILLER_39_288 VGND VGND VPWR VPWR sky130_fd_sc_hd__fill_1
XTAP_TAPCELL_ROW_65_765 VGND VPWR sky130_fd_sc_hd__tapvpwrvgnd_1
XFILLER_62_280 VGND VGND VPWR VPWR sky130_fd_sc_hd__decap_3
X_3988_ _4339_/A _3984_/X _3987_/X _3883_/A VGND VGND VPWR VPWR _3988_/X sky130_fd_sc_hd__a22o_2
X_5727_ _5688_/X _5692_/X _6349_/A VGND VGND VPWR VPWR _5727_/X sky130_fd_sc_hd__a21o_2
XTAP_TAPCELL_ROW_20_356 VGND VPWR sky130_fd_sc_hd__tapvpwrvgnd_1
X_5658_ _5658_/A _5658_/B _5658_/C VGND VGND VPWR VPWR _5658_/X sky130_fd_sc_hd__and3_2
X_5589_ _5587_/A _4281_/X _5588_/X VGND VGND VPWR VPWR _5589_/Y sky130_fd_sc_hd__a21oi_2
X_4609_ _4687_/D _4591_/X _4595_/X _4761_/A _4608_/X VGND VGND VPWR VPWR _4609_/X
+ sky130_fd_sc_hd__a221o_2
XFILLER_18_439 VGND VGND VPWR VPWR sky130_fd_sc_hd__fill_2
XFILLER_45_203 VGND VGND VPWR VPWR sky130_fd_sc_hd__decap_3
XFILLER_45_225 VGND VGND VPWR VPWR sky130_fd_sc_hd__decap_3
XTAP_TAPCELL_ROW_28_434 VGND VPWR sky130_fd_sc_hd__tapvpwrvgnd_1
XFILLER_13_133 VGND VGND VPWR VPWR sky130_fd_sc_hd__decap_3
XFILLER_26_85 VGND VGND VPWR VPWR sky130_fd_sc_hd__fill_2
XFILLER_60_239 VGND VGND VPWR VPWR sky130_fd_sc_hd__decap_3
XFILLER_13_188 VGND VGND VPWR VPWR sky130_fd_sc_hd__fill_1
XFILLER_42_95 VGND VGND VPWR VPWR sky130_fd_sc_hd__fill_1
XFILLER_68_339 VGND VGND VPWR VPWR sky130_fd_sc_hd__fill_2
XFILLER_36_203 VGND VGND VPWR VPWR sky130_fd_sc_hd__decap_3
XFILLER_36_269 VGND VGND VPWR VPWR sky130_fd_sc_hd__decap_3
XFILLER_51_217 VGND VGND VPWR VPWR sky130_fd_sc_hd__decap_3
XFILLER_51_228 VGND VGND VPWR VPWR sky130_fd_sc_hd__decap_3
X_4960_ _4997_/B _4997_/C _5108_/A VGND VGND VPWR VPWR _4962_/A sky130_fd_sc_hd__a21o_2
XFILLER_44_280 VGND VGND VPWR VPWR sky130_fd_sc_hd__fill_1
X_4891_ _5050_/A _4886_/X _4890_/X _4848_/A _5228_/A VGND VGND VPWR VPWR _4891_/X
+ sky130_fd_sc_hd__a221o_2
X_3911_ _3876_/S _3907_/X _3910_/X VGND VGND VPWR VPWR _3912_/B sky130_fd_sc_hd__o21ai_2
XTAP_TAPCELL_ROW_62_735 VGND VPWR sky130_fd_sc_hd__tapvpwrvgnd_1
X_3842_ _3791_/X _3841_/X _3842_/S VGND VGND VPWR VPWR _3842_/X sky130_fd_sc_hd__mux2_2
X_5512_ _5739_/B _4194_/X _5440_/A VGND VGND VPWR VPWR _5512_/Y sky130_fd_sc_hd__o21ai_2
X_3773_ _3752_/X _3772_/Y _3727_/A _3814_/B VGND VGND VPWR VPWR _3774_/C sky130_fd_sc_hd__o211ai_2
X_6492_ _6492_/A _6492_/B VGND VGND VPWR VPWR _6492_/X sky130_fd_sc_hd__or2_2
X_5443_ _4461_/X _4804_/X _5133_/X _5442_/X _6106_/A _5137_/A VGND VGND VPWR VPWR
+ _5444_/B sky130_fd_sc_hd__mux4_2
X_5374_ _5374_/A _5374_/B VGND VGND VPWR VPWR _5374_/Y sky130_fd_sc_hd__xnor2_2
X_4325_ _4325_/A VGND VGND VPWR VPWR _4325_/Y sky130_fd_sc_hd__inv_2
X_4256_ _4302_/A1 _4431_/A _4255_/Y VGND VGND VPWR VPWR _4256_/Y sky130_fd_sc_hd__o21bai_2
X_4187_ _4267_/A _4231_/B VGND VGND VPWR VPWR _4187_/Y sky130_fd_sc_hd__xnor2_2
XFILLER_74_309 VGND VGND VPWR VPWR sky130_fd_sc_hd__fill_1
XFILLER_67_361 VGND VGND VPWR VPWR sky130_fd_sc_hd__decap_3
XFILLER_27_225 VGND VGND VPWR VPWR sky130_fd_sc_hd__decap_3
XTAP_TAPCELL_ROW_25_404 VGND VPWR sky130_fd_sc_hd__tapvpwrvgnd_1
XFILLER_50_250 VGND VGND VPWR VPWR sky130_fd_sc_hd__fill_2
XFILLER_50_261 VGND VGND VPWR VPWR sky130_fd_sc_hd__decap_3
XFILLER_50_283 VGND VGND VPWR VPWR sky130_fd_sc_hd__decap_3
XFILLER_10_158 VGND VGND VPWR VPWR sky130_fd_sc_hd__decap_3
XFILLER_10_169 VGND VGND VPWR VPWR sky130_fd_sc_hd__fill_1
Xfanout650 input114/X VGND VGND VPWR VPWR _5508_/A1 sky130_fd_sc_hd__clkdlybuf4s25_1
Xfanout661 _5458_/A VGND VGND VPWR VPWR _6339_/A sky130_fd_sc_hd__clkdlybuf4s25_1
Xfanout672 input107/X VGND VGND VPWR VPWR _5270_/A2 sky130_fd_sc_hd__clkdlybuf4s25_1
Xfanout683 _4465_/S VGND VGND VPWR VPWR _6442_/A sky130_fd_sc_hd__clkdlybuf4s25_1
Xfanout694 input100/X VGND VGND VPWR VPWR _6270_/A sky130_fd_sc_hd__clkdlybuf4s25_1
XFILLER_18_214 VGND VGND VPWR VPWR sky130_fd_sc_hd__fill_2
XFILLER_58_361 VGND VGND VPWR VPWR sky130_fd_sc_hd__decap_3
XFILLER_33_217 VGND VGND VPWR VPWR sky130_fd_sc_hd__decap_3
XFILLER_73_386 VGND VGND VPWR VPWR sky130_fd_sc_hd__fill_1
XFILLER_33_228 VGND VGND VPWR VPWR sky130_fd_sc_hd__decap_3
XFILLER_41_261 VGND VGND VPWR VPWR sky130_fd_sc_hd__decap_3
XFILLER_68_103 VGND VGND VPWR VPWR sky130_fd_sc_hd__fill_1
X_5090_ _6442_/B _5090_/B VGND VGND VPWR VPWR _5090_/Y sky130_fd_sc_hd__nand2_2
X_4110_ _4106_/X _6167_/B _4109_/X VGND VGND VPWR VPWR _4110_/X sky130_fd_sc_hd__a21o_2
XFILLER_56_309 VGND VGND VPWR VPWR sky130_fd_sc_hd__decap_3
X_4041_ _4021_/S input75/X _4004_/A _4076_/D VGND VGND VPWR VPWR _4046_/B sky130_fd_sc_hd__a211oi_2
XFILLER_49_372 VGND VGND VPWR VPWR sky130_fd_sc_hd__decap_3
XTAP_TAPCELL_ROW_39_529 VGND VPWR sky130_fd_sc_hd__tapvpwrvgnd_1
XFILLER_64_331 VGND VGND VPWR VPWR sky130_fd_sc_hd__decap_3
XFILLER_24_206 VGND VGND VPWR VPWR sky130_fd_sc_hd__decap_3
XFILLER_52_515 VGND VGND VPWR VPWR sky130_fd_sc_hd__fill_1
X_5992_ _5992_/A _5992_/B _5992_/C VGND VGND VPWR VPWR _5993_/D sky130_fd_sc_hd__or3_2
XFILLER_64_375 VGND VGND VPWR VPWR sky130_fd_sc_hd__decap_3
X_4943_ _4940_/X _4941_/X _4943_/S VGND VGND VPWR VPWR _4943_/X sky130_fd_sc_hd__mux2_2
XFILLER_32_250 VGND VGND VPWR VPWR sky130_fd_sc_hd__fill_2
X_4874_ _4874_/A _4874_/B VGND VGND VPWR VPWR _4874_/Y sky130_fd_sc_hd__xnor2_2
XFILLER_20_434 VGND VGND VPWR VPWR sky130_fd_sc_hd__fill_2
XFILLER_20_467 VGND VGND VPWR VPWR sky130_fd_sc_hd__fill_2
XFILLER_32_294 VGND VGND VPWR VPWR sky130_fd_sc_hd__decap_3
X_3825_ _3840_/S _3825_/B VGND VGND VPWR VPWR _3825_/Y sky130_fd_sc_hd__nand2_2
X_3756_ _3432_/A _3753_/Y _3755_/X VGND VGND VPWR VPWR _3756_/Y sky130_fd_sc_hd__a21oi_2
XTAP_TAPCELL_ROW_30_451 VGND VPWR sky130_fd_sc_hd__tapvpwrvgnd_1
X_6475_ _6474_/A _6454_/A _6472_/X _6473_/X _6474_/Y VGND VGND VPWR VPWR _6485_/B
+ sky130_fd_sc_hd__a32o_2
X_5426_ _5425_/A _5425_/B _5418_/C VGND VGND VPWR VPWR _5426_/X sky130_fd_sc_hd__a21o_2
X_3687_ _3687_/A VGND VGND VPWR VPWR _3814_/B sky130_fd_sc_hd__buf_6
X_5357_ _4761_/X _5340_/X _5360_/A _5168_/A _5356_/X VGND VGND VPWR VPWR _5357_/X
+ sky130_fd_sc_hd__a221o_2
X_5288_ _5316_/A VGND VGND VPWR VPWR _6294_/A sky130_fd_sc_hd__inv_2
X_4308_ _4266_/B _4303_/Y _4306_/X _6199_/A _4353_/C VGND VGND VPWR VPWR _4308_/X
+ sky130_fd_sc_hd__a221o_2
X_4239_ _4239_/A VGND VGND VPWR VPWR _4240_/S sky130_fd_sc_hd__inv_2
XFILLER_59_169 VGND VGND VPWR VPWR sky130_fd_sc_hd__decap_3
XFILLER_15_206 VGND VGND VPWR VPWR sky130_fd_sc_hd__fill_2
XFILLER_55_375 VGND VGND VPWR VPWR sky130_fd_sc_hd__decap_3
XTAP_TAPCELL_ROW_2_198 VGND VPWR sky130_fd_sc_hd__tapvpwrvgnd_1
XFILLER_82_194 VGND VGND VPWR VPWR sky130_fd_sc_hd__fill_2
XFILLER_70_334 VGND VGND VPWR VPWR sky130_fd_sc_hd__decap_3
XFILLER_38_309 VGND VGND VPWR VPWR sky130_fd_sc_hd__decap_3
Xfanout480 input56/X VGND VGND VPWR VPWR _6440_/A2 sky130_fd_sc_hd__clkdlybuf4s25_1
Xfanout491 _3548_/B VGND VGND VPWR VPWR _6108_/B sky130_fd_sc_hd__clkdlybuf4s25_1
XFILLER_0_57 VGND VGND VPWR VPWR sky130_fd_sc_hd__decap_3
XFILLER_46_353 VGND VGND VPWR VPWR sky130_fd_sc_hd__decap_3
XFILLER_46_397 VGND VGND VPWR VPWR sky130_fd_sc_hd__decap_3
XTAP_TAPCELL_ROW_72_830 VGND VPWR sky130_fd_sc_hd__tapvpwrvgnd_1
XFILLER_73_194 VGND VGND VPWR VPWR sky130_fd_sc_hd__decap_3
XFILLER_61_323 VGND VGND VPWR VPWR sky130_fd_sc_hd__decap_3
XFILLER_61_367 VGND VGND VPWR VPWR sky130_fd_sc_hd__decap_3
XTAP_TAPCELL_ROW_44_576 VGND VPWR sky130_fd_sc_hd__tapvpwrvgnd_1
X_4590_ _6193_/S _6233_/A _4549_/B _4582_/S VGND VGND VPWR VPWR _4590_/Y sky130_fd_sc_hd__a211oi_2
X_3610_ _3679_/A _3679_/C _3679_/D VGND VGND VPWR VPWR _3610_/X sky130_fd_sc_hd__or3_2
X_3541_ _3572_/S _3799_/A _3748_/B VGND VGND VPWR VPWR _3541_/X sky130_fd_sc_hd__or3b_2
Xmax_cap625 _6042_/A VGND VGND VPWR VPWR _5885_/A sky130_fd_sc_hd__buf_2
XFILLER_50_3 VGND VGND VPWR VPWR sky130_fd_sc_hd__decap_3
X_6260_ _6055_/B _6259_/Y _4923_/B VGND VGND VPWR VPWR _6260_/X sky130_fd_sc_hd__o21a_2
X_3472_ _4200_/A _4199_/A _3679_/A VGND VGND VPWR VPWR _3472_/X sky130_fd_sc_hd__mux2_2
X_6191_ _6192_/A _6233_/C VGND VGND VPWR VPWR _6191_/X sky130_fd_sc_hd__or2_2
X_5211_ _6391_/A _6383_/A _6306_/C _6391_/B VGND VGND VPWR VPWR _5211_/X sky130_fd_sc_hd__a22o_2
X_5142_ _5137_/Y _5141_/Y _5090_/B VGND VGND VPWR VPWR _5142_/X sky130_fd_sc_hd__a21o_2
X_5073_ _5072_/B _5072_/C _5072_/D _5123_/C VGND VGND VPWR VPWR _5120_/B sky130_fd_sc_hd__a31o_2
XFILLER_69_489 VGND VGND VPWR VPWR sky130_fd_sc_hd__fill_2
XFILLER_37_331 VGND VGND VPWR VPWR sky130_fd_sc_hd__decap_3
X_4024_ _6158_/A _4111_/A _4018_/X _4021_/X _4023_/X VGND VGND VPWR VPWR _4024_/X
+ sky130_fd_sc_hd__a221o_2
X_5975_ _5975_/A _5976_/B _5975_/C VGND VGND VPWR VPWR _5975_/X sky130_fd_sc_hd__and3_2
X_4926_ _4926_/A _5535_/B VGND VGND VPWR VPWR _4927_/D sky130_fd_sc_hd__nor2_2
X_4857_ _4967_/B _4953_/A _4927_/C _4927_/B VGND VGND VPWR VPWR _4874_/A sky130_fd_sc_hd__or4bb_2
XFILLER_20_253 VGND VGND VPWR VPWR sky130_fd_sc_hd__fill_1
XFILLER_20_275 VGND VGND VPWR VPWR sky130_fd_sc_hd__decap_3
X_3808_ _3704_/A _3785_/Y _3796_/Y _3807_/X VGND VGND VPWR VPWR _3808_/X sky130_fd_sc_hd__o211a_2
X_4788_ _4954_/A _4854_/B VGND VGND VPWR VPWR _4791_/A sky130_fd_sc_hd__xnor2_2
XFILLER_4_419 VGND VGND VPWR VPWR sky130_fd_sc_hd__fill_1
X_3739_ _6015_/A _3670_/X _3738_/X input67/X VGND VGND VPWR VPWR _3739_/X sky130_fd_sc_hd__a31o_2
X_6458_ input13/X _6458_/A1 _4241_/C input14/X _4099_/S _6438_/X VGND VGND VPWR VPWR
+ _6458_/X sky130_fd_sc_hd__mux4_2
X_6389_ _6392_/B _6304_/X _6391_/D VGND VGND VPWR VPWR _6389_/X sky130_fd_sc_hd__o21ba_2
X_5409_ _5424_/A _5409_/B VGND VGND VPWR VPWR _5409_/Y sky130_fd_sc_hd__nor2_2
XTAP_TAPCELL_ROW_7_246 VGND VPWR sky130_fd_sc_hd__tapvpwrvgnd_1
XFILLER_75_437 VGND VGND VPWR VPWR sky130_fd_sc_hd__decap_3
XFILLER_28_342 VGND VGND VPWR VPWR sky130_fd_sc_hd__decap_3
XFILLER_16_515 VGND VGND VPWR VPWR sky130_fd_sc_hd__fill_1
XFILLER_55_161 VGND VGND VPWR VPWR sky130_fd_sc_hd__decap_3
XFILLER_43_334 VGND VGND VPWR VPWR sky130_fd_sc_hd__fill_2
XFILLER_70_186 VGND VGND VPWR VPWR sky130_fd_sc_hd__decap_3
XTAP_TAPCELL_ROW_41_546 VGND VPWR sky130_fd_sc_hd__tapvpwrvgnd_1
XFILLER_70_197 VGND VGND VPWR VPWR sky130_fd_sc_hd__decap_3
XFILLER_50_73 VGND VGND VPWR VPWR sky130_fd_sc_hd__decap_3
XFILLER_78_253 VGND VGND VPWR VPWR sky130_fd_sc_hd__decap_3
XTAP_TAPCELL_ROW_49_624 VGND VPWR sky130_fd_sc_hd__tapvpwrvgnd_1
XFILLER_19_364 VGND VGND VPWR VPWR sky130_fd_sc_hd__decap_3
XTAP_TAPCELL_ROW_57_690 VGND VPWR sky130_fd_sc_hd__tapvpwrvgnd_1
XFILLER_34_345 VGND VGND VPWR VPWR sky130_fd_sc_hd__decap_3
X_5760_ _5760_/A _5760_/B _5760_/C VGND VGND VPWR VPWR _5760_/Y sky130_fd_sc_hd__nor3_1
X_5691_ _5689_/X _5690_/X _5637_/X VGND VGND VPWR VPWR _5691_/X sky130_fd_sc_hd__o21a_2
X_4711_ _4967_/C _4790_/A VGND VGND VPWR VPWR _4711_/X sky130_fd_sc_hd__xor2_2
X_4642_ _4800_/B _4642_/B VGND VGND VPWR VPWR _4642_/Y sky130_fd_sc_hd__nand2_2
X_4573_ _4599_/A _6233_/B VGND VGND VPWR VPWR _4578_/B sky130_fd_sc_hd__nor2b_2
X_6312_ _6337_/A _6312_/B _6312_/C VGND VGND VPWR VPWR _6313_/D sky130_fd_sc_hd__and3_2
X_3524_ _6113_/B _3524_/B VGND VGND VPWR VPWR _3524_/X sky130_fd_sc_hd__or2_2
X_6243_ _6243_/A _6243_/B _6243_/C _6243_/D VGND VGND VPWR VPWR _6243_/X sky130_fd_sc_hd__or4_2
X_3455_ _5590_/A1 _3896_/B _3799_/A VGND VGND VPWR VPWR _3455_/X sky130_fd_sc_hd__mux2_2
XFILLER_6_290 VGND VGND VPWR VPWR sky130_fd_sc_hd__fill_2
X_6174_ _6174_/A _6200_/C VGND VGND VPWR VPWR _6175_/B sky130_fd_sc_hd__xnor2_2
X_3386_ _3535_/A _3382_/X _4875_/B _3710_/A _6114_/A VGND VGND VPWR VPWR _3386_/X
+ sky130_fd_sc_hd__a221o_2
XFILLER_69_231 VGND VGND VPWR VPWR sky130_fd_sc_hd__decap_3
X_5125_ _4939_/Y _4978_/X _5123_/B _4943_/S VGND VGND VPWR VPWR _5125_/Y sky130_fd_sc_hd__a211oi_2
XTAP_TAPCELL_ROW_4_216 VGND VPWR sky130_fd_sc_hd__tapvpwrvgnd_1
X_5056_ _6275_/A VGND VGND VPWR VPWR _5057_/S sky130_fd_sc_hd__inv_2
X_4007_ _4265_/A _4708_/A VGND VGND VPWR VPWR _4008_/B sky130_fd_sc_hd__or2_2
XFILLER_25_334 VGND VGND VPWR VPWR sky130_fd_sc_hd__fill_2
XFILLER_52_153 VGND VGND VPWR VPWR sky130_fd_sc_hd__decap_3
XFILLER_40_315 VGND VGND VPWR VPWR sky130_fd_sc_hd__decap_3
X_5958_ _5958_/A VGND VGND VPWR VPWR _6498_/A sky130_fd_sc_hd__buf_1
XFILLER_52_197 VGND VGND VPWR VPWR sky130_fd_sc_hd__decap_3
X_4909_ _4909_/A VGND VGND VPWR VPWR _5535_/A sky130_fd_sc_hd__buf_1
X_5889_ _5909_/A _5922_/A _5922_/B VGND VGND VPWR VPWR _5889_/X sky130_fd_sc_hd__and3_2
XFILLER_48_404 VGND VGND VPWR VPWR sky130_fd_sc_hd__decap_3
XFILLER_48_448 VGND VGND VPWR VPWR sky130_fd_sc_hd__decap_3
XFILLER_75_234 VGND VGND VPWR VPWR sky130_fd_sc_hd__fill_1
XFILLER_75_256 VGND VGND VPWR VPWR sky130_fd_sc_hd__decap_3
XFILLER_63_407 VGND VGND VPWR VPWR sky130_fd_sc_hd__decap_3
XFILLER_43_153 VGND VGND VPWR VPWR sky130_fd_sc_hd__decap_3
XFILLER_31_337 VGND VGND VPWR VPWR sky130_fd_sc_hd__decap_3
XANTENNA_5 _4842_/A VGND VGND VPWR VPWR sky130_fd_sc_hd__diode_2
X_3240_ _3784_/A _3232_/X _3239_/X VGND VGND VPWR VPWR _3240_/Y sky130_fd_sc_hd__o21ai_2
XFILLER_66_245 VGND VGND VPWR VPWR sky130_fd_sc_hd__fill_2
XFILLER_81_204 VGND VGND VPWR VPWR sky130_fd_sc_hd__fill_1
XFILLER_66_256 VGND VGND VPWR VPWR sky130_fd_sc_hd__decap_3
XFILLER_81_237 VGND VGND VPWR VPWR sky130_fd_sc_hd__decap_3
XFILLER_19_194 VGND VGND VPWR VPWR sky130_fd_sc_hd__fill_2
XFILLER_34_131 VGND VGND VPWR VPWR sky130_fd_sc_hd__decap_3
XFILLER_34_175 VGND VGND VPWR VPWR sky130_fd_sc_hd__decap_3
X_5812_ _5849_/B _5847_/B VGND VGND VPWR VPWR _5813_/A sky130_fd_sc_hd__and2_2
XFILLER_34_197 VGND VGND VPWR VPWR sky130_fd_sc_hd__decap_3
X_5743_ _5859_/A _4464_/X _5742_/Y VGND VGND VPWR VPWR _5743_/Y sky130_fd_sc_hd__a21oi_2
X_5674_ _5714_/A _5674_/B VGND VGND VPWR VPWR _5674_/X sky130_fd_sc_hd__and2_2
X_4625_ _6193_/S input88/X input89/X _4599_/A VGND VGND VPWR VPWR _4625_/X sky130_fd_sc_hd__o22a_2
X_4556_ _6473_/S _4550_/X _4555_/X VGND VGND VPWR VPWR _4556_/Y sky130_fd_sc_hd__a21boi_2
Xmax_cap252 _4118_/A VGND VGND VPWR VPWR _4498_/B sky130_fd_sc_hd__buf_2
Xmax_cap241 _4379_/S VGND VGND VPWR VPWR _4140_/A sky130_fd_sc_hd__buf_2
X_3507_ _3503_/X _3504_/X _3505_/X _3506_/X _3571_/S _3572_/S VGND VGND VPWR VPWR
+ _3508_/B sky130_fd_sc_hd__mux4_2
Xmax_cap296 _3310_/Y VGND VGND VPWR VPWR _4146_/A sky130_fd_sc_hd__buf_2
Xmax_cap285 _5136_/A VGND VGND VPWR VPWR _4973_/A sky130_fd_sc_hd__buf_4
X_4487_ _4546_/A _6189_/B VGND VGND VPWR VPWR _4487_/X sky130_fd_sc_hd__and2b_2
X_6226_ _6224_/Y _6225_/X _4546_/A VGND VGND VPWR VPWR _6227_/C sky130_fd_sc_hd__a21bo_2
X_3438_ _6449_/A0 _6449_/A1 _6439_/A0 _5615_/A3 _3631_/S0 _3631_/S1 VGND VGND VPWR
+ VPWR _3438_/X sky130_fd_sc_hd__mux4_2
X_6157_ _6162_/A _6162_/B VGND VGND VPWR VPWR _6157_/Y sky130_fd_sc_hd__xnor2_2
X_3369_ _3694_/B _3369_/B _3735_/A VGND VGND VPWR VPWR _3370_/A sky130_fd_sc_hd__and3b_2
X_5108_ _5108_/A _5108_/B VGND VGND VPWR VPWR _5109_/B sky130_fd_sc_hd__or2_2
XFILLER_66_39 VGND VGND VPWR VPWR sky130_fd_sc_hd__fill_1
XFILLER_57_245 VGND VGND VPWR VPWR sky130_fd_sc_hd__decap_3
XFILLER_57_212 VGND VGND VPWR VPWR sky130_fd_sc_hd__decap_3
X_6088_ _6088_/A _6138_/B VGND VGND VPWR VPWR _6088_/X sky130_fd_sc_hd__xor2_2
XFILLER_57_278 VGND VGND VPWR VPWR sky130_fd_sc_hd__fill_2
X_5039_ _5108_/A _5039_/B VGND VGND VPWR VPWR _5123_/B sky130_fd_sc_hd__nand2_2
XFILLER_25_131 VGND VGND VPWR VPWR sky130_fd_sc_hd__decap_3
XFILLER_82_27 VGND VGND VPWR VPWR sky130_fd_sc_hd__fill_1
XFILLER_13_315 VGND VGND VPWR VPWR sky130_fd_sc_hd__decap_3
XFILLER_25_164 VGND VGND VPWR VPWR sky130_fd_sc_hd__decap_3
XFILLER_80_270 VGND VGND VPWR VPWR sky130_fd_sc_hd__decap_3
XFILLER_15_98 VGND VGND VPWR VPWR sky130_fd_sc_hd__decap_3
XTAP_TAPCELL_ROW_51_641 VGND VPWR sky130_fd_sc_hd__tapvpwrvgnd_1
XFILLER_21_381 VGND VGND VPWR VPWR sky130_fd_sc_hd__decap_3
XFILLER_40_189 VGND VGND VPWR VPWR sky130_fd_sc_hd__decap_3
XTAP_TAPCELL_ROW_23_387 VGND VPWR sky130_fd_sc_hd__tapvpwrvgnd_1
XFILLER_5_514 VGND VGND VPWR VPWR sky130_fd_sc_hd__fill_2
Xinput120 operand_b[55] VGND VGND VPWR VPWR _5716_/A sky130_fd_sc_hd__clkdlybuf4s25_1
Xinput131 operand_b[7] VGND VGND VPWR VPWR _3742_/B1 sky130_fd_sc_hd__clkdlybuf4s25_1
XFILLER_48_256 VGND VGND VPWR VPWR sky130_fd_sc_hd__decap_3
XFILLER_16_131 VGND VGND VPWR VPWR sky130_fd_sc_hd__decap_3
XFILLER_16_197 VGND VGND VPWR VPWR sky130_fd_sc_hd__fill_1
XFILLER_31_123 VGND VGND VPWR VPWR sky130_fd_sc_hd__decap_3
XFILLER_71_281 VGND VGND VPWR VPWR sky130_fd_sc_hd__fill_1
XFILLER_31_167 VGND VGND VPWR VPWR sky130_fd_sc_hd__fill_1
X_4410_ _4199_/X _4200_/X _6208_/A VGND VGND VPWR VPWR _4410_/X sky130_fd_sc_hd__mux2_2
X_5390_ _6319_/B _5477_/A wire261/X _5394_/A _5389_/X VGND VGND VPWR VPWR _5390_/X
+ sky130_fd_sc_hd__a221o_2
X_4341_ _4937_/A _4334_/X _4335_/X _4340_/X VGND VGND VPWR VPWR _4341_/X sky130_fd_sc_hd__a211o_2
X_4272_ _4430_/A _4283_/B VGND VGND VPWR VPWR _4272_/X sky130_fd_sc_hd__and2_2
X_6011_ _6077_/A _6274_/A _6078_/A _6011_/D VGND VGND VPWR VPWR _6312_/B sky130_fd_sc_hd__and4_2
X_3223_ _3554_/A VGND VGND VPWR VPWR _3571_/S sky130_fd_sc_hd__inv_2
XFILLER_39_234 VGND VGND VPWR VPWR sky130_fd_sc_hd__decap_3
XFILLER_35_440 VGND VGND VPWR VPWR sky130_fd_sc_hd__fill_1
XFILLER_54_248 VGND VGND VPWR VPWR sky130_fd_sc_hd__decap_3
XFILLER_54_259 VGND VGND VPWR VPWR sky130_fd_sc_hd__decap_3
XTAP_TAPCELL_ROW_65_766 VGND VPWR sky130_fd_sc_hd__tapvpwrvgnd_1
XFILLER_50_410 VGND VGND VPWR VPWR sky130_fd_sc_hd__fill_2
X_3987_ _4196_/B _3985_/X _3986_/X _4146_/A VGND VGND VPWR VPWR _3987_/X sky130_fd_sc_hd__a22o_2
X_5726_ _5726_/A _5726_/B VGND VGND VPWR VPWR _5726_/Y sky130_fd_sc_hd__xnor2_2
XTAP_TAPCELL_ROW_20_357 VGND VPWR sky130_fd_sc_hd__tapvpwrvgnd_1
X_5657_ _6374_/B VGND VGND VPWR VPWR _5658_/B sky130_fd_sc_hd__inv_2
X_5588_ _4286_/B _5510_/B _5587_/Y _5739_/B VGND VGND VPWR VPWR _5588_/X sky130_fd_sc_hd__o22a_2
X_4608_ wire227/X _4597_/X _4598_/Y _4607_/X VGND VGND VPWR VPWR _4608_/X sky130_fd_sc_hd__a211o_2
X_4539_ _4539_/A _4539_/B VGND VGND VPWR VPWR _4539_/X sky130_fd_sc_hd__or2_2
X_6209_ _4370_/B _6208_/Y _6201_/X VGND VGND VPWR VPWR _6210_/B sky130_fd_sc_hd__a21o_2
XFILLER_77_329 VGND VGND VPWR VPWR sky130_fd_sc_hd__fill_1
XFILLER_45_215 VGND VGND VPWR VPWR sky130_fd_sc_hd__decap_3
XFILLER_45_237 VGND VGND VPWR VPWR sky130_fd_sc_hd__decap_3
XFILLER_45_259 VGND VGND VPWR VPWR sky130_fd_sc_hd__decap_3
XTAP_TAPCELL_ROW_28_435 VGND VPWR sky130_fd_sc_hd__tapvpwrvgnd_1
XFILLER_60_207 VGND VGND VPWR VPWR sky130_fd_sc_hd__decap_3
XFILLER_13_101 VGND VGND VPWR VPWR sky130_fd_sc_hd__decap_3
XFILLER_41_421 VGND VGND VPWR VPWR sky130_fd_sc_hd__decap_3
XFILLER_13_145 VGND VGND VPWR VPWR sky130_fd_sc_hd__decap_3
XFILLER_9_105 VGND VGND VPWR VPWR sky130_fd_sc_hd__fill_1
XFILLER_5_322 VGND VGND VPWR VPWR sky130_fd_sc_hd__decap_3
XFILLER_5_300 VGND VGND VPWR VPWR sky130_fd_sc_hd__fill_2
XPHY_EDGE_ROW_39_Left_122 VGND VGND VPWR VPWR sky130_fd_sc_hd__decap_3
XFILLER_68_318 VGND VGND VPWR VPWR sky130_fd_sc_hd__decap_3
XFILLER_36_215 VGND VGND VPWR VPWR sky130_fd_sc_hd__decap_3
XPHY_EDGE_ROW_48_Left_131 VGND VGND VPWR VPWR sky130_fd_sc_hd__decap_3
XFILLER_36_248 VGND VGND VPWR VPWR sky130_fd_sc_hd__decap_3
X_4890_ _6077_/A _5058_/B _4945_/A _4919_/A _4889_/X VGND VGND VPWR VPWR _4890_/X
+ sky130_fd_sc_hd__a221o_2
X_3910_ _3885_/Y _3875_/B _3908_/Y _3909_/Y VGND VGND VPWR VPWR _3910_/X sky130_fd_sc_hd__o31a_2
XTAP_TAPCELL_ROW_62_736 VGND VPWR sky130_fd_sc_hd__tapvpwrvgnd_1
X_3841_ _6464_/A1 _3754_/A _4014_/S VGND VGND VPWR VPWR _3841_/X sky130_fd_sc_hd__mux2_2
X_3772_ _3755_/S _6126_/A _3860_/B VGND VGND VPWR VPWR _3772_/Y sky130_fd_sc_hd__a21oi_2
X_5511_ _5618_/A _5507_/X _5508_/X _4973_/A _5510_/Y VGND VGND VPWR VPWR _5511_/X
+ sky130_fd_sc_hd__a221o_2
X_6491_ _6492_/A _6491_/B VGND VGND VPWR VPWR _6491_/X sky130_fd_sc_hd__or2_2
XPHY_EDGE_ROW_57_Left_140 VGND VGND VPWR VPWR sky130_fd_sc_hd__decap_3
X_5442_ _5281_/X _5441_/X _5442_/S VGND VGND VPWR VPWR _5442_/X sky130_fd_sc_hd__mux2_2
X_5373_ _5373_/A _5373_/B VGND VGND VPWR VPWR _5374_/B sky130_fd_sc_hd__nand2_2
X_4324_ _4352_/A _4356_/A _4353_/C VGND VGND VPWR VPWR _4325_/A sky130_fd_sc_hd__mux2_2
X_4255_ _4255_/A _4255_/B VGND VGND VPWR VPWR _4255_/Y sky130_fd_sc_hd__nand2_2
X_4186_ _6213_/A _4186_/B _4273_/S VGND VGND VPWR VPWR _4231_/B sky130_fd_sc_hd__nor3b_2
XFILLER_67_340 VGND VGND VPWR VPWR sky130_fd_sc_hd__decap_3
XFILLER_27_204 VGND VGND VPWR VPWR sky130_fd_sc_hd__decap_3
XTAP_TAPCELL_ROW_78_880 VGND VPWR sky130_fd_sc_hd__tapvpwrvgnd_1
XFILLER_27_237 VGND VGND VPWR VPWR sky130_fd_sc_hd__fill_1
XFILLER_27_259 VGND VGND VPWR VPWR sky130_fd_sc_hd__decap_3
XFILLER_42_218 VGND VGND VPWR VPWR sky130_fd_sc_hd__decap_3
XTAP_TAPCELL_ROW_25_405 VGND VPWR sky130_fd_sc_hd__tapvpwrvgnd_1
XFILLER_35_281 VGND VGND VPWR VPWR sky130_fd_sc_hd__decap_3
X_5709_ _5649_/B _5674_/X _5679_/X _5716_/A VGND VGND VPWR VPWR _5723_/B sky130_fd_sc_hd__a211o_2
XFILLER_12_88 VGND VGND VPWR VPWR sky130_fd_sc_hd__fill_1
Xfanout640 _5508_/A1 VGND VGND VPWR VPWR _4416_/A sky130_fd_sc_hd__clkdlybuf4s25_1
Xfanout651 _4027_/A VGND VGND VPWR VPWR _3883_/A sky130_fd_sc_hd__clkdlybuf4s25_1
Xfanout662 input112/X VGND VGND VPWR VPWR _5458_/A sky130_fd_sc_hd__clkdlybuf4s25_1
Xfanout673 _5200_/B VGND VGND VPWR VPWR _6393_/A sky130_fd_sc_hd__clkdlybuf4s25_1
Xfanout684 _4061_/S1 VGND VGND VPWR VPWR _4465_/S sky130_fd_sc_hd__clkdlybuf4s25_1
XFILLER_58_340 VGND VGND VPWR VPWR sky130_fd_sc_hd__decap_3
Xfanout695 input10/X VGND VGND VPWR VPWR _3982_/S sky130_fd_sc_hd__clkdlybuf4s25_1
XFILLER_18_226 VGND VGND VPWR VPWR sky130_fd_sc_hd__decap_3
XFILLER_73_332 VGND VGND VPWR VPWR sky130_fd_sc_hd__decap_3
XFILLER_73_321 VGND VGND VPWR VPWR sky130_fd_sc_hd__decap_3
XFILLER_58_395 VGND VGND VPWR VPWR sky130_fd_sc_hd__decap_3
XFILLER_14_421 VGND VGND VPWR VPWR sky130_fd_sc_hd__fill_1
XFILLER_26_270 VGND VGND VPWR VPWR sky130_fd_sc_hd__decap_3
XFILLER_41_273 VGND VGND VPWR VPWR sky130_fd_sc_hd__decap_3
XFILLER_41_284 VGND VGND VPWR VPWR sky130_fd_sc_hd__decap_3
XFILLER_49_340 VGND VGND VPWR VPWR sky130_fd_sc_hd__decap_3
X_4040_ _4021_/S input75/X _4004_/A _4004_/B _4076_/D VGND VGND VPWR VPWR _4046_/A
+ sky130_fd_sc_hd__o2111a_2
XFILLER_49_384 VGND VGND VPWR VPWR sky130_fd_sc_hd__decap_3
XFILLER_24_218 VGND VGND VPWR VPWR sky130_fd_sc_hd__fill_1
X_5991_ _5991_/A _5991_/B _5991_/C _5990_/X VGND VGND VPWR VPWR _5992_/C sky130_fd_sc_hd__or4b_2
XTAP_TAPCELL_ROW_75_850 VGND VPWR sky130_fd_sc_hd__tapvpwrvgnd_1
XFILLER_64_365 VGND VGND VPWR VPWR sky130_fd_sc_hd__decap_3
X_4942_ _4942_/A VGND VGND VPWR VPWR _4943_/S sky130_fd_sc_hd__inv_2
XFILLER_64_387 VGND VGND VPWR VPWR sky130_fd_sc_hd__decap_3
X_4873_ _4954_/C _4873_/B VGND VGND VPWR VPWR _4874_/B sky130_fd_sc_hd__xnor2_2
X_3824_ _3826_/A _6126_/B VGND VGND VPWR VPWR _3825_/B sky130_fd_sc_hd__or2_2
X_3755_ _4200_/A _4199_/A _3755_/S VGND VGND VPWR VPWR _3755_/X sky130_fd_sc_hd__mux2_2
XTAP_TAPCELL_ROW_30_452 VGND VPWR sky130_fd_sc_hd__tapvpwrvgnd_1
X_6474_ _6474_/A _6474_/B VGND VGND VPWR VPWR _6474_/Y sky130_fd_sc_hd__xnor2_2
X_3686_ _6120_/B _3686_/B _3686_/C _3686_/D VGND VGND VPWR VPWR _3687_/A sky130_fd_sc_hd__or4_4
X_5425_ _5425_/A _5425_/B VGND VGND VPWR VPWR _5425_/X sky130_fd_sc_hd__or2_2
XPHY_EDGE_ROW_12_Right_12 VGND VGND VPWR VPWR sky130_fd_sc_hd__decap_3
X_5356_ _5948_/S1 wire227/X _4009_/X _5355_/X VGND VGND VPWR VPWR _5356_/X sky130_fd_sc_hd__a31o_2
X_5287_ _5348_/A _6292_/A VGND VGND VPWR VPWR _5287_/Y sky130_fd_sc_hd__nor2_2
X_4307_ _6199_/B _6021_/D VGND VGND VPWR VPWR _4430_/B sky130_fd_sc_hd__xor2_2
XFILLER_59_126 VGND VGND VPWR VPWR sky130_fd_sc_hd__decap_3
X_4238_ _4365_/A _4238_/B VGND VGND VPWR VPWR _4238_/X sky130_fd_sc_hd__or2_2
XFILLER_55_343 VGND VGND VPWR VPWR sky130_fd_sc_hd__decap_3
X_4169_ _4230_/A _6171_/A VGND VGND VPWR VPWR _4267_/A sky130_fd_sc_hd__xnor2_2
XPHY_EDGE_ROW_21_Right_21 VGND VGND VPWR VPWR sky130_fd_sc_hd__decap_3
XFILLER_55_387 VGND VGND VPWR VPWR sky130_fd_sc_hd__decap_3
XTAP_TAPCELL_ROW_2_199 VGND VPWR sky130_fd_sc_hd__tapvpwrvgnd_1
XPHY_EDGE_ROW_30_Right_30 VGND VGND VPWR VPWR sky130_fd_sc_hd__decap_3
Xfanout470 input60/X VGND VGND VPWR VPWR _5946_/A3 sky130_fd_sc_hd__clkdlybuf4s25_1
Xfanout481 _6440_/A1 VGND VGND VPWR VPWR _5658_/A sky130_fd_sc_hd__clkdlybuf4s25_1
Xfanout492 input50/X VGND VGND VPWR VPWR _3548_/B sky130_fd_sc_hd__clkdlybuf4s25_1
XFILLER_58_192 VGND VGND VPWR VPWR sky130_fd_sc_hd__decap_3
XFILLER_0_69 VGND VGND VPWR VPWR sky130_fd_sc_hd__fill_1
XFILLER_46_365 VGND VGND VPWR VPWR sky130_fd_sc_hd__decap_3
XTAP_TAPCELL_ROW_72_831 VGND VPWR sky130_fd_sc_hd__tapvpwrvgnd_1
XFILLER_61_335 VGND VGND VPWR VPWR sky130_fd_sc_hd__fill_1
XFILLER_61_346 VGND VGND VPWR VPWR sky130_fd_sc_hd__decap_3
XTAP_TAPCELL_ROW_44_577 VGND VPWR sky130_fd_sc_hd__tapvpwrvgnd_1
XFILLER_61_379 VGND VGND VPWR VPWR sky130_fd_sc_hd__decap_3
XFILLER_14_284 VGND VGND VPWR VPWR sky130_fd_sc_hd__decap_3
X_3540_ _3539_/B _3539_/C _3668_/A VGND VGND VPWR VPWR _3540_/Y sky130_fd_sc_hd__a21oi_2
XFILLER_6_450 VGND VGND VPWR VPWR sky130_fd_sc_hd__decap_3
X_5210_ _5210_/A _5210_/B VGND VGND VPWR VPWR _5210_/Y sky130_fd_sc_hd__nand2_2
X_3471_ _6109_/B VGND VGND VPWR VPWR _3679_/A sky130_fd_sc_hd__inv_2
XFILLER_43_3 VGND VGND VPWR VPWR sky130_fd_sc_hd__fill_2
X_6190_ _6190_/A VGND VGND VPWR VPWR _6233_/C sky130_fd_sc_hd__buf_1
X_5141_ _4150_/A _3750_/B _3779_/X VGND VGND VPWR VPWR _5141_/Y sky130_fd_sc_hd__o21ai_2
X_5072_ _5123_/C _5072_/B _5072_/C _5072_/D VGND VGND VPWR VPWR _5297_/A sky130_fd_sc_hd__and4_2
X_4023_ _4042_/A _4044_/B _4241_/B VGND VGND VPWR VPWR _4023_/X sky130_fd_sc_hd__and3_2
XFILLER_49_192 VGND VGND VPWR VPWR sky130_fd_sc_hd__decap_3
XFILLER_37_343 VGND VGND VPWR VPWR sky130_fd_sc_hd__decap_3
XFILLER_64_173 VGND VGND VPWR VPWR sky130_fd_sc_hd__decap_3
XFILLER_52_368 VGND VGND VPWR VPWR sky130_fd_sc_hd__fill_2
X_5974_ _6497_/A _5961_/A _5973_/X VGND VGND VPWR VPWR _5974_/Y sky130_fd_sc_hd__o21ai_2
X_4925_ _4918_/X _4921_/X _4924_/Y VGND VGND VPWR VPWR _5535_/B sky130_fd_sc_hd__a21o_2
X_4856_ _4910_/A _4825_/Y _4975_/B _4855_/X VGND VGND VPWR VPWR _4953_/A sky130_fd_sc_hd__o31a_2
X_3807_ _3335_/X _3803_/X _4154_/B _3806_/X VGND VGND VPWR VPWR _3807_/X sky130_fd_sc_hd__o2bb2a_2
XFILLER_20_287 VGND VGND VPWR VPWR sky130_fd_sc_hd__decap_3
X_4787_ _4787_/A VGND VGND VPWR VPWR _4854_/B sky130_fd_sc_hd__buf_1
X_3738_ _6090_/A _6122_/A1 _3681_/A _3679_/B VGND VGND VPWR VPWR _3738_/X sky130_fd_sc_hd__a22o_2
X_6457_ input22/X _6457_/A1 _6457_/A2 _6457_/A3 _4099_/S _6438_/X VGND VGND VPWR VPWR
+ _6457_/X sky130_fd_sc_hd__mux4_2
X_3669_ _3761_/S _3667_/A _3667_/C _3668_/X VGND VGND VPWR VPWR _3669_/X sky130_fd_sc_hd__o31a_2
X_6388_ _6393_/C _6388_/B _6393_/A _6392_/B VGND VGND VPWR VPWR _6388_/X sky130_fd_sc_hd__and4b_2
X_5408_ _6319_/B _5409_/B _5388_/S VGND VGND VPWR VPWR _5408_/Y sky130_fd_sc_hd__a21oi_2
X_5339_ _5219_/X _5338_/X _5662_/S VGND VGND VPWR VPWR _5339_/X sky130_fd_sc_hd__mux2_2
XFILLER_18_43 VGND VGND VPWR VPWR sky130_fd_sc_hd__decap_3
XFILLER_18_76 VGND VGND VPWR VPWR sky130_fd_sc_hd__fill_1
XFILLER_28_354 VGND VGND VPWR VPWR sky130_fd_sc_hd__decap_3
XFILLER_28_365 VGND VGND VPWR VPWR sky130_fd_sc_hd__decap_3
XFILLER_43_346 VGND VGND VPWR VPWR sky130_fd_sc_hd__fill_1
XFILLER_43_379 VGND VGND VPWR VPWR sky130_fd_sc_hd__decap_3
XTAP_TAPCELL_ROW_41_547 VGND VPWR sky130_fd_sc_hd__tapvpwrvgnd_1
XFILLER_11_276 VGND VGND VPWR VPWR sky130_fd_sc_hd__decap_3
XFILLER_11_287 VGND VGND VPWR VPWR sky130_fd_sc_hd__decap_3
XFILLER_78_265 VGND VGND VPWR VPWR sky130_fd_sc_hd__decap_3
XFILLER_19_387 VGND VGND VPWR VPWR sky130_fd_sc_hd__decap_3
XFILLER_34_324 VGND VGND VPWR VPWR sky130_fd_sc_hd__decap_3
XFILLER_46_184 VGND VGND VPWR VPWR sky130_fd_sc_hd__decap_3
XFILLER_34_368 VGND VGND VPWR VPWR sky130_fd_sc_hd__fill_1
XTAP_TAPCELL_ROW_57_691 VGND VPWR sky130_fd_sc_hd__tapvpwrvgnd_1
XFILLER_61_121 VGND VGND VPWR VPWR sky130_fd_sc_hd__decap_3
X_5690_ _5635_/B _5580_/C _6344_/A VGND VGND VPWR VPWR _5690_/X sky130_fd_sc_hd__o21a_2
X_4710_ _4967_/B _4967_/A _4968_/B _4968_/A VGND VGND VPWR VPWR _4790_/A sky130_fd_sc_hd__and4bb_2
X_4641_ _5616_/A _3945_/A _4456_/Y _4603_/X VGND VGND VPWR VPWR _4642_/B sky130_fd_sc_hd__a31o_2
X_4572_ _6233_/B _4599_/A VGND VGND VPWR VPWR _4614_/B sky130_fd_sc_hd__nor2b_2
X_6311_ _6304_/X _5258_/A _6393_/C _6310_/Y VGND VGND VPWR VPWR _6355_/C sky130_fd_sc_hd__a31o_2
X_3523_ _3523_/A _3523_/B VGND VGND VPWR VPWR _3524_/B sky130_fd_sc_hd__nand2_2
X_6242_ _6243_/A _6240_/Y _6241_/Y _4768_/B VGND VGND VPWR VPWR _6242_/X sky130_fd_sc_hd__a211o_2
X_3454_ _3450_/B _3451_/X _3596_/S VGND VGND VPWR VPWR _3896_/B sky130_fd_sc_hd__mux2_2
XFILLER_69_210 VGND VGND VPWR VPWR sky130_fd_sc_hd__decap_3
X_6173_ _6173_/A _6173_/B _6217_/A VGND VGND VPWR VPWR _6200_/C sky130_fd_sc_hd__and3_2
X_3385_ _3324_/X _3325_/X _3383_/X _3384_/X _3559_/D _4026_/S1 VGND VGND VPWR VPWR
+ _4875_/B sky130_fd_sc_hd__mux4_2
X_5124_ _5128_/A _6275_/B VGND VGND VPWR VPWR _5124_/X sky130_fd_sc_hd__and2_2
XTAP_TAPCELL_ROW_4_217 VGND VPWR sky130_fd_sc_hd__tapvpwrvgnd_1
XFILLER_57_405 VGND VGND VPWR VPWR sky130_fd_sc_hd__decap_3
X_5055_ _5178_/A _6298_/A VGND VGND VPWR VPWR _5055_/Y sky130_fd_sc_hd__nor2_2
XFILLER_57_449 VGND VGND VPWR VPWR sky130_fd_sc_hd__fill_1
X_4006_ _4006_/A _4360_/A _4006_/C _3928_/D VGND VGND VPWR VPWR _4265_/A sky130_fd_sc_hd__or4b_4
XFILLER_37_184 VGND VGND VPWR VPWR sky130_fd_sc_hd__fill_1
XFILLER_40_305 VGND VGND VPWR VPWR sky130_fd_sc_hd__decap_3
X_5957_ _5957_/A _5957_/B _5957_/C VGND VGND VPWR VPWR _5958_/A sky130_fd_sc_hd__and3_2
XFILLER_33_390 VGND VGND VPWR VPWR sky130_fd_sc_hd__fill_2
XFILLER_40_327 VGND VGND VPWR VPWR sky130_fd_sc_hd__decap_3
X_4908_ _4908_/A _4908_/B _4908_/C _4908_/D VGND VGND VPWR VPWR _4909_/A sky130_fd_sc_hd__or4_2
X_5888_ _5849_/B _5847_/Y _6040_/A VGND VGND VPWR VPWR _5922_/B sky130_fd_sc_hd__a21o_2
X_4839_ _5664_/B1 _4836_/X _4838_/Y _5242_/B VGND VGND VPWR VPWR _4839_/X sky130_fd_sc_hd__o2bb2a_2
XFILLER_48_416 VGND VGND VPWR VPWR sky130_fd_sc_hd__decap_3
XFILLER_75_202 VGND VGND VPWR VPWR sky130_fd_sc_hd__fill_1
XFILLER_75_213 VGND VGND VPWR VPWR sky130_fd_sc_hd__decap_3
XFILLER_43_132 VGND VGND VPWR VPWR sky130_fd_sc_hd__decap_3
XFILLER_43_165 VGND VGND VPWR VPWR sky130_fd_sc_hd__decap_3
XTAP_TAPCELL_ROW_54_661 VGND VPWR sky130_fd_sc_hd__tapvpwrvgnd_1
XFILLER_31_349 VGND VGND VPWR VPWR sky130_fd_sc_hd__decap_3
XFILLER_43_187 VGND VGND VPWR VPWR sky130_fd_sc_hd__decap_3
XFILLER_8_501 VGND VGND VPWR VPWR sky130_fd_sc_hd__decap_3
XPHY_EDGE_ROW_20_Left_103 VGND VGND VPWR VPWR sky130_fd_sc_hd__decap_3
XANTENNA_6 _5884_/Y VGND VGND VPWR VPWR sky130_fd_sc_hd__diode_2
XFILLER_39_449 VGND VGND VPWR VPWR sky130_fd_sc_hd__fill_1
XFILLER_66_224 VGND VGND VPWR VPWR sky130_fd_sc_hd__decap_3
XFILLER_54_408 VGND VGND VPWR VPWR sky130_fd_sc_hd__decap_3
XFILLER_66_268 VGND VGND VPWR VPWR sky130_fd_sc_hd__decap_3
XFILLER_19_151 VGND VGND VPWR VPWR sky130_fd_sc_hd__decap_3
XFILLER_47_460 VGND VGND VPWR VPWR sky130_fd_sc_hd__decap_3
XFILLER_19_184 VGND VGND VPWR VPWR sky130_fd_sc_hd__fill_1
XTAP_TAPCELL_ROW_17_330 VGND VPWR sky130_fd_sc_hd__tapvpwrvgnd_1
X_5811_ _5866_/A _6400_/A VGND VGND VPWR VPWR _5847_/B sky130_fd_sc_hd__nand2b_2
XFILLER_34_187 VGND VGND VPWR VPWR sky130_fd_sc_hd__decap_3
X_5742_ _4840_/Y _5738_/X _5741_/X VGND VGND VPWR VPWR _5742_/Y sky130_fd_sc_hd__a21oi_2
X_5673_ _6354_/A _6352_/B VGND VGND VPWR VPWR _5695_/A sky130_fd_sc_hd__nor2_2
X_4624_ _6193_/S input88/X _4546_/X _4547_/X VGND VGND VPWR VPWR _4624_/X sky130_fd_sc_hd__a22o_2
XPHY_EDGE_ROW_6_Right_6 VGND VGND VPWR VPWR sky130_fd_sc_hd__decap_3
Xmax_cap220 _5396_/X VGND VGND VPWR VPWR _5975_/A sky130_fd_sc_hd__clkbuf_2
X_4555_ _5216_/A _3844_/Y _4554_/Y _5739_/B VGND VGND VPWR VPWR _4555_/X sky130_fd_sc_hd__a211o_2
Xmax_cap253 _4174_/B VGND VGND VPWR VPWR _4089_/B sky130_fd_sc_hd__clkbuf_2
Xmax_cap242 _3335_/X VGND VGND VPWR VPWR _3976_/A sky130_fd_sc_hd__buf_2
Xmax_cap231 _5215_/X VGND VGND VPWR VPWR _6477_/A sky130_fd_sc_hd__buf_2
X_3506_ _6450_/A0 _6450_/A3 _6450_/A1 _5096_/A _3526_/S0 _6447_/S0 VGND VGND VPWR
+ VPWR _3506_/X sky130_fd_sc_hd__mux4_2
Xmax_cap286 _4288_/X VGND VGND VPWR VPWR _5224_/A sky130_fd_sc_hd__buf_2
Xmax_cap275 _6443_/A VGND VGND VPWR VPWR _6453_/B sky130_fd_sc_hd__buf_2
Xmax_cap264 _5966_/A VGND VGND VPWR VPWR _5664_/B1 sky130_fd_sc_hd__buf_2
X_4486_ _4486_/A VGND VGND VPWR VPWR _4486_/X sky130_fd_sc_hd__clkbuf_1
X_6225_ _4513_/A _6061_/C _6067_/C _6221_/A VGND VGND VPWR VPWR _6225_/X sky130_fd_sc_hd__a31o_2
Xmax_cap297 _3305_/Y VGND VGND VPWR VPWR _4196_/B sky130_fd_sc_hd__buf_2
X_3437_ _3784_/A VGND VGND VPWR VPWR _4102_/A sky130_fd_sc_hd__clkbuf_1
X_6156_ _6156_/A _6156_/B VGND VGND VPWR VPWR _6162_/B sky130_fd_sc_hd__and2_2
X_3368_ _3368_/A VGND VGND VPWR VPWR _3694_/B sky130_fd_sc_hd__clkbuf_1
X_5107_ _6391_/A _5191_/B VGND VGND VPWR VPWR _5274_/A sky130_fd_sc_hd__xnor2_2
X_6087_ _6089_/A _6151_/C VGND VGND VPWR VPWR _6138_/B sky130_fd_sc_hd__nand2_2
X_3299_ _3299_/A VGND VGND VPWR VPWR _3299_/X sky130_fd_sc_hd__clkbuf_1
XFILLER_57_257 VGND VGND VPWR VPWR sky130_fd_sc_hd__decap_3
X_5038_ _5038_/A VGND VGND VPWR VPWR _6497_/A sky130_fd_sc_hd__clkbuf_2
XFILLER_53_452 VGND VGND VPWR VPWR sky130_fd_sc_hd__fill_1
XPHY_EDGE_ROW_11_Left_94 VGND VGND VPWR VPWR sky130_fd_sc_hd__decap_3
XFILLER_15_55 VGND VGND VPWR VPWR sky130_fd_sc_hd__fill_1
XFILLER_25_187 VGND VGND VPWR VPWR sky130_fd_sc_hd__decap_3
XFILLER_40_113 VGND VGND VPWR VPWR sky130_fd_sc_hd__decap_3
XFILLER_40_168 VGND VGND VPWR VPWR sky130_fd_sc_hd__decap_3
XTAP_TAPCELL_ROW_51_642 VGND VPWR sky130_fd_sc_hd__tapvpwrvgnd_1
XTAP_TAPCELL_ROW_23_388 VGND VPWR sky130_fd_sc_hd__tapvpwrvgnd_1
XFILLER_21_393 VGND VGND VPWR VPWR sky130_fd_sc_hd__decap_3
XFILLER_31_76 VGND VGND VPWR VPWR sky130_fd_sc_hd__fill_1
XFILLER_0_253 VGND VGND VPWR VPWR sky130_fd_sc_hd__fill_2
Xinput110 operand_b[46] VGND VGND VPWR VPWR input110/X sky130_fd_sc_hd__clkdlybuf4s25_1
Xinput132 operand_b[8] VGND VGND VPWR VPWR _6089_/A sky130_fd_sc_hd__clkdlybuf4s25_1
Xinput121 operand_b[56] VGND VGND VPWR VPWR input121/X sky130_fd_sc_hd__clkdlybuf4s25_1
XFILLER_48_246 VGND VGND VPWR VPWR sky130_fd_sc_hd__decap_3
XFILLER_63_249 VGND VGND VPWR VPWR sky130_fd_sc_hd__decap_3
XFILLER_31_179 VGND VGND VPWR VPWR sky130_fd_sc_hd__decap_3
XPHY_EDGE_ROW_59_Right_59 VGND VGND VPWR VPWR sky130_fd_sc_hd__decap_3
XFILLER_75_6 VGND VGND VPWR VPWR sky130_fd_sc_hd__fill_1
X_4340_ _5014_/B _4598_/B _4338_/X _4339_/X VGND VGND VPWR VPWR _4340_/X sky130_fd_sc_hd__a2bb2o_2
X_4271_ _4239_/A _6171_/B _4269_/X _4270_/X VGND VGND VPWR VPWR _4271_/Y sky130_fd_sc_hd__a211oi_2
X_6010_ _6077_/B _6077_/C _6270_/A VGND VGND VPWR VPWR _6011_/D sky130_fd_sc_hd__and3_2
X_3222_ _6428_/A0 _6431_/A0 _6429_/B _5946_/A3 _3625_/A _6439_/S0 VGND VGND VPWR VPWR
+ _3222_/X sky130_fd_sc_hd__mux4_2
XFILLER_39_213 VGND VGND VPWR VPWR sky130_fd_sc_hd__fill_2
XPHY_EDGE_ROW_68_Right_68 VGND VGND VPWR VPWR sky130_fd_sc_hd__decap_3
XFILLER_39_246 VGND VGND VPWR VPWR sky130_fd_sc_hd__decap_3
XFILLER_39_279 VGND VGND VPWR VPWR sky130_fd_sc_hd__fill_1
XFILLER_54_216 VGND VGND VPWR VPWR sky130_fd_sc_hd__fill_2
XTAP_TAPCELL_ROW_65_767 VGND VPWR sky130_fd_sc_hd__tapvpwrvgnd_1
XFILLER_22_113 VGND VGND VPWR VPWR sky130_fd_sc_hd__fill_1
XFILLER_62_271 VGND VGND VPWR VPWR sky130_fd_sc_hd__decap_3
XFILLER_22_146 VGND VGND VPWR VPWR sky130_fd_sc_hd__fill_2
XFILLER_50_466 VGND VGND VPWR VPWR sky130_fd_sc_hd__fill_1
X_3986_ _3308_/X _3748_/B _3986_/S VGND VGND VPWR VPWR _3986_/X sky130_fd_sc_hd__mux2_2
XPHY_EDGE_ROW_77_Right_77 VGND VGND VPWR VPWR sky130_fd_sc_hd__decap_3
X_5725_ _5762_/B _5725_/B VGND VGND VPWR VPWR _5726_/B sky130_fd_sc_hd__nand2_2
X_5656_ wire263/X _5938_/A1 _6374_/A VGND VGND VPWR VPWR _5656_/X sky130_fd_sc_hd__mux2_2
X_4607_ _4339_/A _4602_/X _4604_/X _4800_/B _4606_/Y VGND VGND VPWR VPWR _4607_/X
+ sky130_fd_sc_hd__a221o_2
XTAP_TAPCELL_ROW_20_358 VGND VPWR sky130_fd_sc_hd__tapvpwrvgnd_1
X_5587_ _5587_/A _5587_/B VGND VGND VPWR VPWR _5587_/Y sky130_fd_sc_hd__nor2_2
X_4538_ _6189_/A _4538_/B VGND VGND VPWR VPWR _4538_/Y sky130_fd_sc_hd__xnor2_2
X_4469_ _4469_/A _4513_/A VGND VGND VPWR VPWR _4469_/X sky130_fd_sc_hd__or2_2
X_6208_ _6208_/A _6208_/B VGND VGND VPWR VPWR _6208_/Y sky130_fd_sc_hd__nand2_2
XFILLER_77_308 VGND VGND VPWR VPWR sky130_fd_sc_hd__fill_1
X_6139_ _6138_/A _6137_/X _6138_/Y _3786_/X VGND VGND VPWR VPWR _6139_/X sky130_fd_sc_hd__a211o_2
XFILLER_13_113 VGND VGND VPWR VPWR sky130_fd_sc_hd__decap_3
XFILLER_53_260 VGND VGND VPWR VPWR sky130_fd_sc_hd__decap_3
XFILLER_5_345 VGND VGND VPWR VPWR sky130_fd_sc_hd__decap_3
XFILLER_5_334 VGND VGND VPWR VPWR sky130_fd_sc_hd__fill_2
XFILLER_36_227 VGND VGND VPWR VPWR sky130_fd_sc_hd__decap_3
XFILLER_17_474 VGND VGND VPWR VPWR sky130_fd_sc_hd__fill_1
XFILLER_51_208 VGND VGND VPWR VPWR sky130_fd_sc_hd__decap_3
XFILLER_44_271 VGND VGND VPWR VPWR sky130_fd_sc_hd__decap_3
XTAP_TAPCELL_ROW_62_737 VGND VPWR sky130_fd_sc_hd__tapvpwrvgnd_1
XFILLER_44_293 VGND VGND VPWR VPWR sky130_fd_sc_hd__decap_3
X_3840_ _3825_/B _3826_/Y _3840_/S VGND VGND VPWR VPWR _3840_/X sky130_fd_sc_hd__mux2_2
XFILLER_32_477 VGND VGND VPWR VPWR sky130_fd_sc_hd__fill_2
X_3771_ _6126_/A _3728_/A _3727_/A _3814_/B _3770_/Y VGND VGND VPWR VPWR _3774_/B
+ sky130_fd_sc_hd__a221o_2
X_5510_ _5510_/A _5510_/B VGND VGND VPWR VPWR _5510_/Y sky130_fd_sc_hd__nor2_2
X_6490_ _6477_/B _6423_/X _6490_/S VGND VGND VPWR VPWR _6490_/X sky130_fd_sc_hd__mux2_2
XFILLER_73_3 VGND VGND VPWR VPWR sky130_fd_sc_hd__fill_1
X_5441_ _6439_/A0 _5388_/S _5352_/A _6358_/A _5801_/S0 _5801_/S1 VGND VGND VPWR VPWR
+ _5441_/X sky130_fd_sc_hd__mux4_2
X_5372_ _5425_/A _5416_/B _5416_/C _5418_/C VGND VGND VPWR VPWR _5373_/B sky130_fd_sc_hd__a31o_2
X_4323_ _4312_/A _4354_/S _4728_/A1 VGND VGND VPWR VPWR _4323_/X sky130_fd_sc_hd__a21o_2
X_4254_ _6171_/B _4258_/A _4251_/Y _4252_/X _4240_/S VGND VGND VPWR VPWR _4255_/B
+ sky130_fd_sc_hd__a41o_2
X_4185_ _4073_/X _4447_/C _4184_/X _3745_/B VGND VGND VPWR VPWR _4273_/S sky130_fd_sc_hd__a22oi_2
XFILLER_67_352 VGND VGND VPWR VPWR sky130_fd_sc_hd__decap_3
XFILLER_27_216 VGND VGND VPWR VPWR sky130_fd_sc_hd__decap_3
XTAP_TAPCELL_ROW_78_881 VGND VPWR sky130_fd_sc_hd__tapvpwrvgnd_1
XFILLER_67_374 VGND VGND VPWR VPWR sky130_fd_sc_hd__decap_3
XTAP_TAPCELL_ROW_25_406 VGND VPWR sky130_fd_sc_hd__tapvpwrvgnd_1
XFILLER_23_411 VGND VGND VPWR VPWR sky130_fd_sc_hd__decap_3
XFILLER_50_241 VGND VGND VPWR VPWR sky130_fd_sc_hd__decap_3
XFILLER_50_274 VGND VGND VPWR VPWR sky130_fd_sc_hd__decap_3
XTAP_TAPCELL_ROW_33_472 VGND VPWR sky130_fd_sc_hd__tapvpwrvgnd_1
XFILLER_10_138 VGND VGND VPWR VPWR sky130_fd_sc_hd__fill_2
X_5708_ _5708_/A VGND VGND VPWR VPWR _5983_/A sky130_fd_sc_hd__buf_6
X_3969_ _4709_/A _3969_/B VGND VGND VPWR VPWR _3969_/X sky130_fd_sc_hd__xor2_2
X_5639_ _5639_/A _5639_/B _5639_/C VGND VGND VPWR VPWR _5640_/B sky130_fd_sc_hd__and3_2
Xfanout630 input12/X VGND VGND VPWR VPWR _4049_/S sky130_fd_sc_hd__clkdlybuf4s25_1
Xfanout663 _5424_/A VGND VGND VPWR VPWR _6319_/B sky130_fd_sc_hd__clkdlybuf4s25_1
Xfanout674 input106/X VGND VGND VPWR VPWR _5200_/B sky130_fd_sc_hd__clkdlybuf4s25_1
Xfanout685 _6113_/B VGND VGND VPWR VPWR _6109_/A sky130_fd_sc_hd__clkdlybuf4s25_1
Xfanout696 input10/X VGND VGND VPWR VPWR _6467_/A3 sky130_fd_sc_hd__clkdlybuf4s25_1
XFILLER_58_374 VGND VGND VPWR VPWR sky130_fd_sc_hd__fill_1
XFILLER_58_352 VGND VGND VPWR VPWR sky130_fd_sc_hd__decap_3
XFILLER_37_64 VGND VGND VPWR VPWR sky130_fd_sc_hd__fill_2
XFILLER_33_208 VGND VGND VPWR VPWR sky130_fd_sc_hd__decap_3
XFILLER_26_282 VGND VGND VPWR VPWR sky130_fd_sc_hd__decap_3
XFILLER_41_241 VGND VGND VPWR VPWR sky130_fd_sc_hd__decap_3
XFILLER_41_252 VGND VGND VPWR VPWR sky130_fd_sc_hd__decap_3
XFILLER_41_296 VGND VGND VPWR VPWR sky130_fd_sc_hd__decap_3
XFILLER_68_138 VGND VGND VPWR VPWR sky130_fd_sc_hd__fill_2
XFILLER_37_514 VGND VGND VPWR VPWR sky130_fd_sc_hd__fill_2
XFILLER_49_352 VGND VGND VPWR VPWR sky130_fd_sc_hd__fill_2
XFILLER_49_363 VGND VGND VPWR VPWR sky130_fd_sc_hd__decap_3
X_5990_ _6492_/A _3619_/Y _3660_/X _3722_/A _5989_/X VGND VGND VPWR VPWR _5990_/X
+ sky130_fd_sc_hd__o2111a_2
XTAP_TAPCELL_ROW_75_851 VGND VPWR sky130_fd_sc_hd__tapvpwrvgnd_1
X_4941_ _4941_/A VGND VGND VPWR VPWR _4941_/X sky130_fd_sc_hd__clkbuf_1
X_4872_ _4872_/A _4872_/B VGND VGND VPWR VPWR _4873_/B sky130_fd_sc_hd__nand2_2
XFILLER_20_403 VGND VGND VPWR VPWR sky130_fd_sc_hd__decap_3
X_3823_ _4006_/A _3928_/C VGND VGND VPWR VPWR _3823_/Y sky130_fd_sc_hd__xnor2_2
XFILLER_20_425 VGND VGND VPWR VPWR sky130_fd_sc_hd__fill_1
X_3754_ _3754_/A VGND VGND VPWR VPWR _3755_/S sky130_fd_sc_hd__inv_2
XTAP_TAPCELL_ROW_30_453 VGND VPWR sky130_fd_sc_hd__tapvpwrvgnd_1
X_6473_ _6456_/X _6471_/X _6473_/S VGND VGND VPWR VPWR _6473_/X sky130_fd_sc_hd__mux2_2
X_3685_ _3685_/A _3685_/B VGND VGND VPWR VPWR _3686_/D sky130_fd_sc_hd__nand2_2
Xoutput200 _5991_/B VGND VGND VPWR VPWR result[9] sky130_fd_sc_hd__clkdlybuf4s25_1
X_5424_ _5424_/A _5388_/S VGND VGND VPWR VPWR _5424_/X sky130_fd_sc_hd__or2b_2
X_5355_ _4017_/X _4929_/X _5354_/X VGND VGND VPWR VPWR _5355_/X sky130_fd_sc_hd__a21o_2
X_5286_ _5316_/A _6293_/A VGND VGND VPWR VPWR _5286_/Y sky130_fd_sc_hd__nand2_2
X_4306_ _4354_/S _4266_/B _4355_/B VGND VGND VPWR VPWR _4306_/X sky130_fd_sc_hd__a21bo_2
XFILLER_59_116 VGND VGND VPWR VPWR sky130_fd_sc_hd__fill_1
X_4237_ _4228_/A _4230_/X _4263_/C VGND VGND VPWR VPWR _4237_/X sky130_fd_sc_hd__mux2_2
XFILLER_55_322 VGND VGND VPWR VPWR sky130_fd_sc_hd__decap_3
X_4168_ _4168_/A VGND VGND VPWR VPWR _4168_/X sky130_fd_sc_hd__clkbuf_1
XTAP_TAPCELL_ROW_38_520 VGND VPWR sky130_fd_sc_hd__tapvpwrvgnd_1
XFILLER_55_366 VGND VGND VPWR VPWR sky130_fd_sc_hd__decap_3
X_4099_ _4175_/A _6467_/A1 _4099_/S VGND VGND VPWR VPWR _4099_/X sky130_fd_sc_hd__mux2_2
XFILLER_55_399 VGND VGND VPWR VPWR sky130_fd_sc_hd__decap_3
XFILLER_70_358 VGND VGND VPWR VPWR sky130_fd_sc_hd__decap_3
XPHY_EDGE_ROW_76_Left_159 VGND VGND VPWR VPWR sky130_fd_sc_hd__decap_3
Xfanout460 _5962_/A VGND VGND VPWR VPWR _5918_/A sky130_fd_sc_hd__clkdlybuf4s25_1
Xfanout471 input6/X VGND VGND VPWR VPWR _3264_/A sky130_fd_sc_hd__clkdlybuf4s25_1
Xfanout482 input55/X VGND VGND VPWR VPWR _6440_/A1 sky130_fd_sc_hd__clkdlybuf4s25_1
Xfanout493 _5263_/A VGND VGND VPWR VPWR _4567_/B2 sky130_fd_sc_hd__clkdlybuf4s25_1
XFILLER_0_37 VGND VGND VPWR VPWR sky130_fd_sc_hd__fill_2
XFILLER_46_344 VGND VGND VPWR VPWR sky130_fd_sc_hd__decap_3
XFILLER_46_377 VGND VGND VPWR VPWR sky130_fd_sc_hd__fill_2
XFILLER_46_388 VGND VGND VPWR VPWR sky130_fd_sc_hd__decap_3
XFILLER_61_314 VGND VGND VPWR VPWR sky130_fd_sc_hd__decap_3
XFILLER_61_358 VGND VGND VPWR VPWR sky130_fd_sc_hd__decap_3
XFILLER_14_263 VGND VGND VPWR VPWR sky130_fd_sc_hd__fill_1
XFILLER_14_274 VGND VGND VPWR VPWR sky130_fd_sc_hd__fill_2
XTAP_TAPCELL_ROW_44_578 VGND VPWR sky130_fd_sc_hd__tapvpwrvgnd_1
XFILLER_80_83 VGND VGND VPWR VPWR sky130_fd_sc_hd__fill_1
Xmax_cap605 _6476_/B VGND VGND VPWR VPWR _6423_/B sky130_fd_sc_hd__buf_2
X_3470_ _3985_/A _3470_/B VGND VGND VPWR VPWR _3470_/Y sky130_fd_sc_hd__nand2_2
X_5140_ _5136_/Y _5139_/X _5732_/A VGND VGND VPWR VPWR _5140_/X sky130_fd_sc_hd__a21o_2
X_5071_ _5071_/A _5071_/B VGND VGND VPWR VPWR _5072_/D sky130_fd_sc_hd__and2_2
XFILLER_56_119 VGND VGND VPWR VPWR sky130_fd_sc_hd__decap_3
X_4022_ _6158_/A VGND VGND VPWR VPWR _4044_/B sky130_fd_sc_hd__inv_2
XFILLER_37_388 VGND VGND VPWR VPWR sky130_fd_sc_hd__decap_3
X_5973_ _6477_/A _5976_/B _5975_/C _5966_/Y _5972_/X VGND VGND VPWR VPWR _5973_/X
+ sky130_fd_sc_hd__o311a_2
XFILLER_64_185 VGND VGND VPWR VPWR sky130_fd_sc_hd__decap_3
X_4924_ _4854_/B _6078_/A _4923_/Y _4975_/C VGND VGND VPWR VPWR _4924_/Y sky130_fd_sc_hd__a31oi_2
X_4855_ _4923_/A _4854_/Y _4826_/Y _4954_/B VGND VGND VPWR VPWR _4855_/X sky130_fd_sc_hd__a211o_2
XFILLER_20_266 VGND VGND VPWR VPWR sky130_fd_sc_hd__decap_3
X_4786_ _5162_/A _4825_/B VGND VGND VPWR VPWR _4787_/A sky130_fd_sc_hd__and2_2
X_3806_ _3784_/A _3805_/X _3784_/X VGND VGND VPWR VPWR _3806_/X sky130_fd_sc_hd__o21ba_2
XFILLER_20_299 VGND VGND VPWR VPWR sky130_fd_sc_hd__decap_3
X_3737_ _3276_/X _3284_/X _3736_/X _3279_/X _3803_/S _6113_/B VGND VGND VPWR VPWR
+ _3737_/X sky130_fd_sc_hd__mux4_2
X_6456_ _6445_/X _6452_/X _6471_/S VGND VGND VPWR VPWR _6456_/X sky130_fd_sc_hd__mux2_2
X_3668_ _3668_/A _3668_/B _3679_/D _3668_/D VGND VGND VPWR VPWR _3668_/X sky130_fd_sc_hd__and4_2
X_6387_ _6306_/C _5210_/A _6383_/B _6386_/Y VGND VGND VPWR VPWR _6388_/B sky130_fd_sc_hd__o31a_2
X_5407_ _6365_/A _5384_/X _5406_/X _5383_/Y VGND VGND VPWR VPWR _5409_/B sky130_fd_sc_hd__a31o_2
X_3599_ _4019_/A _4156_/A _3600_/B VGND VGND VPWR VPWR _3599_/X sky130_fd_sc_hd__mux2_2
X_5338_ _6449_/A1 _6449_/A3 _6449_/A0 _5338_/A3 wire423/A wire374/X VGND VGND VPWR
+ VPWR _5338_/X sky130_fd_sc_hd__mux4_2
X_5269_ _6391_/D _5270_/A2 _5212_/X _5200_/B _5268_/X VGND VGND VPWR VPWR _5269_/X
+ sky130_fd_sc_hd__o221a_2
XFILLER_28_333 VGND VGND VPWR VPWR sky130_fd_sc_hd__decap_3
XFILLER_55_141 VGND VGND VPWR VPWR sky130_fd_sc_hd__decap_3
XFILLER_43_303 VGND VGND VPWR VPWR sky130_fd_sc_hd__decap_3
XFILLER_70_111 VGND VGND VPWR VPWR sky130_fd_sc_hd__fill_2
XFILLER_55_196 VGND VGND VPWR VPWR sky130_fd_sc_hd__decap_3
XFILLER_43_369 VGND VGND VPWR VPWR sky130_fd_sc_hd__fill_1
XFILLER_70_177 VGND VGND VPWR VPWR sky130_fd_sc_hd__decap_3
XFILLER_51_380 VGND VGND VPWR VPWR sky130_fd_sc_hd__decap_3
XTAP_TAPCELL_ROW_41_548 VGND VPWR sky130_fd_sc_hd__tapvpwrvgnd_1
XFILLER_78_244 VGND VGND VPWR VPWR sky130_fd_sc_hd__decap_3
XFILLER_19_300 VGND VGND VPWR VPWR sky130_fd_sc_hd__fill_1
XFILLER_19_322 VGND VGND VPWR VPWR sky130_fd_sc_hd__decap_3
XFILLER_46_141 VGND VGND VPWR VPWR sky130_fd_sc_hd__decap_3
XFILLER_19_399 VGND VGND VPWR VPWR sky130_fd_sc_hd__decap_3
XTAP_TAPCELL_ROW_57_692 VGND VPWR sky130_fd_sc_hd__tapvpwrvgnd_1
XFILLER_61_133 VGND VGND VPWR VPWR sky130_fd_sc_hd__decap_3
XFILLER_61_155 VGND VGND VPWR VPWR sky130_fd_sc_hd__fill_1
XFILLER_61_199 VGND VGND VPWR VPWR sky130_fd_sc_hd__decap_3
X_4640_ _5662_/S VGND VGND VPWR VPWR _5616_/A sky130_fd_sc_hd__clkbuf_2
X_6310_ _6308_/Y _6309_/X _5258_/A VGND VGND VPWR VPWR _6310_/Y sky130_fd_sc_hd__a21oi_2
X_4571_ _4527_/X _4545_/Y _4570_/X VGND VGND VPWR VPWR _4571_/X sky130_fd_sc_hd__a21o_2
XTAP_TAPCELL_ROW_12_283 VGND VPWR sky130_fd_sc_hd__tapvpwrvgnd_1
X_3522_ _3799_/A _3468_/X _3469_/S VGND VGND VPWR VPWR _3523_/B sky130_fd_sc_hd__a21o_2
X_6241_ _6243_/B _6243_/D _6243_/A VGND VGND VPWR VPWR _6241_/Y sky130_fd_sc_hd__a21oi_2
X_3453_ _3842_/S _3450_/X _3452_/X VGND VGND VPWR VPWR _3901_/B sky130_fd_sc_hd__o21a_2
X_6172_ _6172_/A VGND VGND VPWR VPWR _6217_/A sky130_fd_sc_hd__buf_1
Xload_slew641 _4416_/A VGND VGND VPWR VPWR _4726_/S sky130_fd_sc_hd__clkbuf_4
X_5123_ _5123_/A _5123_/B _5123_/C _5109_/A VGND VGND VPWR VPWR _5193_/B sky130_fd_sc_hd__or4b_2
X_3384_ _4942_/A _6450_/A3 _5128_/A _5281_/A3 _3584_/S0 _3895_/A2 VGND VGND VPWR VPWR
+ _3384_/X sky130_fd_sc_hd__mux4_2
XFILLER_69_222 VGND VGND VPWR VPWR sky130_fd_sc_hd__fill_2
Xload_slew652 _3883_/A VGND VGND VPWR VPWR _4382_/S sky130_fd_sc_hd__buf_2
XTAP_TAPCELL_ROW_4_218 VGND VPWR sky130_fd_sc_hd__tapvpwrvgnd_1
XFILLER_69_277 VGND VGND VPWR VPWR sky130_fd_sc_hd__decap_3
XFILLER_69_266 VGND VGND VPWR VPWR sky130_fd_sc_hd__decap_3
X_5054_ _5054_/A _6080_/A VGND VGND VPWR VPWR _5071_/A sky130_fd_sc_hd__nand2_2
X_4005_ _6154_/B _4005_/B VGND VGND VPWR VPWR _4708_/B sky130_fd_sc_hd__xnor2_2
XFILLER_25_325 VGND VGND VPWR VPWR sky130_fd_sc_hd__decap_3
XFILLER_52_133 VGND VGND VPWR VPWR sky130_fd_sc_hd__decap_3
XFILLER_52_144 VGND VGND VPWR VPWR sky130_fd_sc_hd__decap_3
X_5956_ _5918_/A _5917_/B _5925_/Y VGND VGND VPWR VPWR _5957_/C sky130_fd_sc_hd__a21o_2
XFILLER_80_475 VGND VGND VPWR VPWR sky130_fd_sc_hd__fill_1
XFILLER_40_339 VGND VGND VPWR VPWR sky130_fd_sc_hd__decap_3
XFILLER_52_188 VGND VGND VPWR VPWR sky130_fd_sc_hd__decap_3
X_5887_ _5885_/Y _5886_/Y _5816_/A _5816_/B _5847_/B VGND VGND VPWR VPWR _5922_/A
+ sky130_fd_sc_hd__o2111ai_2
X_4907_ _4919_/A _4919_/B _4975_/D VGND VGND VPWR VPWR _4908_/D sky130_fd_sc_hd__mux2_2
X_4838_ _4286_/A _5485_/A _4837_/X VGND VGND VPWR VPWR _4838_/Y sky130_fd_sc_hd__a21oi_2
X_4769_ _6243_/A _6060_/D _6061_/B _4695_/A VGND VGND VPWR VPWR _4769_/Y sky130_fd_sc_hd__a22oi_2
X_6439_ _6439_/A0 input51/X _6439_/A2 _6439_/A3 _6439_/S0 _6438_/X VGND VGND VPWR
+ VPWR _6439_/X sky130_fd_sc_hd__mux4_2
XFILLER_29_54 VGND VGND VPWR VPWR sky130_fd_sc_hd__fill_2
XFILLER_75_225 VGND VGND VPWR VPWR sky130_fd_sc_hd__decap_3
XFILLER_28_141 VGND VGND VPWR VPWR sky130_fd_sc_hd__decap_3
XFILLER_43_111 VGND VGND VPWR VPWR sky130_fd_sc_hd__fill_1
XTAP_TAPCELL_ROW_54_662 VGND VPWR sky130_fd_sc_hd__tapvpwrvgnd_1
XFILLER_24_380 VGND VGND VPWR VPWR sky130_fd_sc_hd__decap_3
XFILLER_61_41 VGND VGND VPWR VPWR sky130_fd_sc_hd__fill_2
XANTENNA_7 _3370_/X VGND VGND VPWR VPWR sky130_fd_sc_hd__diode_2
XFILLER_66_236 VGND VGND VPWR VPWR sky130_fd_sc_hd__decap_3
XFILLER_81_217 VGND VGND VPWR VPWR sky130_fd_sc_hd__fill_1
XFILLER_34_122 VGND VGND VPWR VPWR sky130_fd_sc_hd__decap_3
XFILLER_34_144 VGND VGND VPWR VPWR sky130_fd_sc_hd__fill_1
XFILLER_34_166 VGND VGND VPWR VPWR sky130_fd_sc_hd__decap_3
X_5810_ _6400_/A _5866_/A VGND VGND VPWR VPWR _5849_/B sky130_fd_sc_hd__nand2b_2
XTAP_TAPCELL_ROW_17_331 VGND VPWR sky130_fd_sc_hd__tapvpwrvgnd_1
X_5741_ _5138_/B _5485_/B _5134_/X _5739_/Y _5740_/Y VGND VGND VPWR VPWR _5741_/X
+ sky130_fd_sc_hd__a221o_2
XFILLER_15_391 VGND VGND VPWR VPWR sky130_fd_sc_hd__fill_1
X_5672_ _5697_/S _6374_/C VGND VGND VPWR VPWR _6352_/B sky130_fd_sc_hd__and2_2
X_4623_ _4623_/A _4623_/B VGND VGND VPWR VPWR _4623_/Y sky130_fd_sc_hd__xnor2_2
Xmax_cap210 _5118_/X VGND VGND VPWR VPWR _5172_/B sky130_fd_sc_hd__buf_2
X_4554_ _5216_/A _4554_/B VGND VGND VPWR VPWR _4554_/Y sky130_fd_sc_hd__nor2_2
Xmax_cap243 _3303_/Y VGND VGND VPWR VPWR _3710_/A sky130_fd_sc_hd__buf_2
Xmax_cap232 _4840_/Y VGND VGND VPWR VPWR _5618_/A sky130_fd_sc_hd__buf_2
Xmax_cap221 _4761_/X VGND VGND VPWR VPWR _5177_/A sky130_fd_sc_hd__buf_4
X_3505_ _6446_/A0 _5281_/A3 _5225_/S _5338_/A3 _3526_/S0 _6447_/S0 VGND VGND VPWR
+ VPWR _3505_/X sky130_fd_sc_hd__mux4_2
X_6224_ _6224_/A _6224_/B VGND VGND VPWR VPWR _6224_/Y sky130_fd_sc_hd__nand2_2
Xmax_cap276 _6089_/B VGND VGND VPWR VPWR _6151_/C sky130_fd_sc_hd__buf_2
Xmax_cap265 _4842_/B VGND VGND VPWR VPWR _5967_/B1 sky130_fd_sc_hd__buf_2
Xmax_cap254 _4174_/B VGND VGND VPWR VPWR _4302_/A1 sky130_fd_sc_hd__clkbuf_2
X_4485_ _4485_/A _4485_/B VGND VGND VPWR VPWR _4486_/A sky130_fd_sc_hd__and2_2
Xmax_cap298 _3299_/A VGND VGND VPWR VPWR _3799_/A sky130_fd_sc_hd__buf_2
X_3436_ _3386_/X _3402_/X _3415_/X _3419_/Y _3435_/Y VGND VGND VPWR VPWR _3436_/X
+ sky130_fd_sc_hd__a221o_2
X_6155_ _6154_/X _6155_/B _6155_/C VGND VGND VPWR VPWR _6155_/X sky130_fd_sc_hd__and3b_2
X_3367_ _3367_/A _3367_/B VGND VGND VPWR VPWR _3368_/A sky130_fd_sc_hd__or2_2
X_6086_ _6086_/A _6086_/B VGND VGND VPWR VPWR _6148_/A sky130_fd_sc_hd__xnor2_2
X_5106_ _4312_/A _5075_/Y _5076_/X _5105_/X VGND VGND VPWR VPWR _5996_/D sky130_fd_sc_hd__a31o_2
XFILLER_57_236 VGND VGND VPWR VPWR sky130_fd_sc_hd__decap_3
XFILLER_57_203 VGND VGND VPWR VPWR sky130_fd_sc_hd__decap_3
X_5037_ _5120_/D _5037_/B VGND VGND VPWR VPWR _5037_/Y sky130_fd_sc_hd__xnor2_2
X_3298_ _3500_/S VGND VGND VPWR VPWR _3299_/A sky130_fd_sc_hd__clkbuf_1
XFILLER_57_269 VGND VGND VPWR VPWR sky130_fd_sc_hd__decap_3
XTAP_TAPCELL_ROW_68_787 VGND VPWR sky130_fd_sc_hd__tapvpwrvgnd_1
XFILLER_72_206 VGND VGND VPWR VPWR sky130_fd_sc_hd__fill_1
XFILLER_72_239 VGND VGND VPWR VPWR sky130_fd_sc_hd__decap_3
XFILLER_80_250 VGND VGND VPWR VPWR sky130_fd_sc_hd__fill_2
XFILLER_15_67 VGND VGND VPWR VPWR sky130_fd_sc_hd__decap_3
XFILLER_15_89 VGND VGND VPWR VPWR sky130_fd_sc_hd__decap_3
XFILLER_40_147 VGND VGND VPWR VPWR sky130_fd_sc_hd__decap_3
X_5939_ _5939_/A _6479_/B VGND VGND VPWR VPWR _5939_/Y sky130_fd_sc_hd__nor2_2
XTAP_TAPCELL_ROW_23_389 VGND VPWR sky130_fd_sc_hd__tapvpwrvgnd_1
Xinput100 operand_b[37] VGND VGND VPWR VPWR input100/X sky130_fd_sc_hd__clkdlybuf4s25_1
Xinput111 operand_b[47] VGND VGND VPWR VPWR _5424_/A sky130_fd_sc_hd__clkdlybuf4s25_1
Xinput133 operand_b[9] VGND VGND VPWR VPWR _6088_/A sky130_fd_sc_hd__clkdlybuf4s25_1
Xinput122 operand_b[57] VGND VGND VPWR VPWR _5773_/A1 sky130_fd_sc_hd__clkdlybuf4s25_1
XTAP_TAPCELL_ROW_59_710 VGND VPWR sky130_fd_sc_hd__tapvpwrvgnd_1
XFILLER_36_409 VGND VGND VPWR VPWR sky130_fd_sc_hd__fill_2
XFILLER_16_100 VGND VGND VPWR VPWR sky130_fd_sc_hd__fill_2
XFILLER_29_494 VGND VGND VPWR VPWR sky130_fd_sc_hd__fill_2
XFILLER_56_85 VGND VGND VPWR VPWR sky130_fd_sc_hd__decap_3
XFILLER_16_155 VGND VGND VPWR VPWR sky130_fd_sc_hd__decap_3
XFILLER_44_453 VGND VGND VPWR VPWR sky130_fd_sc_hd__fill_1
XTAP_TAPCELL_ROW_14_301 VGND VPWR sky130_fd_sc_hd__tapvpwrvgnd_1
XFILLER_71_272 VGND VGND VPWR VPWR sky130_fd_sc_hd__decap_3
XFILLER_31_158 VGND VGND VPWR VPWR sky130_fd_sc_hd__decap_3
XFILLER_31_169 VGND VGND VPWR VPWR sky130_fd_sc_hd__fill_1
XFILLER_12_383 VGND VGND VPWR VPWR sky130_fd_sc_hd__decap_3
XFILLER_8_365 VGND VGND VPWR VPWR sky130_fd_sc_hd__decap_3
X_4270_ _4239_/A _6171_/B _6171_/A _4230_/A VGND VGND VPWR VPWR _4270_/X sky130_fd_sc_hd__o211a_2
X_3221_ _3450_/B _3220_/X _6429_/A VGND VGND VPWR VPWR _3945_/A sky130_fd_sc_hd__mux2_2
XFILLER_39_225 VGND VGND VPWR VPWR sky130_fd_sc_hd__decap_3
XTAP_TAPCELL_ROW_65_768 VGND VPWR sky130_fd_sc_hd__tapvpwrvgnd_1
XFILLER_50_401 VGND VGND VPWR VPWR sky130_fd_sc_hd__decap_3
XFILLER_62_283 VGND VGND VPWR VPWR sky130_fd_sc_hd__decap_3
X_3985_ _3985_/A _3985_/B VGND VGND VPWR VPWR _3985_/X sky130_fd_sc_hd__and2_2
XFILLER_10_309 VGND VGND VPWR VPWR sky130_fd_sc_hd__fill_2
X_5724_ _5724_/A _5724_/B VGND VGND VPWR VPWR _5726_/A sky130_fd_sc_hd__and2_2
XFILLER_30_180 VGND VGND VPWR VPWR sky130_fd_sc_hd__decap_3
X_5655_ _5658_/A VGND VGND VPWR VPWR _6374_/A sky130_fd_sc_hd__inv_2
X_4606_ _4606_/A _4606_/B VGND VGND VPWR VPWR _4606_/Y sky130_fd_sc_hd__nor2_2
XTAP_TAPCELL_ROW_20_359 VGND VPWR sky130_fd_sc_hd__tapvpwrvgnd_1
X_5586_ _4632_/X _4971_/X _5282_/X _5585_/X _5175_/S _5049_/S VGND VGND VPWR VPWR
+ _5587_/B sky130_fd_sc_hd__mux4_2
X_4537_ _4537_/A _4537_/B VGND VGND VPWR VPWR _5534_/C sky130_fd_sc_hd__and2_2
X_4468_ _4464_/X _4467_/Y _5732_/A VGND VGND VPWR VPWR _4468_/Y sky130_fd_sc_hd__a21oi_2
X_6207_ _6199_/C _6200_/C _6059_/B VGND VGND VPWR VPWR _6208_/B sky130_fd_sc_hd__a21bo_2
X_3419_ _3620_/A _3667_/C _3418_/X _3413_/X _3486_/D VGND VGND VPWR VPWR _3419_/Y
+ sky130_fd_sc_hd__o221ai_2
X_6138_ _6138_/A _6138_/B VGND VGND VPWR VPWR _6138_/Y sky130_fd_sc_hd__nor2_2
X_4399_ _4449_/C _4399_/B _4399_/C VGND VGND VPWR VPWR _4586_/B sky130_fd_sc_hd__and3_2
XFILLER_45_206 VGND VGND VPWR VPWR sky130_fd_sc_hd__decap_3
X_6069_ _6071_/B _6312_/C VGND VGND VPWR VPWR _6258_/B sky130_fd_sc_hd__nor2_2
XFILLER_45_228 VGND VGND VPWR VPWR sky130_fd_sc_hd__decap_3
XFILLER_13_136 VGND VGND VPWR VPWR sky130_fd_sc_hd__decap_3
XFILLER_13_158 VGND VGND VPWR VPWR sky130_fd_sc_hd__fill_1
XFILLER_13_169 VGND VGND VPWR VPWR sky130_fd_sc_hd__decap_3
XFILLER_21_191 VGND VGND VPWR VPWR sky130_fd_sc_hd__decap_3
XFILLER_49_501 VGND VGND VPWR VPWR sky130_fd_sc_hd__decap_3
XFILLER_36_206 VGND VGND VPWR VPWR sky130_fd_sc_hd__decap_3
XFILLER_36_239 VGND VGND VPWR VPWR sky130_fd_sc_hd__decap_3
XFILLER_44_250 VGND VGND VPWR VPWR sky130_fd_sc_hd__fill_2
XTAP_TAPCELL_ROW_62_738 VGND VPWR sky130_fd_sc_hd__tapvpwrvgnd_1
X_3770_ _3753_/Y _4077_/A _6138_/A VGND VGND VPWR VPWR _3770_/Y sky130_fd_sc_hd__a21oi_2
X_5440_ _5440_/A _5440_/B VGND VGND VPWR VPWR _5440_/Y sky130_fd_sc_hd__nand2_2
XFILLER_8_195 VGND VGND VPWR VPWR sky130_fd_sc_hd__fill_1
X_5371_ _5416_/B _5416_/C _5425_/A VGND VGND VPWR VPWR _5373_/A sky130_fd_sc_hd__a21o_2
X_4322_ _4728_/A1 _4354_/S _4353_/C _4321_/X VGND VGND VPWR VPWR _4322_/X sky130_fd_sc_hd__a31o_2
X_4253_ _4258_/A _4251_/Y _4252_/X _6171_/B VGND VGND VPWR VPWR _4255_/A sky130_fd_sc_hd__a31o_2
X_4184_ _4447_/A _4447_/B _4447_/C VGND VGND VPWR VPWR _4184_/X sky130_fd_sc_hd__and3_2
XTAP_TAPCELL_ROW_78_882 VGND VPWR sky130_fd_sc_hd__tapvpwrvgnd_1
XFILLER_67_364 VGND VGND VPWR VPWR sky130_fd_sc_hd__decap_3
XFILLER_27_228 VGND VGND VPWR VPWR sky130_fd_sc_hd__decap_3
XFILLER_42_209 VGND VGND VPWR VPWR sky130_fd_sc_hd__decap_3
XTAP_TAPCELL_ROW_25_407 VGND VPWR sky130_fd_sc_hd__tapvpwrvgnd_1
XFILLER_50_220 VGND VGND VPWR VPWR sky130_fd_sc_hd__decap_3
X_3968_ _3968_/A VGND VGND VPWR VPWR _3969_/B sky130_fd_sc_hd__clkbuf_1
XFILLER_50_286 VGND VGND VPWR VPWR sky130_fd_sc_hd__decap_3
X_5707_ _5707_/A _5707_/B _5707_/C _5706_/X VGND VGND VPWR VPWR _5708_/A sky130_fd_sc_hd__or4b_4
XTAP_TAPCELL_ROW_33_473 VGND VPWR sky130_fd_sc_hd__tapvpwrvgnd_1
X_3899_ _4636_/S _3895_/Y _3896_/Y _3898_/Y VGND VGND VPWR VPWR _3899_/X sky130_fd_sc_hd__a31o_2
X_5638_ _6346_/A _6344_/A _5635_/C _5637_/X VGND VGND VPWR VPWR _5639_/C sky130_fd_sc_hd__o31a_2
X_5569_ _5532_/A _5532_/B _5532_/C _5710_/B VGND VGND VPWR VPWR _5570_/B sky130_fd_sc_hd__a31o_2
Xfanout620 _6116_/A VGND VGND VPWR VPWR wire621/A sky130_fd_sc_hd__clkdlybuf4s25_1
Xfanout631 input12/X VGND VGND VPWR VPWR _6467_/A2 sky130_fd_sc_hd__clkdlybuf4s25_1
Xfanout642 _4286_/A VGND VGND VPWR VPWR _5216_/A sky130_fd_sc_hd__clkdlybuf4s25_1
Xfanout653 _6453_/A VGND VGND VPWR VPWR _3703_/A sky130_fd_sc_hd__clkdlybuf4s25_1
Xfanout664 _5425_/A VGND VGND VPWR VPWR _6319_/A sky130_fd_sc_hd__clkdlybuf4s25_1
Xfanout675 _5180_/A VGND VGND VPWR VPWR _6306_/C sky130_fd_sc_hd__clkdlybuf4s25_1
XFILLER_46_515 VGND VGND VPWR VPWR sky130_fd_sc_hd__fill_1
Xfanout697 input1/X VGND VGND VPWR VPWR _3410_/B sky130_fd_sc_hd__clkdlybuf4s25_1
XFILLER_53_42 VGND VGND VPWR VPWR sky130_fd_sc_hd__decap_3
XFILLER_41_264 VGND VGND VPWR VPWR sky130_fd_sc_hd__decap_3
XFILLER_1_382 VGND VGND VPWR VPWR sky130_fd_sc_hd__fill_2
XFILLER_1_393 VGND VGND VPWR VPWR sky130_fd_sc_hd__fill_1
XFILLER_49_331 VGND VGND VPWR VPWR sky130_fd_sc_hd__decap_3
XFILLER_49_375 VGND VGND VPWR VPWR sky130_fd_sc_hd__decap_3
XFILLER_64_334 VGND VGND VPWR VPWR sky130_fd_sc_hd__fill_1
XFILLER_64_312 VGND VGND VPWR VPWR sky130_fd_sc_hd__decap_3
XFILLER_24_209 VGND VGND VPWR VPWR sky130_fd_sc_hd__decap_3
XTAP_TAPCELL_ROW_75_852 VGND VPWR sky130_fd_sc_hd__tapvpwrvgnd_1
XFILLER_17_250 VGND VGND VPWR VPWR sky130_fd_sc_hd__fill_1
X_4940_ _4940_/A VGND VGND VPWR VPWR _4940_/X sky130_fd_sc_hd__clkbuf_1
XTAP_TAPCELL_ROW_47_598 VGND VPWR sky130_fd_sc_hd__tapvpwrvgnd_1
XFILLER_64_378 VGND VGND VPWR VPWR sky130_fd_sc_hd__decap_3
X_4871_ _4485_/A _4485_/B _4784_/X _4868_/Y VGND VGND VPWR VPWR _4872_/B sky130_fd_sc_hd__a211o_2
XFILLER_32_253 VGND VGND VPWR VPWR sky130_fd_sc_hd__decap_3
XFILLER_32_264 VGND VGND VPWR VPWR sky130_fd_sc_hd__decap_3
X_3822_ _3776_/A _3776_/B _3735_/B _3731_/X _3735_/D VGND VGND VPWR VPWR _4006_/A
+ sky130_fd_sc_hd__a2111o_2
XFILLER_32_297 VGND VGND VPWR VPWR sky130_fd_sc_hd__fill_2
X_3753_ _6126_/A VGND VGND VPWR VPWR _3753_/Y sky130_fd_sc_hd__inv_2
X_6472_ _6456_/X _6471_/X _6472_/S VGND VGND VPWR VPWR _6472_/X sky130_fd_sc_hd__mux2_2
X_3684_ _3479_/A _3479_/C _3610_/X VGND VGND VPWR VPWR _3686_/C sky130_fd_sc_hd__a21oi_2
Xoutput201 _6005_/Y VGND VGND VPWR VPWR zero_flag sky130_fd_sc_hd__clkdlybuf4s25_1
X_5423_ _5423_/A _5423_/B VGND VGND VPWR VPWR _5530_/B sky130_fd_sc_hd__or2_2
X_5354_ _4726_/S _5347_/X _5353_/X _4848_/A _5228_/A VGND VGND VPWR VPWR _5354_/X
+ sky130_fd_sc_hd__a221o_2
X_4305_ _6199_/A _4303_/Y _4304_/Y VGND VGND VPWR VPWR _4305_/Y sky130_fd_sc_hd__o21ai_2
X_5285_ _6292_/A VGND VGND VPWR VPWR _6293_/A sky130_fd_sc_hd__inv_2
X_4236_ _4931_/B2 _3901_/B _3460_/X VGND VGND VPWR VPWR _4236_/X sky130_fd_sc_hd__a21o_2
X_4167_ _4118_/X _4122_/X _4123_/Y _4166_/X VGND VGND VPWR VPWR _5985_/A sky130_fd_sc_hd__a31o_2
XTAP_TAPCELL_ROW_38_521 VGND VPWR sky130_fd_sc_hd__tapvpwrvgnd_1
X_4098_ _4098_/A VGND VGND VPWR VPWR _4840_/B sky130_fd_sc_hd__clkbuf_2
XFILLER_55_378 VGND VGND VPWR VPWR sky130_fd_sc_hd__decap_3
XFILLER_70_337 VGND VGND VPWR VPWR sky130_fd_sc_hd__decap_3
XFILLER_23_89 VGND VGND VPWR VPWR sky130_fd_sc_hd__fill_2
Xfanout450 input68/X VGND VGND VPWR VPWR _6138_/A sky130_fd_sc_hd__clkdlybuf4s25_1
Xfanout461 input64/X VGND VGND VPWR VPWR _5962_/A sky130_fd_sc_hd__clkdlybuf4s25_1
Xfanout472 input6/X VGND VGND VPWR VPWR _3371_/A sky130_fd_sc_hd__clkdlybuf4s25_1
Xfanout483 _6440_/A3 VGND VGND VPWR VPWR _5637_/A sky130_fd_sc_hd__clkdlybuf4s25_1
XFILLER_58_150 VGND VGND VPWR VPWR sky130_fd_sc_hd__decap_3
XFILLER_46_301 VGND VGND VPWR VPWR sky130_fd_sc_hd__decap_3
XFILLER_46_312 VGND VGND VPWR VPWR sky130_fd_sc_hd__decap_3
XFILLER_46_356 VGND VGND VPWR VPWR sky130_fd_sc_hd__decap_3
XFILLER_61_326 VGND VGND VPWR VPWR sky130_fd_sc_hd__decap_3
XTAP_TAPCELL_ROW_1_190 VGND VPWR sky130_fd_sc_hd__tapvpwrvgnd_1
XFILLER_73_197 VGND VGND VPWR VPWR sky130_fd_sc_hd__decap_3
XFILLER_64_74 VGND VGND VPWR VPWR sky130_fd_sc_hd__fill_1
XFILLER_61_337 VGND VGND VPWR VPWR sky130_fd_sc_hd__decap_3
XFILLER_14_253 VGND VGND VPWR VPWR sky130_fd_sc_hd__decap_3
XTAP_TAPCELL_ROW_44_579 VGND VPWR sky130_fd_sc_hd__tapvpwrvgnd_1
Xmax_cap606 _5962_/B VGND VGND VPWR VPWR _6410_/A sky130_fd_sc_hd__buf_2
XFILLER_50_6 VGND VGND VPWR VPWR sky130_fd_sc_hd__fill_1
X_5070_ _5057_/S _6298_/A _6270_/B _5030_/B _5034_/S VGND VGND VPWR VPWR _5071_/B
+ sky130_fd_sc_hd__a221o_2
X_4021_ _4156_/A _4288_/A _4021_/S VGND VGND VPWR VPWR _4021_/X sky130_fd_sc_hd__mux2_2
XFILLER_37_312 VGND VGND VPWR VPWR sky130_fd_sc_hd__decap_3
XFILLER_37_334 VGND VGND VPWR VPWR sky130_fd_sc_hd__fill_2
X_5972_ _6476_/A _5967_/X _5971_/X _5853_/A VGND VGND VPWR VPWR _5972_/X sky130_fd_sc_hd__o2bb2a_2
X_4923_ _4923_/A _4923_/B VGND VGND VPWR VPWR _4923_/Y sky130_fd_sc_hd__nor2_2
XFILLER_64_197 VGND VGND VPWR VPWR sky130_fd_sc_hd__decap_3
X_4854_ _4854_/A _4854_/B VGND VGND VPWR VPWR _4854_/Y sky130_fd_sc_hd__xnor2_2
X_4785_ _4440_/X _4442_/X _4784_/X VGND VGND VPWR VPWR _4825_/B sky130_fd_sc_hd__a21o_2
X_3805_ _4150_/A _3805_/B VGND VGND VPWR VPWR _3805_/X sky130_fd_sc_hd__or2_2
XFILLER_20_278 VGND VGND VPWR VPWR sky130_fd_sc_hd__decap_3
X_3736_ _3234_/X _3236_/X _4221_/S VGND VGND VPWR VPWR _3736_/X sky130_fd_sc_hd__mux2_2
X_6455_ _6472_/S _6455_/B VGND VGND VPWR VPWR _6471_/S sky130_fd_sc_hd__xnor2_2
X_3667_ _3667_/A _3667_/B _3667_/C VGND VGND VPWR VPWR _3667_/X sky130_fd_sc_hd__or3_2
X_6386_ _6391_/B _6386_/B VGND VGND VPWR VPWR _6386_/Y sky130_fd_sc_hd__nand2_2
X_5406_ _5316_/A _5406_/A2 _5406_/B1 _6358_/A VGND VGND VPWR VPWR _5406_/X sky130_fd_sc_hd__a22o_2
X_3598_ _3638_/A _6090_/A VGND VGND VPWR VPWR _3598_/X sky130_fd_sc_hd__or2_2
X_5337_ _5422_/A _5337_/B VGND VGND VPWR VPWR _5337_/Y sky130_fd_sc_hd__xnor2_2
XTAP_TAPCELL_ROW_7_238 VGND VPWR sky130_fd_sc_hd__tapvpwrvgnd_1
X_5268_ _6393_/A _5212_/X _6391_/C VGND VGND VPWR VPWR _5268_/X sky130_fd_sc_hd__a21o_2
X_4219_ _3440_/X _3484_/X _5010_/S VGND VGND VPWR VPWR _4219_/X sky130_fd_sc_hd__mux2_2
X_5199_ _5210_/A _5153_/X _5156_/X _5198_/X VGND VGND VPWR VPWR _5984_/A sky130_fd_sc_hd__a31o_2
XFILLER_28_345 VGND VGND VPWR VPWR sky130_fd_sc_hd__decap_3
XFILLER_55_164 VGND VGND VPWR VPWR sky130_fd_sc_hd__decap_3
XFILLER_43_337 VGND VGND VPWR VPWR sky130_fd_sc_hd__decap_3
XFILLER_11_223 VGND VGND VPWR VPWR sky130_fd_sc_hd__fill_1
XFILLER_34_88 VGND VGND VPWR VPWR sky130_fd_sc_hd__decap_3
XFILLER_70_189 VGND VGND VPWR VPWR sky130_fd_sc_hd__decap_3
XTAP_TAPCELL_ROW_41_549 VGND VPWR sky130_fd_sc_hd__tapvpwrvgnd_1
XFILLER_50_65 VGND VGND VPWR VPWR sky130_fd_sc_hd__decap_3
XFILLER_78_256 VGND VGND VPWR VPWR sky130_fd_sc_hd__decap_3
XTAP_TAPCELL_ROW_49_616 VGND VPWR sky130_fd_sc_hd__tapvpwrvgnd_1
XFILLER_46_131 VGND VGND VPWR VPWR sky130_fd_sc_hd__decap_3
XFILLER_19_367 VGND VGND VPWR VPWR sky130_fd_sc_hd__fill_2
XFILLER_19_378 VGND VGND VPWR VPWR sky130_fd_sc_hd__decap_3
XFILLER_46_175 VGND VGND VPWR VPWR sky130_fd_sc_hd__decap_3
XFILLER_34_348 VGND VGND VPWR VPWR sky130_fd_sc_hd__fill_2
XFILLER_34_359 VGND VGND VPWR VPWR sky130_fd_sc_hd__decap_3
XTAP_TAPCELL_ROW_57_693 VGND VPWR sky130_fd_sc_hd__tapvpwrvgnd_1
XFILLER_61_178 VGND VGND VPWR VPWR sky130_fd_sc_hd__decap_3
X_4570_ _4728_/A1 _5534_/C _4569_/Y VGND VGND VPWR VPWR _4570_/X sky130_fd_sc_hd__a21o_2
X_3521_ _3264_/A _3394_/X _3520_/X _3500_/S _6429_/A VGND VGND VPWR VPWR _3523_/A
+ sky130_fd_sc_hd__a221o_2
XTAP_TAPCELL_ROW_12_284 VGND VPWR sky130_fd_sc_hd__tapvpwrvgnd_1
X_6240_ _6243_/B _6243_/D VGND VGND VPWR VPWR _6240_/Y sky130_fd_sc_hd__xnor2_2
X_3452_ _3748_/B _3394_/X _3451_/X _3500_/S _6429_/A VGND VGND VPWR VPWR _3452_/X
+ sky130_fd_sc_hd__a221o_2
X_6171_ _6171_/A _6171_/B _6171_/C VGND VGND VPWR VPWR _6172_/A sky130_fd_sc_hd__and3_2
X_3383_ _5338_/A3 _6449_/A3 _6449_/A2 _6439_/A3 _3631_/S0 _3631_/S1 VGND VGND VPWR
+ VPWR _3383_/X sky130_fd_sc_hd__mux4_2
XFILLER_69_201 VGND VGND VPWR VPWR sky130_fd_sc_hd__decap_3
X_5122_ _5438_/A _5122_/B VGND VGND VPWR VPWR _5122_/Y sky130_fd_sc_hd__xnor2_2
XTAP_TAPCELL_ROW_4_219 VGND VPWR sky130_fd_sc_hd__tapvpwrvgnd_1
Xload_slew686 _6109_/A VGND VGND VPWR VPWR _3761_/S sky130_fd_sc_hd__buf_2
X_5053_ _6274_/A VGND VGND VPWR VPWR _6080_/A sky130_fd_sc_hd__inv_2
X_4004_ _4004_/A _4004_/B VGND VGND VPWR VPWR _4005_/B sky130_fd_sc_hd__nand2_2
XFILLER_1_70 VGND VGND VPWR VPWR sky130_fd_sc_hd__fill_1
XFILLER_37_175 VGND VGND VPWR VPWR sky130_fd_sc_hd__decap_3
XFILLER_52_156 VGND VGND VPWR VPWR sky130_fd_sc_hd__decap_3
X_5955_ _5918_/A _5917_/B _6420_/A _5924_/B _5924_/C VGND VGND VPWR VPWR _5957_/B
+ sky130_fd_sc_hd__a2111o_2
XFILLER_33_381 VGND VGND VPWR VPWR sky130_fd_sc_hd__decap_3
XFILLER_40_318 VGND VGND VPWR VPWR sky130_fd_sc_hd__decap_3
X_5886_ _5886_/A _6040_/A VGND VGND VPWR VPWR _5886_/Y sky130_fd_sc_hd__nor2_2
X_4906_ _4956_/A _6053_/A _4872_/A _4872_/B _4975_/D VGND VGND VPWR VPWR _4908_/C
+ sky130_fd_sc_hd__o2111a_2
X_4837_ _4879_/S _4837_/B VGND VGND VPWR VPWR _4837_/X sky130_fd_sc_hd__and2_2
X_4768_ _4768_/A _4768_/B _4778_/A _4783_/B VGND VGND VPWR VPWR _4768_/X sky130_fd_sc_hd__and4_2
X_4699_ _4778_/A _4736_/S VGND VGND VPWR VPWR _4699_/Y sky130_fd_sc_hd__xnor2_2
X_3719_ _3363_/Y _3714_/Y _3718_/X _3940_/A VGND VGND VPWR VPWR _3719_/X sky130_fd_sc_hd__a2bb2o_2
X_6438_ _6438_/A VGND VGND VPWR VPWR _6438_/X sky130_fd_sc_hd__clkbuf_2
X_6369_ _6374_/B _6374_/D _6374_/C VGND VGND VPWR VPWR _6369_/Y sky130_fd_sc_hd__o21ai_2
XFILLER_48_407 VGND VGND VPWR VPWR sky130_fd_sc_hd__decap_3
XFILLER_28_131 VGND VGND VPWR VPWR sky130_fd_sc_hd__decap_3
XFILLER_75_259 VGND VGND VPWR VPWR sky130_fd_sc_hd__decap_3
XFILLER_28_197 VGND VGND VPWR VPWR sky130_fd_sc_hd__decap_3
XFILLER_43_156 VGND VGND VPWR VPWR sky130_fd_sc_hd__decap_3
XTAP_TAPCELL_ROW_54_663 VGND VPWR sky130_fd_sc_hd__tapvpwrvgnd_1
XANTENNA_8 _3370_/X VGND VGND VPWR VPWR sky130_fd_sc_hd__diode_2
XFILLER_10_90 VGND VGND VPWR VPWR sky130_fd_sc_hd__decap_3
XFILLER_66_259 VGND VGND VPWR VPWR sky130_fd_sc_hd__decap_3
XFILLER_34_134 VGND VGND VPWR VPWR sky130_fd_sc_hd__decap_3
XTAP_TAPCELL_ROW_17_332 VGND VPWR sky130_fd_sc_hd__tapvpwrvgnd_1
XFILLER_34_178 VGND VGND VPWR VPWR sky130_fd_sc_hd__decap_3
X_5740_ _5740_/A VGND VGND VPWR VPWR _5740_/Y sky130_fd_sc_hd__inv_2
X_5671_ _5697_/S _6374_/C VGND VGND VPWR VPWR _6354_/A sky130_fd_sc_hd__nor2_2
XFILLER_30_395 VGND VGND VPWR VPWR sky130_fd_sc_hd__decap_3
X_4622_ _4622_/A _4622_/B VGND VGND VPWR VPWR _4623_/B sky130_fd_sc_hd__or2_2
Xmax_cap211 _4527_/X VGND VGND VPWR VPWR _5627_/A sky130_fd_sc_hd__buf_2
X_4553_ _4015_/X _4190_/X _4377_/X _4551_/X _5442_/S _6106_/A VGND VGND VPWR VPWR
+ _4554_/B sky130_fd_sc_hd__mux4_2
Xmax_cap244 _6470_/S VGND VGND VPWR VPWR _6463_/S sky130_fd_sc_hd__buf_2
Xmax_cap233 _4813_/X VGND VGND VPWR VPWR _5396_/A sky130_fd_sc_hd__buf_2
Xmax_cap222 _5058_/B VGND VGND VPWR VPWR _5290_/B sky130_fd_sc_hd__buf_2
X_4484_ _4484_/A _6189_/A VGND VGND VPWR VPWR _4539_/A sky130_fd_sc_hd__nand2_2
X_3504_ _6449_/A0 _6449_/A3 _6449_/A1 _6449_/A2 _3526_/S0 _6449_/S0 VGND VGND VPWR
+ VPWR _3504_/X sky130_fd_sc_hd__mux4_2
X_6223_ _6189_/A _6221_/C _6221_/A VGND VGND VPWR VPWR _6224_/B sky130_fd_sc_hd__o21ai_2
Xmax_cap277 _5712_/C VGND VGND VPWR VPWR _5628_/C sky130_fd_sc_hd__clkbuf_2
Xmax_cap255 _4139_/S VGND VGND VPWR VPWR _4461_/S sky130_fd_sc_hd__buf_2
X_3435_ _3480_/A _3423_/Y _3427_/Y _3363_/Y _3434_/X VGND VGND VPWR VPWR _3435_/Y
+ sky130_fd_sc_hd__o221ai_2
Xmax_cap299 _3399_/B VGND VGND VPWR VPWR _5509_/B sky130_fd_sc_hd__buf_2
Xmax_cap288 _4106_/X VGND VGND VPWR VPWR _5906_/A1 sky130_fd_sc_hd__buf_8
X_6154_ _6183_/A _6154_/B _3982_/S VGND VGND VPWR VPWR _6154_/X sky130_fd_sc_hd__or3b_2
X_3366_ _3986_/S _3794_/C VGND VGND VPWR VPWR _3366_/X sky130_fd_sc_hd__or2b_2
X_6085_ _6151_/C _6085_/B VGND VGND VPWR VPWR _6086_/B sky130_fd_sc_hd__nand2_2
X_5105_ _4813_/A _5081_/X _5104_/X VGND VGND VPWR VPWR _5105_/X sky130_fd_sc_hd__a21o_2
X_3297_ _3240_/Y _3947_/A _3272_/X _3296_/Y VGND VGND VPWR VPWR _3297_/Y sky130_fd_sc_hd__o211ai_2
XFILLER_38_440 VGND VGND VPWR VPWR sky130_fd_sc_hd__fill_2
Xload_slew494 _4567_/B2 VGND VGND VPWR VPWR _4926_/A sky130_fd_sc_hd__clkbuf_4
X_5036_ _5573_/A _5120_/C VGND VGND VPWR VPWR _5037_/B sky130_fd_sc_hd__nand2_2
XFILLER_57_248 VGND VGND VPWR VPWR sky130_fd_sc_hd__decap_3
XFILLER_38_451 VGND VGND VPWR VPWR sky130_fd_sc_hd__fill_2
XTAP_TAPCELL_ROW_68_788 VGND VPWR sky130_fd_sc_hd__tapvpwrvgnd_1
XFILLER_65_281 VGND VGND VPWR VPWR sky130_fd_sc_hd__fill_2
XFILLER_65_270 VGND VGND VPWR VPWR sky130_fd_sc_hd__decap_3
XFILLER_15_13 VGND VGND VPWR VPWR sky130_fd_sc_hd__decap_3
XFILLER_25_167 VGND VGND VPWR VPWR sky130_fd_sc_hd__fill_1
XFILLER_13_318 VGND VGND VPWR VPWR sky130_fd_sc_hd__decap_3
XFILLER_15_57 VGND VGND VPWR VPWR sky130_fd_sc_hd__fill_2
XFILLER_25_178 VGND VGND VPWR VPWR sky130_fd_sc_hd__decap_3
X_5938_ wire263/X _5938_/A1 _5938_/S VGND VGND VPWR VPWR _5938_/X sky130_fd_sc_hd__mux2_2
XFILLER_80_273 VGND VGND VPWR VPWR sky130_fd_sc_hd__decap_3
X_5869_ _5869_/A _5935_/A VGND VGND VPWR VPWR _5870_/B sky130_fd_sc_hd__xor2_2
XFILLER_21_384 VGND VGND VPWR VPWR sky130_fd_sc_hd__decap_3
Xinput101 operand_b[38] VGND VGND VPWR VPWR input101/X sky130_fd_sc_hd__clkdlybuf4s25_1
XFILLER_0_288 VGND VGND VPWR VPWR sky130_fd_sc_hd__fill_1
Xinput123 operand_b[58] VGND VGND VPWR VPWR _6042_/A sky130_fd_sc_hd__buf_1
Xinput112 operand_b[48] VGND VGND VPWR VPWR input112/X sky130_fd_sc_hd__clkdlybuf4s25_1
XTAP_TAPCELL_ROW_59_711 VGND VPWR sky130_fd_sc_hd__tapvpwrvgnd_1
XFILLER_48_237 VGND VGND VPWR VPWR sky130_fd_sc_hd__decap_3
XFILLER_44_421 VGND VGND VPWR VPWR sky130_fd_sc_hd__decap_3
XTAP_TAPCELL_ROW_14_302 VGND VPWR sky130_fd_sc_hd__tapvpwrvgnd_1
XFILLER_31_126 VGND VGND VPWR VPWR sky130_fd_sc_hd__decap_3
XFILLER_72_85 VGND VGND VPWR VPWR sky130_fd_sc_hd__fill_1
XFILLER_72_74 VGND VGND VPWR VPWR sky130_fd_sc_hd__fill_1
X_3220_ _5932_/A _4422_/A _3451_/S VGND VGND VPWR VPWR _3220_/X sky130_fd_sc_hd__mux2_2
XFILLER_39_237 VGND VGND VPWR VPWR sky130_fd_sc_hd__decap_3
XFILLER_39_259 VGND VGND VPWR VPWR sky130_fd_sc_hd__decap_3
XFILLER_47_281 VGND VGND VPWR VPWR sky130_fd_sc_hd__decap_3
XFILLER_62_240 VGND VGND VPWR VPWR sky130_fd_sc_hd__decap_3
XFILLER_62_262 VGND VGND VPWR VPWR sky130_fd_sc_hd__decap_3
X_3984_ _6133_/A _4111_/A _3981_/X _3956_/A _3983_/X VGND VGND VPWR VPWR _3984_/X
+ sky130_fd_sc_hd__a221o_2
X_5723_ _5731_/A _5723_/B _5723_/C VGND VGND VPWR VPWR _5724_/B sky130_fd_sc_hd__nand3_2
X_5654_ _5968_/A _6374_/B VGND VGND VPWR VPWR _5654_/X sky130_fd_sc_hd__or2_2
XFILLER_30_192 VGND VGND VPWR VPWR sky130_fd_sc_hd__decap_3
X_4605_ _6193_/S _4577_/X _4589_/X _4582_/S VGND VGND VPWR VPWR _4606_/B sky130_fd_sc_hd__o2bb2a_2
X_5585_ _5441_/X _5584_/X _5662_/S VGND VGND VPWR VPWR _5585_/X sky130_fd_sc_hd__mux2_2
X_4536_ _4627_/C _4536_/B _4536_/C VGND VGND VPWR VPWR _4537_/B sky130_fd_sc_hd__nand3_2
X_4467_ _6427_/A _4467_/B VGND VGND VPWR VPWR _4467_/Y sky130_fd_sc_hd__nand2_2
X_6206_ _4367_/S _6059_/A _6201_/X _6205_/X VGND VGND VPWR VPWR _6210_/A sky130_fd_sc_hd__a211o_2
X_4398_ _4399_/B _4399_/C _4449_/C VGND VGND VPWR VPWR _4586_/A sky130_fd_sc_hd__a21oi_2
X_3418_ _3418_/A VGND VGND VPWR VPWR _3418_/X sky130_fd_sc_hd__clkbuf_1
X_6137_ _6088_/A _6151_/C _6135_/Y VGND VGND VPWR VPWR _6137_/X sky130_fd_sc_hd__a21o_2
X_3349_ _3349_/A _3515_/B _3369_/B VGND VGND VPWR VPWR _3350_/A sky130_fd_sc_hd__and3_2
XFILLER_58_513 VGND VGND VPWR VPWR sky130_fd_sc_hd__decap_3
XFILLER_45_218 VGND VGND VPWR VPWR sky130_fd_sc_hd__decap_3
X_6068_ _6244_/A _6244_/B VGND VGND VPWR VPWR _6312_/C sky130_fd_sc_hd__and2_2
XFILLER_26_421 VGND VGND VPWR VPWR sky130_fd_sc_hd__fill_1
XFILLER_38_281 VGND VGND VPWR VPWR sky130_fd_sc_hd__fill_2
X_5019_ _5178_/A _6270_/A _5018_/X VGND VGND VPWR VPWR _5019_/Y sky130_fd_sc_hd__o21ai_2
XTAP_TAPCELL_ROW_28_427 VGND VPWR sky130_fd_sc_hd__tapvpwrvgnd_1
XFILLER_13_104 VGND VGND VPWR VPWR sky130_fd_sc_hd__decap_3
XFILLER_41_402 VGND VGND VPWR VPWR sky130_fd_sc_hd__fill_1
XFILLER_41_424 VGND VGND VPWR VPWR sky130_fd_sc_hd__decap_3
XFILLER_53_251 VGND VGND VPWR VPWR sky130_fd_sc_hd__decap_3
XFILLER_13_148 VGND VGND VPWR VPWR sky130_fd_sc_hd__fill_1
XFILLER_5_325 VGND VGND VPWR VPWR sky130_fd_sc_hd__fill_2
XFILLER_29_281 VGND VGND VPWR VPWR sky130_fd_sc_hd__decap_3
XFILLER_36_218 VGND VGND VPWR VPWR sky130_fd_sc_hd__decap_3
XFILLER_44_262 VGND VGND VPWR VPWR sky130_fd_sc_hd__decap_3
XTAP_TAPCELL_ROW_62_739 VGND VPWR sky130_fd_sc_hd__tapvpwrvgnd_1
XPHY_EDGE_ROW_17_Left_100 VGND VGND VPWR VPWR sky130_fd_sc_hd__decap_3
X_5370_ _5370_/A _5374_/A VGND VGND VPWR VPWR _5370_/Y sky130_fd_sc_hd__xnor2_2
XFILLER_59_3 VGND VGND VPWR VPWR sky130_fd_sc_hd__fill_1
X_4321_ _4355_/B _4498_/B _4357_/S _4355_/C VGND VGND VPWR VPWR _4321_/X sky130_fd_sc_hd__and4_2
X_4252_ _4252_/A _4263_/A VGND VGND VPWR VPWR _4252_/X sky130_fd_sc_hd__or2_2
X_4183_ _4183_/A _4183_/B VGND VGND VPWR VPWR _4447_/C sky130_fd_sc_hd__nor2_2
XFILLER_67_343 VGND VGND VPWR VPWR sky130_fd_sc_hd__decap_3
XFILLER_27_207 VGND VGND VPWR VPWR sky130_fd_sc_hd__decap_3
XTAP_TAPCELL_ROW_78_883 VGND VPWR sky130_fd_sc_hd__tapvpwrvgnd_1
XFILLER_35_240 VGND VGND VPWR VPWR sky130_fd_sc_hd__decap_3
XTAP_TAPCELL_ROW_25_408 VGND VPWR sky130_fd_sc_hd__tapvpwrvgnd_1
XFILLER_35_284 VGND VGND VPWR VPWR sky130_fd_sc_hd__decap_3
X_3967_ _3967_/A _3967_/B _3967_/C _3967_/D VGND VGND VPWR VPWR _3968_/A sky130_fd_sc_hd__or4_2
X_5706_ _5706_/A1 _4417_/X _5705_/X VGND VGND VPWR VPWR _5706_/X sky130_fd_sc_hd__a21o_2
XTAP_TAPCELL_ROW_33_474 VGND VPWR sky130_fd_sc_hd__tapvpwrvgnd_1
XFILLER_12_14 VGND VGND VPWR VPWR sky130_fd_sc_hd__fill_1
X_3898_ _4636_/S _3898_/B VGND VGND VPWR VPWR _3898_/Y sky130_fd_sc_hd__nor2_2
X_5637_ _5637_/A _6332_/A VGND VGND VPWR VPWR _5637_/X sky130_fd_sc_hd__or2_2
X_5568_ _5710_/B _5532_/A _5532_/B _5532_/C _5553_/S VGND VGND VPWR VPWR _5570_/A
+ sky130_fd_sc_hd__a41o_2
X_4519_ _4517_/Y _4518_/X _4211_/A VGND VGND VPWR VPWR _4519_/X sky130_fd_sc_hd__a21o_2
X_5499_ _5499_/A _5538_/A _5625_/A _5499_/D VGND VGND VPWR VPWR _5500_/B sky130_fd_sc_hd__or4_2
Xfanout632 input119/X VGND VGND VPWR VPWR _6374_/B sky130_fd_sc_hd__clkdlybuf4s25_1
Xfanout643 _4636_/S VGND VGND VPWR VPWR _4286_/A sky130_fd_sc_hd__clkdlybuf4s25_1
Xfanout654 _4027_/A VGND VGND VPWR VPWR _6453_/A sky130_fd_sc_hd__clkdlybuf4s25_1
Xfanout665 input110/X VGND VGND VPWR VPWR _5425_/A sky130_fd_sc_hd__clkdlybuf4s25_1
Xfanout676 _6383_/A VGND VGND VPWR VPWR _5191_/B sky130_fd_sc_hd__clkdlybuf4s25_1
Xfanout687 _4061_/S1 VGND VGND VPWR VPWR _6113_/B sky130_fd_sc_hd__clkdlybuf4s25_1
XFILLER_58_365 VGND VGND VPWR VPWR sky130_fd_sc_hd__decap_3
XFILLER_58_343 VGND VGND VPWR VPWR sky130_fd_sc_hd__decap_3
XFILLER_18_229 VGND VGND VPWR VPWR sky130_fd_sc_hd__fill_1
XFILLER_73_335 VGND VGND VPWR VPWR sky130_fd_sc_hd__fill_1
XFILLER_73_324 VGND VGND VPWR VPWR sky130_fd_sc_hd__decap_3
XFILLER_58_398 VGND VGND VPWR VPWR sky130_fd_sc_hd__decap_3
XFILLER_37_77 VGND VGND VPWR VPWR sky130_fd_sc_hd__decap_3
XFILLER_26_273 VGND VGND VPWR VPWR sky130_fd_sc_hd__decap_3
XFILLER_41_232 VGND VGND VPWR VPWR sky130_fd_sc_hd__decap_3
XFILLER_41_276 VGND VGND VPWR VPWR sky130_fd_sc_hd__decap_3
XFILLER_41_287 VGND VGND VPWR VPWR sky130_fd_sc_hd__decap_3
XFILLER_1_372 VGND VGND VPWR VPWR sky130_fd_sc_hd__decap_3
XFILLER_49_310 VGND VGND VPWR VPWR sky130_fd_sc_hd__decap_3
XFILLER_49_343 VGND VGND VPWR VPWR sky130_fd_sc_hd__decap_3
XFILLER_49_387 VGND VGND VPWR VPWR sky130_fd_sc_hd__decap_3
XTAP_TAPCELL_ROW_75_853 VGND VPWR sky130_fd_sc_hd__tapvpwrvgnd_1
X_4870_ _5162_/A _4868_/Y _4869_/Y VGND VGND VPWR VPWR _4872_/A sky130_fd_sc_hd__o21a_2
XTAP_TAPCELL_ROW_47_599 VGND VPWR sky130_fd_sc_hd__tapvpwrvgnd_1
X_3821_ _3840_/S _3858_/B VGND VGND VPWR VPWR _3928_/C sky130_fd_sc_hd__xor2_2
X_3752_ _6126_/A _3754_/A VGND VGND VPWR VPWR _3752_/X sky130_fd_sc_hd__and2b_2
X_6471_ _6463_/X _6470_/X _6471_/S VGND VGND VPWR VPWR _6471_/X sky130_fd_sc_hd__mux2_2
X_3683_ _3667_/B _3558_/B _3558_/C _3608_/Y VGND VGND VPWR VPWR _3686_/B sky130_fd_sc_hd__o31a_2
X_5422_ _5422_/A _5422_/B _5422_/C VGND VGND VPWR VPWR _5423_/B sky130_fd_sc_hd__or3_2
X_5353_ _5425_/A _5180_/B _5348_/X _5350_/X _5352_/X VGND VGND VPWR VPWR _5353_/X
+ sky130_fd_sc_hd__a221o_2
X_4304_ _4355_/B _4357_/S VGND VGND VPWR VPWR _4304_/Y sky130_fd_sc_hd__nand2_2
X_5284_ _4634_/B _5283_/X _5284_/S VGND VGND VPWR VPWR _5284_/X sky130_fd_sc_hd__mux2_2
X_4235_ _4235_/A _4235_/B VGND VGND VPWR VPWR _4235_/X sky130_fd_sc_hd__and2_2
XFILLER_59_129 VGND VGND VPWR VPWR sky130_fd_sc_hd__decap_3
X_4166_ _4124_/X _4129_/Y _4131_/X _4165_/Y VGND VGND VPWR VPWR _4166_/X sky130_fd_sc_hd__a31o_2
XTAP_TAPCELL_ROW_38_522 VGND VPWR sky130_fd_sc_hd__tapvpwrvgnd_1
XFILLER_55_346 VGND VGND VPWR VPWR sky130_fd_sc_hd__decap_3
X_4097_ _3239_/B _4096_/X _5010_/S VGND VGND VPWR VPWR _4097_/X sky130_fd_sc_hd__mux2_2
XFILLER_23_210 VGND VGND VPWR VPWR sky130_fd_sc_hd__decap_3
XFILLER_70_349 VGND VGND VPWR VPWR sky130_fd_sc_hd__decap_3
XFILLER_23_265 VGND VGND VPWR VPWR sky130_fd_sc_hd__decap_3
XFILLER_23_276 VGND VGND VPWR VPWR sky130_fd_sc_hd__decap_3
X_4999_ _4999_/A _4999_/B _4999_/C _4998_/X VGND VGND VPWR VPWR _5000_/A sky130_fd_sc_hd__or4b_2
XFILLER_11_449 VGND VGND VPWR VPWR sky130_fd_sc_hd__fill_2
Xwire329 _3668_/D VGND VGND VPWR VPWR _3691_/A sky130_fd_sc_hd__buf_2
Xfanout451 input67/X VGND VGND VPWR VPWR _3664_/A sky130_fd_sc_hd__clkdlybuf4s25_1
Xfanout462 input63/X VGND VGND VPWR VPWR _5932_/A sky130_fd_sc_hd__clkdlybuf4s25_1
Xfanout473 input59/X VGND VGND VPWR VPWR _5874_/A sky130_fd_sc_hd__clkdlybuf4s25_1
Xfanout484 input54/X VGND VGND VPWR VPWR _6440_/A3 sky130_fd_sc_hd__clkdlybuf4s25_1
Xfanout495 _3872_/A VGND VGND VPWR VPWR _5263_/A sky130_fd_sc_hd__clkdlybuf4s25_1
XFILLER_58_195 VGND VGND VPWR VPWR sky130_fd_sc_hd__fill_1
XFILLER_46_368 VGND VGND VPWR VPWR sky130_fd_sc_hd__decap_3
XTAP_TAPCELL_ROW_72_823 VGND VPWR sky130_fd_sc_hd__tapvpwrvgnd_1
XTAP_TAPCELL_ROW_1_191 VGND VPWR sky130_fd_sc_hd__tapvpwrvgnd_1
XFILLER_61_349 VGND VGND VPWR VPWR sky130_fd_sc_hd__decap_3
XFILLER_14_287 VGND VGND VPWR VPWR sky130_fd_sc_hd__decap_3
Xmax_cap607 _5932_/B VGND VGND VPWR VPWR _6040_/B sky130_fd_sc_hd__buf_2
XFILLER_6_475 VGND VGND VPWR VPWR sky130_fd_sc_hd__fill_1
X_4020_ _4042_/A VGND VGND VPWR VPWR _4021_/S sky130_fd_sc_hd__inv_2
XFILLER_37_346 VGND VGND VPWR VPWR sky130_fd_sc_hd__decap_3
XFILLER_49_195 VGND VGND VPWR VPWR sky130_fd_sc_hd__decap_3
XFILLER_52_305 VGND VGND VPWR VPWR sky130_fd_sc_hd__decap_3
X_5971_ _5939_/A _6492_/B _5968_/Y _5969_/X _5970_/Y VGND VGND VPWR VPWR _5971_/X
+ sky130_fd_sc_hd__o221a_2
XFILLER_64_176 VGND VGND VPWR VPWR sky130_fd_sc_hd__decap_3
XFILLER_45_390 VGND VGND VPWR VPWR sky130_fd_sc_hd__fill_2
X_4922_ _4922_/A _4922_/B VGND VGND VPWR VPWR _6078_/A sky130_fd_sc_hd__nor2_2
X_4853_ _4588_/B _5536_/B _4828_/Y VGND VGND VPWR VPWR _4853_/X sky130_fd_sc_hd__a21o_2
XFILLER_60_382 VGND VGND VPWR VPWR sky130_fd_sc_hd__fill_1
X_4784_ _4784_/A VGND VGND VPWR VPWR _4784_/X sky130_fd_sc_hd__buf_1
X_3804_ _3299_/A _3985_/B _3780_/Y VGND VGND VPWR VPWR _3805_/B sky130_fd_sc_hd__o21bai_2
X_3735_ _3735_/A _3735_/B _3777_/D _3735_/D VGND VGND VPWR VPWR _3735_/X sky130_fd_sc_hd__or4_2
X_6454_ _6454_/A _6454_/B VGND VGND VPWR VPWR _6455_/B sky130_fd_sc_hd__nand2_2
X_5405_ _5341_/A _5405_/B _5422_/A _5422_/C VGND VGND VPWR VPWR _5579_/B sky130_fd_sc_hd__and4b_2
X_3666_ _3666_/A _3666_/B _3666_/C VGND VGND VPWR VPWR _3666_/X sky130_fd_sc_hd__or3_2
X_6385_ _5251_/Y _6383_/Y _6384_/Y _6391_/A VGND VGND VPWR VPWR _6386_/B sky130_fd_sc_hd__a22o_2
X_3597_ _3794_/C _3394_/X _3596_/X _3500_/S VGND VGND VPWR VPWR _3597_/X sky130_fd_sc_hd__a22o_2
X_5336_ _5308_/B _5322_/B _5335_/X VGND VGND VPWR VPWR _5337_/B sky130_fd_sc_hd__o21a_2
XTAP_TAPCELL_ROW_7_239 VGND VPWR sky130_fd_sc_hd__tapvpwrvgnd_1
X_5267_ _5274_/A _5274_/C _5274_/D VGND VGND VPWR VPWR _5579_/A sky130_fd_sc_hd__nor3_2
X_4218_ _4842_/A VGND VGND VPWR VPWR _4937_/A sky130_fd_sc_hd__clkbuf_2
XFILLER_28_313 VGND VGND VPWR VPWR sky130_fd_sc_hd__fill_2
X_5198_ _5669_/B2 _5438_/A _5168_/B _5166_/X _5197_/Y VGND VGND VPWR VPWR _5198_/X
+ sky130_fd_sc_hd__a41o_2
XFILLER_18_46 VGND VGND VPWR VPWR sky130_fd_sc_hd__fill_1
XFILLER_28_357 VGND VGND VPWR VPWR sky130_fd_sc_hd__decap_3
X_4149_ _4757_/S VGND VGND VPWR VPWR _5137_/A sky130_fd_sc_hd__clkbuf_1
XFILLER_28_368 VGND VGND VPWR VPWR sky130_fd_sc_hd__decap_3
XFILLER_70_102 VGND VGND VPWR VPWR sky130_fd_sc_hd__fill_2
XFILLER_55_187 VGND VGND VPWR VPWR sky130_fd_sc_hd__decap_3
XFILLER_11_279 VGND VGND VPWR VPWR sky130_fd_sc_hd__fill_1
XFILLER_78_235 VGND VGND VPWR VPWR sky130_fd_sc_hd__decap_3
XFILLER_78_268 VGND VGND VPWR VPWR sky130_fd_sc_hd__decap_3
XTAP_TAPCELL_ROW_49_617 VGND VPWR sky130_fd_sc_hd__tapvpwrvgnd_1
XFILLER_46_187 VGND VGND VPWR VPWR sky130_fd_sc_hd__decap_3
XTAP_TAPCELL_ROW_57_694 VGND VPWR sky130_fd_sc_hd__tapvpwrvgnd_1
XFILLER_61_124 VGND VGND VPWR VPWR sky130_fd_sc_hd__decap_3
XFILLER_61_146 VGND VGND VPWR VPWR sky130_fd_sc_hd__decap_3
XFILLER_42_360 VGND VGND VPWR VPWR sky130_fd_sc_hd__decap_3
X_3520_ _3548_/B _3464_/A _3520_/S VGND VGND VPWR VPWR _3520_/X sky130_fd_sc_hd__mux2_2
XTAP_TAPCELL_ROW_12_285 VGND VPWR sky130_fd_sc_hd__tapvpwrvgnd_1
X_3451_ _5946_/A3 _6431_/A1 _3451_/S VGND VGND VPWR VPWR _3451_/X sky130_fd_sc_hd__mux2_2
X_6170_ _6170_/A _6183_/A _6183_/B VGND VGND VPWR VPWR _6171_/C sky130_fd_sc_hd__and3_2
X_3382_ _3378_/X _3381_/X _3495_/A VGND VGND VPWR VPWR _3382_/X sky130_fd_sc_hd__mux2_2
Xload_slew610 _4990_/A1 VGND VGND VPWR VPWR _5440_/A sky130_fd_sc_hd__buf_4
X_5121_ _5573_/A _5572_/D VGND VGND VPWR VPWR _5438_/A sky130_fd_sc_hd__nand2_2
XFILLER_69_213 VGND VGND VPWR VPWR sky130_fd_sc_hd__decap_3
XFILLER_57_408 VGND VGND VPWR VPWR sky130_fd_sc_hd__decap_3
X_5052_ _5051_/A _5051_/Y _5052_/S VGND VGND VPWR VPWR _5052_/X sky130_fd_sc_hd__mux2_2
X_4003_ _4003_/A VGND VGND VPWR VPWR _4004_/B sky130_fd_sc_hd__inv_2
XFILLER_77_290 VGND VGND VPWR VPWR sky130_fd_sc_hd__fill_2
XFILLER_37_165 VGND VGND VPWR VPWR sky130_fd_sc_hd__decap_3
X_5954_ _6492_/B _6491_/B VGND VGND VPWR VPWR _5976_/B sky130_fd_sc_hd__nand2_2
X_5885_ _5885_/A _6040_/A VGND VGND VPWR VPWR _5885_/Y sky130_fd_sc_hd__nor2_2
X_4905_ _4872_/A _4872_/B _4975_/D _4956_/A VGND VGND VPWR VPWR _4908_/B sky130_fd_sc_hd__a211oi_2
XFILLER_33_393 VGND VGND VPWR VPWR sky130_fd_sc_hd__decap_3
X_4836_ _4143_/B _4834_/X _4879_/S VGND VGND VPWR VPWR _4836_/X sky130_fd_sc_hd__mux2_2
XFILLER_60_190 VGND VGND VPWR VPWR sky130_fd_sc_hd__decap_3
X_4767_ _4863_/A _4910_/A VGND VGND VPWR VPWR _4954_/A sky130_fd_sc_hd__nand2_2
X_4698_ _4698_/A _4697_/X VGND VGND VPWR VPWR _4736_/S sky130_fd_sc_hd__or2b_2
X_3718_ _6015_/A _3641_/B _4241_/B _4077_/A _3717_/X VGND VGND VPWR VPWR _3718_/X
+ sky130_fd_sc_hd__a221o_2
X_6437_ _6428_/X _6436_/X _6437_/S VGND VGND VPWR VPWR _6437_/X sky130_fd_sc_hd__mux2_2
X_3649_ _6461_/A2 _6457_/A3 _6457_/A2 _6460_/A3 _6461_/S0 _3948_/S1 VGND VGND VPWR
+ VPWR _3649_/X sky130_fd_sc_hd__mux4_2
X_6368_ _6319_/B _6362_/X _6364_/X _6367_/Y VGND VGND VPWR VPWR _6368_/X sky130_fd_sc_hd__o211a_2
X_5319_ _5319_/A _5319_/B VGND VGND VPWR VPWR _5319_/X sky130_fd_sc_hd__xor2_2
X_6299_ _6299_/A VGND VGND VPWR VPWR _6383_/B sky130_fd_sc_hd__buf_1
XFILLER_48_419 VGND VGND VPWR VPWR sky130_fd_sc_hd__fill_1
XFILLER_75_216 VGND VGND VPWR VPWR sky130_fd_sc_hd__decap_3
XFILLER_28_176 VGND VGND VPWR VPWR sky130_fd_sc_hd__fill_2
XFILLER_43_113 VGND VGND VPWR VPWR sky130_fd_sc_hd__decap_3
XFILLER_43_135 VGND VGND VPWR VPWR sky130_fd_sc_hd__decap_3
XTAP_TAPCELL_ROW_54_664 VGND VPWR sky130_fd_sc_hd__tapvpwrvgnd_1
XFILLER_24_393 VGND VGND VPWR VPWR sky130_fd_sc_hd__decap_3
XFILLER_51_190 VGND VGND VPWR VPWR sky130_fd_sc_hd__decap_3
XANTENNA_9 _3370_/X VGND VGND VPWR VPWR sky130_fd_sc_hd__diode_2
XFILLER_66_227 VGND VGND VPWR VPWR sky130_fd_sc_hd__decap_3
XFILLER_19_154 VGND VGND VPWR VPWR sky130_fd_sc_hd__fill_1
XFILLER_47_452 VGND VGND VPWR VPWR sky130_fd_sc_hd__fill_1
XFILLER_47_463 VGND VGND VPWR VPWR sky130_fd_sc_hd__fill_1
XFILLER_34_113 VGND VGND VPWR VPWR sky130_fd_sc_hd__decap_3
XFILLER_74_282 VGND VGND VPWR VPWR sky130_fd_sc_hd__decap_3
XTAP_TAPCELL_ROW_17_333 VGND VPWR sky130_fd_sc_hd__tapvpwrvgnd_1
XFILLER_15_393 VGND VGND VPWR VPWR sky130_fd_sc_hd__decap_3
X_5670_ _6349_/A VGND VGND VPWR VPWR _5697_/S sky130_fd_sc_hd__inv_2
XFILLER_30_341 VGND VGND VPWR VPWR sky130_fd_sc_hd__decap_3
X_4621_ _4768_/A _4621_/B _4621_/C VGND VGND VPWR VPWR _4622_/B sky130_fd_sc_hd__and3_2
X_4552_ _4721_/S VGND VGND VPWR VPWR _5442_/S sky130_fd_sc_hd__clkbuf_2
Xmax_cap234 _4442_/X VGND VGND VPWR VPWR _4443_/B sky130_fd_sc_hd__buf_2
Xmax_cap223 _4486_/X VGND VGND VPWR VPWR _4538_/B sky130_fd_sc_hd__buf_2
Xmax_cap212 _5195_/Y VGND VGND VPWR VPWR _5688_/A1 sky130_fd_sc_hd__buf_2
X_4483_ _6224_/A _6185_/A _4482_/X _4541_/S VGND VGND VPWR VPWR _4483_/Y sky130_fd_sc_hd__o211ai_2
X_3503_ _6439_/A0 _6439_/A3 _5615_/A3 _6439_/A2 _3503_/S0 _3631_/S0 VGND VGND VPWR
+ VPWR _3503_/X sky130_fd_sc_hd__mux4_2
X_6222_ _6224_/A _4546_/A _6233_/C VGND VGND VPWR VPWR _6227_/B sky130_fd_sc_hd__o21ai_2
Xmax_cap278 _5457_/X VGND VGND VPWR VPWR _5501_/B sky130_fd_sc_hd__buf_2
Xmax_cap267 _5007_/A VGND VGND VPWR VPWR _4497_/A sky130_fd_sc_hd__buf_4
Xmax_cap256 _3480_/A VGND VGND VPWR VPWR _4132_/A sky130_fd_sc_hd__buf_2
Xmax_cap245 _6161_/B VGND VGND VPWR VPWR _6067_/C sky130_fd_sc_hd__buf_2
X_3434_ _3430_/X _3433_/X _3735_/A VGND VGND VPWR VPWR _3434_/X sky130_fd_sc_hd__a21o_2
X_6153_ _6152_/A _6152_/B _6156_/B _6152_/Y VGND VGND VPWR VPWR _6153_/X sky130_fd_sc_hd__a31o_2
Xload_slew440 _6424_/A VGND VGND VPWR VPWR _4506_/S sky130_fd_sc_hd__buf_4
X_3365_ _3357_/B _3264_/A _6429_/A VGND VGND VPWR VPWR _3794_/C sky130_fd_sc_hd__mux2_2
X_6084_ _6262_/A _6074_/X _6076_/X _6083_/X VGND VGND VPWR VPWR _6084_/X sky130_fd_sc_hd__o211a_2
X_5104_ _4761_/A _5084_/X _5089_/X _4320_/A _5103_/X VGND VGND VPWR VPWR _5104_/X
+ sky130_fd_sc_hd__a221o_2
X_3296_ _3296_/A _3535_/A VGND VGND VPWR VPWR _3296_/Y sky130_fd_sc_hd__nand2_2
X_5035_ _4962_/A _5030_/X _5032_/Y _5034_/X VGND VGND VPWR VPWR _5120_/D sky130_fd_sc_hd__a211o_2
XFILLER_38_474 VGND VGND VPWR VPWR sky130_fd_sc_hd__fill_2
XTAP_TAPCELL_ROW_68_789 VGND VPWR sky130_fd_sc_hd__tapvpwrvgnd_1
XFILLER_25_113 VGND VGND VPWR VPWR sky130_fd_sc_hd__decap_3
XFILLER_40_116 VGND VGND VPWR VPWR sky130_fd_sc_hd__decap_3
XFILLER_53_477 VGND VGND VPWR VPWR sky130_fd_sc_hd__fill_1
X_5937_ _5968_/A _6410_/A VGND VGND VPWR VPWR _5937_/X sky130_fd_sc_hd__or2_2
XTAP_TAPCELL_ROW_51_634 VGND VPWR sky130_fd_sc_hd__tapvpwrvgnd_1
X_5868_ _5866_/A _6400_/A _5867_/Y VGND VGND VPWR VPWR _5935_/A sky130_fd_sc_hd__a21oi_2
XFILLER_21_396 VGND VGND VPWR VPWR sky130_fd_sc_hd__decap_3
X_5799_ _4560_/A _4885_/X _5798_/X _6486_/C wire230/X VGND VGND VPWR VPWR _5805_/A
+ sky130_fd_sc_hd__a221o_2
X_4819_ _4975_/B _4819_/B VGND VGND VPWR VPWR _4819_/X sky130_fd_sc_hd__and2_2
Xinput102 operand_b[39] VGND VGND VPWR VPWR input102/X sky130_fd_sc_hd__clkdlybuf4s25_1
Xinput124 operand_b[59] VGND VGND VPWR VPWR _6417_/A sky130_fd_sc_hd__clkdlybuf4s25_1
Xinput113 operand_b[49] VGND VGND VPWR VPWR _5503_/A2 sky130_fd_sc_hd__clkdlybuf4s25_1
XTAP_TAPCELL_ROW_59_712 VGND VPWR sky130_fd_sc_hd__tapvpwrvgnd_1
XFILLER_48_227 VGND VGND VPWR VPWR sky130_fd_sc_hd__decap_3
XFILLER_48_249 VGND VGND VPWR VPWR sky130_fd_sc_hd__decap_3
XFILLER_44_411 VGND VGND VPWR VPWR sky130_fd_sc_hd__decap_3
XPHY_EDGE_ROW_19_Right_19 VGND VGND VPWR VPWR sky130_fd_sc_hd__decap_3
XFILLER_71_241 VGND VGND VPWR VPWR sky130_fd_sc_hd__decap_3
XTAP_TAPCELL_ROW_14_303 VGND VPWR sky130_fd_sc_hd__tapvpwrvgnd_1
XFILLER_71_263 VGND VGND VPWR VPWR sky130_fd_sc_hd__fill_2
XTAP_TAPCELL_ROW_22_380 VGND VPWR sky130_fd_sc_hd__tapvpwrvgnd_1
XPHY_EDGE_ROW_28_Right_28 VGND VGND VPWR VPWR sky130_fd_sc_hd__decap_3
XFILLER_39_249 VGND VGND VPWR VPWR sky130_fd_sc_hd__decap_3
XFILLER_35_411 VGND VGND VPWR VPWR sky130_fd_sc_hd__fill_2
XPHY_EDGE_ROW_37_Right_37 VGND VGND VPWR VPWR sky130_fd_sc_hd__decap_3
XFILLER_35_466 VGND VGND VPWR VPWR sky130_fd_sc_hd__fill_2
XFILLER_62_274 VGND VGND VPWR VPWR sky130_fd_sc_hd__decap_3
X_5722_ _5723_/B _5723_/C _5731_/A VGND VGND VPWR VPWR _5724_/A sky130_fd_sc_hd__a21o_2
X_3983_ _4365_/A _6152_/A _3982_/X VGND VGND VPWR VPWR _3983_/X sky130_fd_sc_hd__o21a_2
XFILLER_30_171 VGND VGND VPWR VPWR sky130_fd_sc_hd__decap_3
X_5653_ _5653_/A _5762_/B VGND VGND VPWR VPWR _5653_/X sky130_fd_sc_hd__or2_2
X_5584_ _6346_/A _6439_/A2 _5615_/A3 _6439_/A3 _5764_/S0 _5801_/S1 VGND VGND VPWR
+ VPWR _5584_/X sky130_fd_sc_hd__mux4_2
X_4604_ _5442_/S _3896_/B _4456_/Y _4603_/X VGND VGND VPWR VPWR _4604_/X sky130_fd_sc_hd__a31o_2
XPHY_EDGE_ROW_46_Right_46 VGND VGND VPWR VPWR sky130_fd_sc_hd__decap_3
X_4535_ _4536_/B _4536_/C _4627_/C VGND VGND VPWR VPWR _4537_/A sky130_fd_sc_hd__a21o_2
X_4466_ _4465_/X _5137_/B _6453_/A VGND VGND VPWR VPWR _4467_/B sky130_fd_sc_hd__mux2_2
XPHY_EDGE_ROW_15_Left_98 VGND VGND VPWR VPWR sky130_fd_sc_hd__decap_3
X_6205_ _6021_/D _4356_/A _6217_/A _6204_/Y _6200_/B VGND VGND VPWR VPWR _6205_/X
+ sky130_fd_sc_hd__o32a_2
X_4397_ _6208_/A _6022_/C VGND VGND VPWR VPWR _6178_/B sky130_fd_sc_hd__xor2_2
X_3417_ _3417_/A _3694_/B VGND VGND VPWR VPWR _3418_/A sky130_fd_sc_hd__or2_2
X_6136_ _6138_/A _6135_/Y _3753_/Y VGND VGND VPWR VPWR _6136_/X sky130_fd_sc_hd__o21a_2
X_3348_ _3348_/A _3354_/S VGND VGND VPWR VPWR _3348_/Y sky130_fd_sc_hd__nor2_2
X_6067_ _6247_/A _6067_/B _6067_/C VGND VGND VPWR VPWR _6244_/B sky130_fd_sc_hd__and3_2
X_3279_ _3800_/B _3278_/X _3698_/S VGND VGND VPWR VPWR _3279_/X sky130_fd_sc_hd__mux2_2
XPHY_EDGE_ROW_55_Right_55 VGND VGND VPWR VPWR sky130_fd_sc_hd__decap_3
XFILLER_26_400 VGND VGND VPWR VPWR sky130_fd_sc_hd__decap_3
X_5018_ _5224_/A _4846_/A _6265_/B VGND VGND VPWR VPWR _5018_/X sky130_fd_sc_hd__mux2_2
XTAP_TAPCELL_ROW_28_428 VGND VPWR sky130_fd_sc_hd__tapvpwrvgnd_1
XFILLER_53_230 VGND VGND VPWR VPWR sky130_fd_sc_hd__decap_3
XFILLER_53_263 VGND VGND VPWR VPWR sky130_fd_sc_hd__decap_3
XFILLER_53_274 VGND VGND VPWR VPWR sky130_fd_sc_hd__decap_3
XFILLER_13_116 VGND VGND VPWR VPWR sky130_fd_sc_hd__fill_1
XFILLER_13_127 VGND VGND VPWR VPWR sky130_fd_sc_hd__decap_3
XPHY_EDGE_ROW_64_Right_64 VGND VGND VPWR VPWR sky130_fd_sc_hd__decap_3
XFILLER_21_182 VGND VGND VPWR VPWR sky130_fd_sc_hd__decap_3
XFILLER_5_348 VGND VGND VPWR VPWR sky130_fd_sc_hd__decap_3
XFILLER_3_17 VGND VGND VPWR VPWR sky130_fd_sc_hd__fill_1
XPHY_EDGE_ROW_73_Right_73 VGND VGND VPWR VPWR sky130_fd_sc_hd__decap_3
XFILLER_29_271 VGND VGND VPWR VPWR sky130_fd_sc_hd__decap_3
XFILLER_44_241 VGND VGND VPWR VPWR sky130_fd_sc_hd__decap_3
XFILLER_44_274 VGND VGND VPWR VPWR sky130_fd_sc_hd__decap_3
XFILLER_44_296 VGND VGND VPWR VPWR sky130_fd_sc_hd__fill_2
XPHY_EDGE_ROW_82_Right_82 VGND VGND VPWR VPWR sky130_fd_sc_hd__decap_3
XFILLER_12_171 VGND VGND VPWR VPWR sky130_fd_sc_hd__fill_2
X_4320_ _4320_/A VGND VGND VPWR VPWR _5168_/A sky130_fd_sc_hd__clkbuf_1
X_4251_ _4263_/A _4251_/B _4251_/C VGND VGND VPWR VPWR _4251_/Y sky130_fd_sc_hd__nand3b_2
X_4182_ _4181_/A _6170_/A _6164_/A _6167_/A VGND VGND VPWR VPWR _4186_/B sky130_fd_sc_hd__o211a_2
XFILLER_67_355 VGND VGND VPWR VPWR sky130_fd_sc_hd__decap_3
XFILLER_27_219 VGND VGND VPWR VPWR sky130_fd_sc_hd__decap_3
XTAP_TAPCELL_ROW_78_884 VGND VPWR sky130_fd_sc_hd__tapvpwrvgnd_1
XFILLER_67_377 VGND VGND VPWR VPWR sky130_fd_sc_hd__decap_3
XFILLER_35_252 VGND VGND VPWR VPWR sky130_fd_sc_hd__fill_2
XFILLER_35_263 VGND VGND VPWR VPWR sky130_fd_sc_hd__decap_3
XFILLER_50_211 VGND VGND VPWR VPWR sky130_fd_sc_hd__decap_3
XFILLER_50_244 VGND VGND VPWR VPWR sky130_fd_sc_hd__decap_3
X_3966_ _3934_/X _6133_/B _3966_/S VGND VGND VPWR VPWR _3967_/D sky130_fd_sc_hd__mux2_2
XFILLER_50_277 VGND VGND VPWR VPWR sky130_fd_sc_hd__decap_3
X_5705_ _5739_/B _5701_/Y _5704_/Y _4424_/X _4937_/A VGND VGND VPWR VPWR _5705_/X
+ sky130_fd_sc_hd__o311a_2
XTAP_TAPCELL_ROW_33_475 VGND VPWR sky130_fd_sc_hd__tapvpwrvgnd_1
X_5636_ _5688_/A1 _5579_/X _5635_/X _5580_/X VGND VGND VPWR VPWR _5639_/B sky130_fd_sc_hd__a211o_2
X_3897_ _3383_/X _3459_/B _3438_/X _3458_/X _4931_/B2 _3625_/A VGND VGND VPWR VPWR
+ _3898_/B sky130_fd_sc_hd__mux4_2
X_5567_ _5647_/A _5567_/B VGND VGND VPWR VPWR _5712_/B sky130_fd_sc_hd__nor2_2
XFILLER_2_329 VGND VGND VPWR VPWR sky130_fd_sc_hd__decap_3
X_5498_ _5498_/A _5498_/B VGND VGND VPWR VPWR _5500_/A sky130_fd_sc_hd__nor2_2
X_4518_ _6189_/B _5099_/B _4370_/A _4489_/B VGND VGND VPWR VPWR _4518_/X sky130_fd_sc_hd__o2bb2a_2
X_4449_ _4449_/A _4449_/B _4449_/C VGND VGND VPWR VPWR _4449_/Y sky130_fd_sc_hd__nand3_2
Xfanout600 _6089_/A VGND VGND VPWR VPWR _6126_/A sky130_fd_sc_hd__clkdlybuf4s25_1
Xfanout611 wire614/A VGND VGND VPWR VPWR _5706_/A1 sky130_fd_sc_hd__clkdlybuf4s25_1
Xfanout622 input125/X VGND VGND VPWR VPWR _4295_/A1 sky130_fd_sc_hd__clkdlybuf4s25_1
Xfanout633 input119/X VGND VGND VPWR VPWR _5714_/A sky130_fd_sc_hd__clkdlybuf4s25_1
XFILLER_58_300 VGND VGND VPWR VPWR sky130_fd_sc_hd__decap_3
Xfanout644 _5508_/A1 VGND VGND VPWR VPWR _4636_/S sky130_fd_sc_hd__clkdlybuf4s25_1
Xfanout655 _6114_/A VGND VGND VPWR VPWR _3672_/B1 sky130_fd_sc_hd__clkdlybuf4s25_1
Xfanout666 _4044_/A VGND VGND VPWR VPWR _4042_/A sky130_fd_sc_hd__clkdlybuf4s25_1
X_6119_ _6122_/A1 _3670_/X _6121_/S VGND VGND VPWR VPWR _6119_/X sky130_fd_sc_hd__mux2_2
Xfanout677 _5196_/A2 VGND VGND VPWR VPWR _6383_/A sky130_fd_sc_hd__clkdlybuf4s25_1
Xfanout688 input103/X VGND VGND VPWR VPWR _4061_/S1 sky130_fd_sc_hd__clkdlybuf4s25_1
XFILLER_58_355 VGND VGND VPWR VPWR sky130_fd_sc_hd__fill_1
XFILLER_37_89 VGND VGND VPWR VPWR sky130_fd_sc_hd__fill_2
XFILLER_73_369 VGND VGND VPWR VPWR sky130_fd_sc_hd__fill_1
XFILLER_26_285 VGND VGND VPWR VPWR sky130_fd_sc_hd__decap_3
XFILLER_41_211 VGND VGND VPWR VPWR sky130_fd_sc_hd__decap_3
XFILLER_41_255 VGND VGND VPWR VPWR sky130_fd_sc_hd__decap_3
XFILLER_53_55 VGND VGND VPWR VPWR sky130_fd_sc_hd__fill_1
XFILLER_53_88 VGND VGND VPWR VPWR sky130_fd_sc_hd__decap_3
XFILLER_41_299 VGND VGND VPWR VPWR sky130_fd_sc_hd__decap_3
XFILLER_53_99 VGND VGND VPWR VPWR sky130_fd_sc_hd__decap_3
XFILLER_1_340 VGND VGND VPWR VPWR sky130_fd_sc_hd__fill_2
XFILLER_49_322 VGND VGND VPWR VPWR sky130_fd_sc_hd__decap_3
XFILLER_49_366 VGND VGND VPWR VPWR sky130_fd_sc_hd__decap_3
XFILLER_76_163 VGND VGND VPWR VPWR sky130_fd_sc_hd__decap_3
XFILLER_64_325 VGND VGND VPWR VPWR sky130_fd_sc_hd__fill_1
XTAP_TAPCELL_ROW_75_854 VGND VPWR sky130_fd_sc_hd__tapvpwrvgnd_1
XFILLER_17_274 VGND VGND VPWR VPWR sky130_fd_sc_hd__decap_3
XFILLER_32_200 VGND VGND VPWR VPWR sky130_fd_sc_hd__decap_3
XFILLER_20_406 VGND VGND VPWR VPWR sky130_fd_sc_hd__decap_3
X_3820_ _3820_/A _3820_/B VGND VGND VPWR VPWR _3858_/B sky130_fd_sc_hd__nand2_2
XFILLER_32_277 VGND VGND VPWR VPWR sky130_fd_sc_hd__decap_3
X_3751_ _4150_/A _5228_/A _5138_/B _4102_/A VGND VGND VPWR VPWR _3751_/X sky130_fd_sc_hd__a211o_2
XTAP_TAPCELL_ROW_30_445 VGND VPWR sky130_fd_sc_hd__tapvpwrvgnd_1
X_6470_ _6466_/X _6469_/X _6470_/S VGND VGND VPWR VPWR _6470_/X sky130_fd_sc_hd__mux2_2
X_3682_ _3682_/A VGND VGND VPWR VPWR _3727_/A sky130_fd_sc_hd__buf_6
XFILLER_71_3 VGND VGND VPWR VPWR sky130_fd_sc_hd__decap_3
X_5421_ _5421_/A _5421_/B VGND VGND VPWR VPWR _5421_/Y sky130_fd_sc_hd__nor2_2
X_5352_ _5352_/A _5416_/A _5352_/C VGND VGND VPWR VPWR _5352_/X sky130_fd_sc_hd__and3_2
X_4303_ _4355_/B _4357_/S VGND VGND VPWR VPWR _4303_/Y sky130_fd_sc_hd__nor2_2
X_5283_ _4971_/X _5282_/X _5548_/S VGND VGND VPWR VPWR _5283_/X sky130_fd_sc_hd__mux2_2
X_4234_ _4931_/B2 _3455_/X _3460_/X _4234_/C1 VGND VGND VPWR VPWR _4235_/B sky130_fd_sc_hd__a211o_2
XFILLER_28_506 VGND VGND VPWR VPWR sky130_fd_sc_hd__fill_2
X_4165_ _4513_/B _4136_/Y _4145_/X _4295_/A1 _4164_/Y VGND VGND VPWR VPWR _4165_/Y
+ sky130_fd_sc_hd__o221ai_2
XFILLER_55_325 VGND VGND VPWR VPWR sky130_fd_sc_hd__fill_2
X_4096_ _3276_/X _3279_/X _4462_/S VGND VGND VPWR VPWR _4096_/X sky130_fd_sc_hd__mux2_2
XTAP_TAPCELL_ROW_38_523 VGND VPWR sky130_fd_sc_hd__tapvpwrvgnd_1
XFILLER_67_196 VGND VGND VPWR VPWR sky130_fd_sc_hd__fill_1
XFILLER_55_369 VGND VGND VPWR VPWR sky130_fd_sc_hd__decap_3
XFILLER_23_222 VGND VGND VPWR VPWR sky130_fd_sc_hd__fill_2
XFILLER_63_380 VGND VGND VPWR VPWR sky130_fd_sc_hd__decap_3
XFILLER_23_299 VGND VGND VPWR VPWR sky130_fd_sc_hd__fill_2
X_4998_ _4997_/A _6077_/C _4997_/B _4997_/C _5108_/B VGND VGND VPWR VPWR _4998_/X
+ sky130_fd_sc_hd__a221o_2
Xwire319 _4654_/Y VGND VGND VPWR VPWR _6243_/C sky130_fd_sc_hd__buf_2
X_3949_ _3529_/X _3531_/X _3949_/S VGND VGND VPWR VPWR _3950_/B sky130_fd_sc_hd__mux2_2
XPHY_EDGE_ROW_36_Left_119 VGND VGND VPWR VPWR sky130_fd_sc_hd__decap_3
X_5619_ _5014_/B _5510_/B _5614_/Y _5739_/B _5618_/Y VGND VGND VPWR VPWR _5619_/X
+ sky130_fd_sc_hd__o221a_2
Xfanout430 _3706_/S VGND VGND VPWR VPWR _3306_/C sky130_fd_sc_hd__clkdlybuf4s25_1
Xfanout441 _6100_/A VGND VGND VPWR VPWR _3411_/A1 sky130_fd_sc_hd__clkdlybuf4s25_1
Xfanout452 _4086_/A VGND VGND VPWR VPWR _3681_/A sky130_fd_sc_hd__clkdlybuf4s25_1
Xfanout463 input63/X VGND VGND VPWR VPWR _6431_/A1 sky130_fd_sc_hd__clkdlybuf4s25_1
Xfanout474 input59/X VGND VGND VPWR VPWR _6429_/B sky130_fd_sc_hd__clkdlybuf4s25_1
XPHY_EDGE_ROW_45_Left_128 VGND VGND VPWR VPWR sky130_fd_sc_hd__decap_3
XFILLER_58_141 VGND VGND VPWR VPWR sky130_fd_sc_hd__decap_3
XFILLER_58_130 VGND VGND VPWR VPWR sky130_fd_sc_hd__fill_1
Xfanout485 _6440_/A0 VGND VGND VPWR VPWR _6346_/A sky130_fd_sc_hd__clkdlybuf4s25_1
Xfanout496 _3872_/A VGND VGND VPWR VPWR wire497/A sky130_fd_sc_hd__clkdlybuf4s25_1
XFILLER_46_347 VGND VGND VPWR VPWR sky130_fd_sc_hd__decap_3
XFILLER_61_317 VGND VGND VPWR VPWR sky130_fd_sc_hd__decap_3
XFILLER_14_222 VGND VGND VPWR VPWR sky130_fd_sc_hd__decap_3
XTAP_TAPCELL_ROW_72_824 VGND VPWR sky130_fd_sc_hd__tapvpwrvgnd_1
XTAP_TAPCELL_ROW_1_192 VGND VPWR sky130_fd_sc_hd__tapvpwrvgnd_1
XFILLER_14_233 VGND VGND VPWR VPWR sky130_fd_sc_hd__decap_3
XPHY_EDGE_ROW_54_Left_137 VGND VGND VPWR VPWR sky130_fd_sc_hd__decap_3
XPHY_EDGE_ROW_63_Left_146 VGND VGND VPWR VPWR sky130_fd_sc_hd__decap_3
XFILLER_49_152 VGND VGND VPWR VPWR sky130_fd_sc_hd__decap_3
X_5970_ _6423_/B _5970_/B VGND VGND VPWR VPWR _5970_/Y sky130_fd_sc_hd__nand2_2
X_4921_ _4863_/A _4825_/Y _4817_/A _4975_/C _4920_/X VGND VGND VPWR VPWR _4921_/X
+ sky130_fd_sc_hd__o311a_2
X_4852_ _4828_/Y _4830_/X _4839_/X _4990_/A1 _4851_/X VGND VGND VPWR VPWR _4852_/Y
+ sky130_fd_sc_hd__o221ai_2
X_3803_ _3797_/X _3802_/X _3803_/S VGND VGND VPWR VPWR _3803_/X sky130_fd_sc_hd__mux2_2
XTAP_TAPCELL_ROW_43_570 VGND VPWR sky130_fd_sc_hd__tapvpwrvgnd_1
XPHY_EDGE_ROW_72_Left_155 VGND VGND VPWR VPWR sky130_fd_sc_hd__decap_3
XFILLER_60_372 VGND VGND VPWR VPWR sky130_fd_sc_hd__decap_3
XFILLER_60_361 VGND VGND VPWR VPWR sky130_fd_sc_hd__decap_3
X_4783_ _4783_/A _4783_/B _4778_/Y VGND VGND VPWR VPWR _4784_/A sky130_fd_sc_hd__or3b_2
XFILLER_20_269 VGND VGND VPWR VPWR sky130_fd_sc_hd__decap_3
X_3734_ _3734_/A _3855_/A _3855_/B VGND VGND VPWR VPWR _3735_/D sky130_fd_sc_hd__or3_2
X_6453_ _6453_/A _6453_/B VGND VGND VPWR VPWR _6454_/B sky130_fd_sc_hd__nand2_2
X_3665_ _3728_/A _3816_/A VGND VGND VPWR VPWR _3689_/A sky130_fd_sc_hd__nand2_2
X_5404_ _6322_/B _5467_/A VGND VGND VPWR VPWR _5501_/A sky130_fd_sc_hd__nand2_2
X_6384_ _6383_/A _6383_/B _6306_/C VGND VGND VPWR VPWR _6384_/Y sky130_fd_sc_hd__o21ai_2
X_3596_ _3520_/X _3595_/X _3596_/S VGND VGND VPWR VPWR _3596_/X sky130_fd_sc_hd__mux2_2
X_5335_ _5308_/B _5322_/B _5328_/S VGND VGND VPWR VPWR _5335_/X sky130_fd_sc_hd__a21o_2
XPHY_EDGE_ROW_81_Left_164 VGND VGND VPWR VPWR sky130_fd_sc_hd__decap_3
X_5266_ _5316_/A _6292_/A VGND VGND VPWR VPWR _5341_/A sky130_fd_sc_hd__xnor2_2
X_4217_ _4217_/A _4217_/B _4217_/C VGND VGND VPWR VPWR _4217_/X sky130_fd_sc_hd__or3_2
X_5197_ _5188_/S _5169_/X _5190_/X _5196_/X VGND VGND VPWR VPWR _5197_/Y sky130_fd_sc_hd__o211ai_2
XFILLER_28_336 VGND VGND VPWR VPWR sky130_fd_sc_hd__decap_3
XFILLER_55_111 VGND VGND VPWR VPWR sky130_fd_sc_hd__fill_1
XFILLER_55_122 VGND VGND VPWR VPWR sky130_fd_sc_hd__fill_1
X_4148_ _5084_/S VGND VGND VPWR VPWR _4757_/S sky130_fd_sc_hd__clkbuf_2
XFILLER_43_306 VGND VGND VPWR VPWR sky130_fd_sc_hd__decap_3
XFILLER_55_144 VGND VGND VPWR VPWR sky130_fd_sc_hd__fill_2
XFILLER_55_155 VGND VGND VPWR VPWR sky130_fd_sc_hd__decap_3
X_4079_ _4086_/B _4086_/C _4086_/D VGND VGND VPWR VPWR _4079_/X sky130_fd_sc_hd__and3_2
XFILLER_55_199 VGND VGND VPWR VPWR sky130_fd_sc_hd__fill_2
XFILLER_36_391 VGND VGND VPWR VPWR sky130_fd_sc_hd__decap_3
XFILLER_51_361 VGND VGND VPWR VPWR sky130_fd_sc_hd__decap_3
XFILLER_51_383 VGND VGND VPWR VPWR sky130_fd_sc_hd__decap_3
XFILLER_11_225 VGND VGND VPWR VPWR sky130_fd_sc_hd__fill_1
XFILLER_1_3 VGND VGND VPWR VPWR sky130_fd_sc_hd__fill_1
XFILLER_3_446 VGND VGND VPWR VPWR sky130_fd_sc_hd__fill_2
XFILLER_59_54 VGND VGND VPWR VPWR sky130_fd_sc_hd__fill_2
XTAP_TAPCELL_ROW_49_618 VGND VPWR sky130_fd_sc_hd__tapvpwrvgnd_1
XPHY_EDGE_ROW_3_Left_86 VGND VGND VPWR VPWR sky130_fd_sc_hd__decap_3
XFILLER_19_325 VGND VGND VPWR VPWR sky130_fd_sc_hd__decap_3
XFILLER_75_42 VGND VGND VPWR VPWR sky130_fd_sc_hd__fill_1
XFILLER_34_306 VGND VGND VPWR VPWR sky130_fd_sc_hd__fill_2
XFILLER_46_144 VGND VGND VPWR VPWR sky130_fd_sc_hd__decap_3
XTAP_TAPCELL_ROW_57_695 VGND VPWR sky130_fd_sc_hd__tapvpwrvgnd_1
XFILLER_61_136 VGND VGND VPWR VPWR sky130_fd_sc_hd__fill_1
XTAP_TAPCELL_ROW_40_540 VGND VPWR sky130_fd_sc_hd__tapvpwrvgnd_1
XTAP_TAPCELL_ROW_12_286 VGND VPWR sky130_fd_sc_hd__tapvpwrvgnd_1
XFILLER_6_251 VGND VGND VPWR VPWR sky130_fd_sc_hd__fill_1
X_3450_ _3500_/S _3450_/B VGND VGND VPWR VPWR _3450_/X sky130_fd_sc_hd__and2_2
X_3381_ _3379_/X _3380_/X _3571_/S VGND VGND VPWR VPWR _3381_/X sky130_fd_sc_hd__mux2_2
X_5120_ _5297_/A _5120_/B _5120_/C _5120_/D VGND VGND VPWR VPWR _5572_/D sky130_fd_sc_hd__and4b_2
XFILLER_69_225 VGND VGND VPWR VPWR sky130_fd_sc_hd__decap_3
X_5051_ _5051_/A _5123_/B VGND VGND VPWR VPWR _5051_/Y sky130_fd_sc_hd__nand2_2
XFILLER_69_247 VGND VGND VPWR VPWR sky130_fd_sc_hd__decap_3
X_4002_ _3934_/X _3955_/X _4001_/Y _3917_/A _3956_/A VGND VGND VPWR VPWR _4003_/A
+ sky130_fd_sc_hd__a221o_2
XFILLER_37_122 VGND VGND VPWR VPWR sky130_fd_sc_hd__decap_3
XFILLER_18_380 VGND VGND VPWR VPWR sky130_fd_sc_hd__decap_3
XFILLER_25_328 VGND VGND VPWR VPWR sky130_fd_sc_hd__decap_3
XFILLER_52_136 VGND VGND VPWR VPWR sky130_fd_sc_hd__decap_3
XFILLER_52_147 VGND VGND VPWR VPWR sky130_fd_sc_hd__decap_3
X_5953_ _6476_/A _6423_/B VGND VGND VPWR VPWR _6491_/B sky130_fd_sc_hd__or2b_2
XFILLER_80_456 VGND VGND VPWR VPWR sky130_fd_sc_hd__fill_1
XFILLER_40_309 VGND VGND VPWR VPWR sky130_fd_sc_hd__decap_3
X_5884_ _5884_/A _5909_/A VGND VGND VPWR VPWR _5884_/Y sky130_fd_sc_hd__nor2_2
X_4904_ _4872_/A _4872_/B _4903_/X VGND VGND VPWR VPWR _4908_/A sky130_fd_sc_hd__a21oi_2
X_4835_ _5176_/S VGND VGND VPWR VPWR _5049_/S sky130_fd_sc_hd__clkbuf_1
X_4766_ _4818_/A _6071_/B VGND VGND VPWR VPWR _4910_/A sky130_fd_sc_hd__nand2b_2
X_3717_ _3638_/A _6015_/A _3716_/X VGND VGND VPWR VPWR _3717_/X sky130_fd_sc_hd__o21a_2
X_4697_ _4695_/A _6061_/B _4630_/B _6060_/D _4696_/X VGND VGND VPWR VPWR _4697_/X
+ sky130_fd_sc_hd__a221o_2
X_6436_ _5947_/S _6430_/X _6433_/X _6435_/X VGND VGND VPWR VPWR _6436_/X sky130_fd_sc_hd__o22a_2
X_3648_ _6460_/A2 _6447_/A3 input34/X _6450_/A3 _6450_/S0 _3648_/S1 VGND VGND VPWR
+ VPWR _3648_/X sky130_fd_sc_hd__mux4_2
X_6367_ _6365_/Y _6366_/Y _6319_/B VGND VGND VPWR VPWR _6367_/Y sky130_fd_sc_hd__o21ai_2
X_3579_ _6114_/A _3572_/X _3578_/X _3535_/A VGND VGND VPWR VPWR _3579_/X sky130_fd_sc_hd__o211a_2
X_5318_ _5318_/A _5318_/B _5318_/C VGND VGND VPWR VPWR _5319_/B sky130_fd_sc_hd__and3_2
X_6298_ _6298_/A _6306_/A _6298_/C VGND VGND VPWR VPWR _6299_/A sky130_fd_sc_hd__and3_2
X_5249_ _3880_/X _4929_/X _5248_/Y wire230/X VGND VGND VPWR VPWR _5249_/X sky130_fd_sc_hd__a211o_2
XTAP_TAPCELL_ROW_3_210 VGND VPWR sky130_fd_sc_hd__tapvpwrvgnd_1
XFILLER_28_122 VGND VGND VPWR VPWR sky130_fd_sc_hd__decap_3
XFILLER_75_228 VGND VGND VPWR VPWR sky130_fd_sc_hd__decap_3
XFILLER_28_144 VGND VGND VPWR VPWR sky130_fd_sc_hd__decap_3
XFILLER_28_155 VGND VGND VPWR VPWR sky130_fd_sc_hd__decap_3
XFILLER_56_486 VGND VGND VPWR VPWR sky130_fd_sc_hd__fill_1
XTAP_TAPCELL_ROW_82_930 VGND VPWR sky130_fd_sc_hd__tapvpwrvgnd_1
XFILLER_43_147 VGND VGND VPWR VPWR sky130_fd_sc_hd__decap_3
XFILLER_45_89 VGND VGND VPWR VPWR sky130_fd_sc_hd__decap_3
XTAP_TAPCELL_ROW_54_665 VGND VPWR sky130_fd_sc_hd__tapvpwrvgnd_1
XFILLER_24_383 VGND VGND VPWR VPWR sky130_fd_sc_hd__fill_2
XFILLER_66_239 VGND VGND VPWR VPWR sky130_fd_sc_hd__decap_3
XFILLER_34_125 VGND VGND VPWR VPWR sky130_fd_sc_hd__decap_3
XTAP_TAPCELL_ROW_17_334 VGND VPWR sky130_fd_sc_hd__tapvpwrvgnd_1
XFILLER_15_361 VGND VGND VPWR VPWR sky130_fd_sc_hd__decap_3
XFILLER_22_309 VGND VGND VPWR VPWR sky130_fd_sc_hd__decap_3
XFILLER_34_169 VGND VGND VPWR VPWR sky130_fd_sc_hd__decap_3
XFILLER_42_180 VGND VGND VPWR VPWR sky130_fd_sc_hd__decap_3
X_4620_ _4621_/B _4621_/C _4768_/A VGND VGND VPWR VPWR _4622_/A sky130_fd_sc_hd__a21oi_2
Xmax_cap202 _6495_/C VGND VGND VPWR VPWR _5763_/A sky130_fd_sc_hd__buf_1
X_4551_ _6457_/A1 _6457_/A3 _4429_/A _6461_/A2 _4675_/S0 _4675_/S1 VGND VGND VPWR
+ VPWR _4551_/X sky130_fd_sc_hd__mux4_2
Xmax_cap235 _4440_/X VGND VGND VPWR VPWR _4443_/A sky130_fd_sc_hd__buf_2
Xmax_cap224 _5168_/A VGND VGND VPWR VPWR _4728_/A1 sky130_fd_sc_hd__clkbuf_2
Xmax_cap213 _4987_/B VGND VGND VPWR VPWR _5477_/A sky130_fd_sc_hd__buf_2
X_4482_ _4544_/A _4482_/B VGND VGND VPWR VPWR _4482_/X sky130_fd_sc_hd__or2_2
X_3502_ _3633_/A _3500_/X _3501_/Y _3945_/A VGND VGND VPWR VPWR _4286_/B sky130_fd_sc_hd__a22oi_2
X_6221_ _6221_/A _6221_/B _6221_/C VGND VGND VPWR VPWR _6227_/A sky130_fd_sc_hd__or3_2
Xmax_cap268 _4797_/A VGND VGND VPWR VPWR _4370_/A sky130_fd_sc_hd__buf_4
Xmax_cap246 _4829_/X VGND VGND VPWR VPWR _5609_/A sky130_fd_sc_hd__buf_2
X_3433_ _3554_/A _3640_/A _3479_/A _4473_/A VGND VGND VPWR VPWR _3433_/X sky130_fd_sc_hd__o2bb2a_2
X_6152_ _6152_/A _6152_/B _6156_/B VGND VGND VPWR VPWR _6152_/Y sky130_fd_sc_hd__nor3_2
Xmax_cap279 _5422_/C VGND VGND VPWR VPWR _5374_/A sky130_fd_sc_hd__buf_2
X_5103_ wire227/X _3710_/B _5091_/X _5102_/Y VGND VGND VPWR VPWR _5103_/X sky130_fd_sc_hd__a31o_2
X_3364_ _4150_/A _3394_/B _3451_/S VGND VGND VPWR VPWR _3986_/S sky130_fd_sc_hd__or3_2
X_6083_ _5085_/A _5110_/B _6298_/C _6082_/Y VGND VGND VPWR VPWR _6083_/X sky130_fd_sc_hd__a31o_2
X_3295_ _3748_/A _3302_/A VGND VGND VPWR VPWR _3535_/A sky130_fd_sc_hd__nor2_2
XFILLER_57_206 VGND VGND VPWR VPWR sky130_fd_sc_hd__decap_3
X_5034_ _5033_/Y _5109_/A _5034_/S VGND VGND VPWR VPWR _5034_/X sky130_fd_sc_hd__mux2_2
XFILLER_57_239 VGND VGND VPWR VPWR sky130_fd_sc_hd__decap_3
XFILLER_65_261 VGND VGND VPWR VPWR sky130_fd_sc_hd__decap_3
XFILLER_13_309 VGND VGND VPWR VPWR sky130_fd_sc_hd__decap_3
XFILLER_25_169 VGND VGND VPWR VPWR sky130_fd_sc_hd__fill_1
XFILLER_40_106 VGND VGND VPWR VPWR sky130_fd_sc_hd__fill_1
X_5936_ _5935_/A _5942_/S _5935_/X VGND VGND VPWR VPWR _5936_/X sky130_fd_sc_hd__a21bo_2
XTAP_TAPCELL_ROW_51_635 VGND VPWR sky130_fd_sc_hd__tapvpwrvgnd_1
XFILLER_21_331 VGND VGND VPWR VPWR sky130_fd_sc_hd__decap_3
X_5867_ _5886_/A _5819_/Y _5818_/Y _5866_/Y VGND VGND VPWR VPWR _5867_/Y sky130_fd_sc_hd__a211oi_2
X_5798_ _5885_/A _5970_/B wire261/X _5847_/A _5797_/Y VGND VGND VPWR VPWR _5798_/X
+ sky130_fd_sc_hd__a221o_2
X_4818_ _4818_/A _6071_/B VGND VGND VPWR VPWR _4819_/B sky130_fd_sc_hd__or2_2
X_4749_ _5224_/A _4846_/A _4751_/A VGND VGND VPWR VPWR _4749_/X sky130_fd_sc_hd__mux2_2
X_6419_ _6419_/A _6419_/B _6419_/C VGND VGND VPWR VPWR _6419_/X sky130_fd_sc_hd__or3_2
XFILLER_0_279 VGND VGND VPWR VPWR sky130_fd_sc_hd__fill_1
Xinput103 operand_b[3] VGND VGND VPWR VPWR input103/X sky130_fd_sc_hd__clkdlybuf4s25_1
Xinput125 operand_b[5] VGND VGND VPWR VPWR input125/X sky130_fd_sc_hd__clkdlybuf4s25_1
Xinput114 operand_b[4] VGND VGND VPWR VPWR input114/X sky130_fd_sc_hd__clkdlybuf4s25_1
XTAP_TAPCELL_ROW_59_713 VGND VPWR sky130_fd_sc_hd__tapvpwrvgnd_1
XFILLER_56_283 VGND VGND VPWR VPWR sky130_fd_sc_hd__decap_3
XFILLER_56_88 VGND VGND VPWR VPWR sky130_fd_sc_hd__fill_1
XFILLER_16_158 VGND VGND VPWR VPWR sky130_fd_sc_hd__decap_3
XTAP_TAPCELL_ROW_14_304 VGND VPWR sky130_fd_sc_hd__tapvpwrvgnd_1
XFILLER_71_275 VGND VGND VPWR VPWR sky130_fd_sc_hd__decap_3
XFILLER_12_331 VGND VGND VPWR VPWR sky130_fd_sc_hd__fill_2
XFILLER_12_386 VGND VGND VPWR VPWR sky130_fd_sc_hd__fill_2
XFILLER_8_324 VGND VGND VPWR VPWR sky130_fd_sc_hd__decap_3
XTAP_TAPCELL_ROW_22_381 VGND VPWR sky130_fd_sc_hd__tapvpwrvgnd_1
XFILLER_8_368 VGND VGND VPWR VPWR sky130_fd_sc_hd__decap_3
XFILLER_67_515 VGND VGND VPWR VPWR sky130_fd_sc_hd__fill_1
XFILLER_39_228 VGND VGND VPWR VPWR sky130_fd_sc_hd__decap_3
XFILLER_47_261 VGND VGND VPWR VPWR sky130_fd_sc_hd__decap_3
XFILLER_50_404 VGND VGND VPWR VPWR sky130_fd_sc_hd__decap_3
X_3982_ _4019_/A _4156_/A _3982_/S VGND VGND VPWR VPWR _3982_/X sky130_fd_sc_hd__mux2_2
XFILLER_62_253 VGND VGND VPWR VPWR sky130_fd_sc_hd__decap_3
X_5721_ _5721_/A _5721_/B VGND VGND VPWR VPWR _5731_/A sky130_fd_sc_hd__or2_2
XFILLER_62_286 VGND VGND VPWR VPWR sky130_fd_sc_hd__decap_3
XFILLER_30_150 VGND VGND VPWR VPWR sky130_fd_sc_hd__decap_3
X_5652_ _5625_/A _5625_/B _6494_/B _6494_/C VGND VGND VPWR VPWR _5762_/B sky130_fd_sc_hd__and4bb_4
XFILLER_30_183 VGND VGND VPWR VPWR sky130_fd_sc_hd__decap_3
X_5583_ _5712_/B _5583_/B VGND VGND VPWR VPWR _5583_/X sky130_fd_sc_hd__xor2_2
X_4603_ _3780_/A _5732_/B _4422_/A VGND VGND VPWR VPWR _4603_/X sky130_fd_sc_hd__o21a_2
X_4534_ _4534_/A VGND VGND VPWR VPWR _4627_/C sky130_fd_sc_hd__buf_1
X_4465_ _3276_/X _3736_/X _4465_/S VGND VGND VPWR VPWR _4465_/X sky130_fd_sc_hd__mux2_2
X_6204_ _6199_/A _6202_/Y _6203_/Y VGND VGND VPWR VPWR _6204_/Y sky130_fd_sc_hd__a21oi_2
X_4396_ _4354_/S _4394_/A _4393_/B _6174_/A VGND VGND VPWR VPWR _4399_/C sky130_fd_sc_hd__a211o_2
X_3416_ _3515_/A _3515_/B _3417_/A VGND VGND VPWR VPWR _3620_/A sky130_fd_sc_hd__or3_2
X_6135_ _3716_/S _6134_/X _6089_/B VGND VGND VPWR VPWR _6135_/Y sky130_fd_sc_hd__a21oi_2
X_3347_ _3357_/B VGND VGND VPWR VPWR _3354_/S sky130_fd_sc_hd__inv_2
X_6066_ _6066_/A VGND VGND VPWR VPWR _6161_/B sky130_fd_sc_hd__clkbuf_1
XFILLER_45_209 VGND VGND VPWR VPWR sky130_fd_sc_hd__decap_3
X_5017_ _4757_/S _3592_/X _4885_/A _5013_/X VGND VGND VPWR VPWR _5023_/C sky130_fd_sc_hd__o211a_2
X_3278_ _4175_/A _6458_/A1 _4355_/A _6199_/C _3654_/S0 _3653_/S VGND VGND VPWR VPWR
+ _3278_/X sky130_fd_sc_hd__mux4_2
XFILLER_38_250 VGND VGND VPWR VPWR sky130_fd_sc_hd__fill_2
XFILLER_38_272 VGND VGND VPWR VPWR sky130_fd_sc_hd__decap_3
XTAP_TAPCELL_ROW_28_429 VGND VPWR sky130_fd_sc_hd__tapvpwrvgnd_1
XFILLER_26_467 VGND VGND VPWR VPWR sky130_fd_sc_hd__fill_2
XFILLER_13_139 VGND VGND VPWR VPWR sky130_fd_sc_hd__decap_3
X_5919_ _5938_/S _6410_/A VGND VGND VPWR VPWR _5957_/A sky130_fd_sc_hd__nand2_2
XFILLER_21_194 VGND VGND VPWR VPWR sky130_fd_sc_hd__decap_3
XFILLER_36_209 VGND VGND VPWR VPWR sky130_fd_sc_hd__decap_3
XFILLER_12_150 VGND VGND VPWR VPWR sky130_fd_sc_hd__decap_3
XFILLER_8_187 VGND VGND VPWR VPWR sky130_fd_sc_hd__fill_1
X_4250_ _4230_/A _6161_/A VGND VGND VPWR VPWR _4263_/A sky130_fd_sc_hd__and2b_2
X_4181_ _4181_/A _6170_/A VGND VGND VPWR VPWR _6213_/A sky130_fd_sc_hd__and2_2
XFILLER_67_367 VGND VGND VPWR VPWR sky130_fd_sc_hd__fill_1
XTAP_TAPCELL_ROW_78_885 VGND VPWR sky130_fd_sc_hd__tapvpwrvgnd_1
XFILLER_67_389 VGND VGND VPWR VPWR sky130_fd_sc_hd__decap_3
XFILLER_35_231 VGND VGND VPWR VPWR sky130_fd_sc_hd__decap_3
XFILLER_50_223 VGND VGND VPWR VPWR sky130_fd_sc_hd__decap_3
X_3965_ _3965_/A _6086_/A VGND VGND VPWR VPWR _6133_/B sky130_fd_sc_hd__nor2_2
XTAP_TAPCELL_ROW_61_730 VGND VPWR sky130_fd_sc_hd__tapvpwrvgnd_1
XFILLER_10_109 VGND VGND VPWR VPWR sky130_fd_sc_hd__fill_1
XFILLER_50_289 VGND VGND VPWR VPWR sky130_fd_sc_hd__fill_1
X_5704_ _5704_/A _5704_/B VGND VGND VPWR VPWR _5704_/Y sky130_fd_sc_hd__nor2_2
X_3896_ _3896_/A _3896_/B VGND VGND VPWR VPWR _3896_/Y sky130_fd_sc_hd__nand2_2
XTAP_TAPCELL_ROW_33_476 VGND VPWR sky130_fd_sc_hd__tapvpwrvgnd_1
X_5635_ _6346_/A _5635_/B _5635_/C VGND VGND VPWR VPWR _5635_/X sky130_fd_sc_hd__or3_2
X_5566_ _6346_/A _5566_/B VGND VGND VPWR VPWR _5567_/B sky130_fd_sc_hd__nor2_2
X_5497_ _5505_/A _5497_/B _5497_/C VGND VGND VPWR VPWR _5498_/B sky130_fd_sc_hd__and3_2
X_4517_ _4469_/A _6189_/B _4516_/X VGND VGND VPWR VPWR _4517_/Y sky130_fd_sc_hd__o21ai_2
X_4448_ _3744_/A _3744_/B _4447_/X VGND VGND VPWR VPWR _4454_/A sky130_fd_sc_hd__a21bo_2
Xfanout601 _3742_/B1 VGND VGND VPWR VPWR _6015_/A sky130_fd_sc_hd__clkdlybuf4s25_1
Xfanout634 input117/X VGND VGND VPWR VPWR _6344_/A sky130_fd_sc_hd__clkdlybuf4s25_1
Xfanout645 _5704_/A VGND VGND VPWR VPWR _4057_/A sky130_fd_sc_hd__clkdlybuf4s25_1
Xfanout667 _6467_/A1 VGND VGND VPWR VPWR _4044_/A sky130_fd_sc_hd__clkdlybuf4s25_1
X_4379_ _4016_/X _4378_/X _4379_/S VGND VGND VPWR VPWR _4380_/B sky130_fd_sc_hd__mux2_2
XFILLER_58_312 VGND VGND VPWR VPWR sky130_fd_sc_hd__decap_3
X_6118_ _6118_/A _6118_/B VGND VGND VPWR VPWR _6118_/Y sky130_fd_sc_hd__nor2_2
Xfanout678 _4061_/S1 VGND VGND VPWR VPWR _4507_/S sky130_fd_sc_hd__clkdlybuf4s25_1
Xfanout689 _5099_/A VGND VGND VPWR VPWR _6275_/B sky130_fd_sc_hd__clkdlybuf4s25_1
X_6049_ _6051_/A _6051_/B _6033_/B VGND VGND VPWR VPWR _6050_/C sky130_fd_sc_hd__a21bo_2
XFILLER_53_45 VGND VGND VPWR VPWR sky130_fd_sc_hd__fill_1
XFILLER_41_267 VGND VGND VPWR VPWR sky130_fd_sc_hd__decap_3
XFILLER_49_301 VGND VGND VPWR VPWR sky130_fd_sc_hd__decap_3
XFILLER_49_334 VGND VGND VPWR VPWR sky130_fd_sc_hd__fill_2
XFILLER_49_378 VGND VGND VPWR VPWR sky130_fd_sc_hd__decap_3
XFILLER_64_315 VGND VGND VPWR VPWR sky130_fd_sc_hd__fill_1
XTAP_TAPCELL_ROW_75_855 VGND VPWR sky130_fd_sc_hd__tapvpwrvgnd_1
XFILLER_32_212 VGND VGND VPWR VPWR sky130_fd_sc_hd__decap_3
XFILLER_32_256 VGND VGND VPWR VPWR sky130_fd_sc_hd__decap_3
XFILLER_32_267 VGND VGND VPWR VPWR sky130_fd_sc_hd__decap_3
X_3750_ _3750_/A _3750_/B VGND VGND VPWR VPWR _5138_/B sky130_fd_sc_hd__and2_2
XTAP_TAPCELL_ROW_30_446 VGND VPWR sky130_fd_sc_hd__tapvpwrvgnd_1
X_3681_ _3681_/A _3818_/A _3818_/B _3818_/C VGND VGND VPWR VPWR _3682_/A sky130_fd_sc_hd__or4_4
X_5420_ _5573_/B _5573_/C VGND VGND VPWR VPWR _5625_/A sky130_fd_sc_hd__nand2_2
XFILLER_64_3 VGND VGND VPWR VPWR sky130_fd_sc_hd__fill_2
X_5351_ _6319_/A VGND VGND VPWR VPWR _5416_/A sky130_fd_sc_hd__inv_2
X_5282_ _5132_/X _5281_/X _5662_/S VGND VGND VPWR VPWR _5282_/X sky130_fd_sc_hd__mux2_2
X_4302_ _4302_/A1 _4431_/A _4255_/Y VGND VGND VPWR VPWR _4357_/S sky130_fd_sc_hd__o21ba_2
X_4233_ _4233_/A _4800_/A VGND VGND VPWR VPWR _4235_/A sky130_fd_sc_hd__or2_2
XFILLER_59_109 VGND VGND VPWR VPWR sky130_fd_sc_hd__decap_3
XFILLER_4_83 VGND VGND VPWR VPWR sky130_fd_sc_hd__fill_1
X_4164_ _4207_/A _4152_/X _4163_/X VGND VGND VPWR VPWR _4164_/Y sky130_fd_sc_hd__a21oi_2
X_4095_ _4095_/A VGND VGND VPWR VPWR _6427_/A sky130_fd_sc_hd__clkbuf_2
XFILLER_55_337 VGND VGND VPWR VPWR sky130_fd_sc_hd__decap_3
XTAP_TAPCELL_ROW_38_524 VGND VPWR sky130_fd_sc_hd__tapvpwrvgnd_1
XFILLER_82_167 VGND VGND VPWR VPWR sky130_fd_sc_hd__fill_1
XFILLER_82_156 VGND VGND VPWR VPWR sky130_fd_sc_hd__fill_1
XTAP_TAPCELL_ROW_46_590 VGND VPWR sky130_fd_sc_hd__tapvpwrvgnd_1
XFILLER_23_26 VGND VGND VPWR VPWR sky130_fd_sc_hd__fill_1
X_4997_ _4997_/A _4997_/B _4997_/C _5108_/B VGND VGND VPWR VPWR _4999_/C sky130_fd_sc_hd__and4_2
X_3948_ _3273_/X _3506_/X _3526_/X _3505_/X _4025_/S0 _3948_/S1 VGND VGND VPWR VPWR
+ _3948_/X sky130_fd_sc_hd__mux4_2
X_3879_ _3712_/X _3878_/X _3942_/A VGND VGND VPWR VPWR _3879_/X sky130_fd_sc_hd__mux2_2
X_5618_ _5618_/A _5618_/B VGND VGND VPWR VPWR _5618_/Y sky130_fd_sc_hd__nand2_2
X_5549_ _5704_/A _4935_/X _5587_/A VGND VGND VPWR VPWR _5550_/B sky130_fd_sc_hd__a21oi_2
Xfanout420 wire423/X VGND VGND VPWR VPWR _5173_/S0 sky130_fd_sc_hd__clkdlybuf4s25_1
Xfanout453 _6120_/A VGND VGND VPWR VPWR _4086_/A sky130_fd_sc_hd__clkdlybuf4s25_1
Xfanout464 _6428_/A2 VGND VGND VPWR VPWR _5923_/A sky130_fd_sc_hd__clkdlybuf4s25_1
Xfanout475 _6431_/A0 VGND VGND VPWR VPWR _6050_/A sky130_fd_sc_hd__clkdlybuf4s25_1
XFILLER_46_304 VGND VGND VPWR VPWR sky130_fd_sc_hd__decap_3
XFILLER_46_315 VGND VGND VPWR VPWR sky130_fd_sc_hd__decap_3
Xfanout486 input53/X VGND VGND VPWR VPWR _6440_/A0 sky130_fd_sc_hd__clkdlybuf4s25_1
XFILLER_58_153 VGND VGND VPWR VPWR sky130_fd_sc_hd__decap_3
XFILLER_46_359 VGND VGND VPWR VPWR sky130_fd_sc_hd__decap_3
XTAP_TAPCELL_ROW_72_825 VGND VPWR sky130_fd_sc_hd__tapvpwrvgnd_1
XFILLER_61_329 VGND VGND VPWR VPWR sky130_fd_sc_hd__decap_3
XFILLER_10_484 VGND VGND VPWR VPWR sky130_fd_sc_hd__fill_2
XTAP_TAPCELL_ROW_9_260 VGND VPWR sky130_fd_sc_hd__tapvpwrvgnd_1
XFILLER_1_182 VGND VGND VPWR VPWR sky130_fd_sc_hd__fill_1
XFILLER_1_193 VGND VGND VPWR VPWR sky130_fd_sc_hd__fill_1
XFILLER_49_131 VGND VGND VPWR VPWR sky130_fd_sc_hd__decap_3
XFILLER_37_315 VGND VGND VPWR VPWR sky130_fd_sc_hd__decap_3
XFILLER_37_337 VGND VGND VPWR VPWR sky130_fd_sc_hd__decap_3
XFILLER_45_381 VGND VGND VPWR VPWR sky130_fd_sc_hd__decap_3
X_4920_ _5162_/A _4825_/B _4817_/A _4916_/C VGND VGND VPWR VPWR _4920_/X sky130_fd_sc_hd__a211o_2
X_4851_ _3366_/X _4841_/Y _5090_/B _4843_/Y _4850_/X VGND VGND VPWR VPWR _4851_/X
+ sky130_fd_sc_hd__o221a_2
X_3802_ _3750_/A _3798_/X _3799_/X _3801_/X VGND VGND VPWR VPWR _3802_/X sky130_fd_sc_hd__a31o_2
X_4782_ _4782_/A VGND VGND VPWR VPWR _5162_/A sky130_fd_sc_hd__buf_1
X_3733_ _3733_/A _3733_/B _3733_/C VGND VGND VPWR VPWR _3777_/D sky130_fd_sc_hd__nor3_2
X_6452_ _6448_/X _6451_/X _6463_/S VGND VGND VPWR VPWR _6452_/X sky130_fd_sc_hd__mux2_2
X_3664_ _3664_/A _6015_/A VGND VGND VPWR VPWR _3816_/A sky130_fd_sc_hd__or2b_2
X_5403_ _5466_/A _6339_/A VGND VGND VPWR VPWR _5467_/A sky130_fd_sc_hd__nand2_2
X_6383_ _6383_/A _6383_/B VGND VGND VPWR VPWR _6383_/Y sky130_fd_sc_hd__nand2_2
X_3595_ _3600_/B _3556_/A _3711_/S VGND VGND VPWR VPWR _3595_/X sky130_fd_sc_hd__mux2_2
X_5334_ _6363_/A _6319_/A VGND VGND VPWR VPWR _5422_/A sky130_fd_sc_hd__xor2_2
X_5265_ _5396_/A _5236_/Y _5250_/X _5264_/X VGND VGND VPWR VPWR _5984_/C sky130_fd_sc_hd__a211o_2
X_5196_ _5191_/A _5196_/A2 _5696_/A _5192_/X _5195_/Y VGND VGND VPWR VPWR _5196_/X
+ sky130_fd_sc_hd__a2111o_2
X_4216_ _4217_/A _4217_/C _4217_/B VGND VGND VPWR VPWR _4216_/Y sky130_fd_sc_hd__o21ai_2
X_4147_ _5010_/S VGND VGND VPWR VPWR _5084_/S sky130_fd_sc_hd__clkbuf_1
XFILLER_28_348 VGND VGND VPWR VPWR sky130_fd_sc_hd__decap_3
XFILLER_55_167 VGND VGND VPWR VPWR sky130_fd_sc_hd__fill_1
X_4078_ _4086_/C _4086_/D _4078_/C VGND VGND VPWR VPWR _4120_/A sky130_fd_sc_hd__and3_2
XFILLER_43_318 VGND VGND VPWR VPWR sky130_fd_sc_hd__decap_3
XFILLER_78_215 VGND VGND VPWR VPWR sky130_fd_sc_hd__decap_3
XFILLER_59_77 VGND VGND VPWR VPWR sky130_fd_sc_hd__fill_1
XTAP_TAPCELL_ROW_6_230 VGND VPWR sky130_fd_sc_hd__tapvpwrvgnd_1
XFILLER_78_259 VGND VGND VPWR VPWR sky130_fd_sc_hd__decap_3
XTAP_TAPCELL_ROW_49_619 VGND VPWR sky130_fd_sc_hd__tapvpwrvgnd_1
XFILLER_46_112 VGND VGND VPWR VPWR sky130_fd_sc_hd__decap_3
XFILLER_46_134 VGND VGND VPWR VPWR sky130_fd_sc_hd__decap_3
XFILLER_27_370 VGND VGND VPWR VPWR sky130_fd_sc_hd__decap_3
XFILLER_34_318 VGND VGND VPWR VPWR sky130_fd_sc_hd__decap_3
XFILLER_46_178 VGND VGND VPWR VPWR sky130_fd_sc_hd__decap_3
XTAP_TAPCELL_ROW_57_696 VGND VPWR sky130_fd_sc_hd__tapvpwrvgnd_1
XFILLER_42_351 VGND VGND VPWR VPWR sky130_fd_sc_hd__decap_3
XTAP_TAPCELL_ROW_40_541 VGND VPWR sky130_fd_sc_hd__tapvpwrvgnd_1
XTAP_TAPCELL_ROW_12_287 VGND VPWR sky130_fd_sc_hd__tapvpwrvgnd_1
XFILLER_10_292 VGND VGND VPWR VPWR sky130_fd_sc_hd__fill_1
X_3380_ _3464_/A _3556_/A _3548_/B _3600_/B _6100_/A _3711_/S VGND VGND VPWR VPWR
+ _3380_/X sky130_fd_sc_hd__mux4_2
Xload_slew623 _4295_/A1 VGND VGND VPWR VPWR _6116_/A sky130_fd_sc_hd__clkbuf_2
Xload_slew612 _5706_/A1 VGND VGND VPWR VPWR _5587_/A sky130_fd_sc_hd__buf_4
XFILLER_69_204 VGND VGND VPWR VPWR sky130_fd_sc_hd__decap_3
Xload_slew656 _3672_/B1 VGND VGND VPWR VPWR _6113_/A sky130_fd_sc_hd__clkbuf_4
X_5050_ _5050_/A _5050_/B VGND VGND VPWR VPWR _5061_/B sky130_fd_sc_hd__nand2_2
X_4001_ _4001_/A _4076_/B VGND VGND VPWR VPWR _4001_/Y sky130_fd_sc_hd__nor2_2
XFILLER_77_281 VGND VGND VPWR VPWR sky130_fd_sc_hd__decap_3
XFILLER_37_178 VGND VGND VPWR VPWR sky130_fd_sc_hd__decap_3
X_5952_ _6423_/B _6476_/A VGND VGND VPWR VPWR _6492_/B sky130_fd_sc_hd__or2b_2
XFILLER_52_159 VGND VGND VPWR VPWR sky130_fd_sc_hd__decap_3
X_4903_ _6053_/A _4975_/D VGND VGND VPWR VPWR _4903_/X sky130_fd_sc_hd__or2_2
XFILLER_33_340 VGND VGND VPWR VPWR sky130_fd_sc_hd__decap_3
X_5883_ _5883_/A VGND VGND VPWR VPWR _5909_/A sky130_fd_sc_hd__buf_1
XFILLER_33_384 VGND VGND VPWR VPWR sky130_fd_sc_hd__decap_3
X_4834_ _4505_/X _4833_/X _5175_/S VGND VGND VPWR VPWR _4834_/X sky130_fd_sc_hd__mux2_2
XFILLER_60_181 VGND VGND VPWR VPWR sky130_fd_sc_hd__decap_3
X_4765_ _6071_/B _4818_/A VGND VGND VPWR VPWR _4863_/A sky130_fd_sc_hd__or2b_2
X_3716_ _4156_/A _4019_/A _3716_/S VGND VGND VPWR VPWR _3716_/X sky130_fd_sc_hd__mux2_2
X_4696_ _6060_/D _4630_/B _6243_/A VGND VGND VPWR VPWR _4696_/X sky130_fd_sc_hd__o21a_2
X_6435_ _3394_/B input64/X _6473_/S _6434_/X _4674_/S VGND VGND VPWR VPWR _6435_/X
+ sky130_fd_sc_hd__o311a_2
X_3647_ _4462_/S _3647_/B VGND VGND VPWR VPWR _3647_/Y sky130_fd_sc_hd__nand2_2
X_6366_ _6363_/A _6365_/B _6285_/Y VGND VGND VPWR VPWR _6366_/Y sky130_fd_sc_hd__a21oi_2
X_3578_ _3578_/A _3578_/B VGND VGND VPWR VPWR _3578_/X sky130_fd_sc_hd__or2_2
X_5317_ _5286_/Y _5405_/B _5313_/Y _5314_/X _6296_/A VGND VGND VPWR VPWR _5318_/C
+ sky130_fd_sc_hd__o2111a_2
X_6297_ _6288_/X _6290_/X _6295_/X _6296_/X VGND VGND VPWR VPWR _6396_/A sky130_fd_sc_hd__a22o_2
X_5248_ _5245_/Y _5247_/X _5263_/A VGND VGND VPWR VPWR _5248_/Y sky130_fd_sc_hd__a21oi_2
XFILLER_75_207 VGND VGND VPWR VPWR sky130_fd_sc_hd__decap_3
XFILLER_28_101 VGND VGND VPWR VPWR sky130_fd_sc_hd__decap_3
X_5179_ _4941_/A _4940_/A _6391_/B VGND VGND VPWR VPWR _5179_/X sky130_fd_sc_hd__mux2_2
XFILLER_28_134 VGND VGND VPWR VPWR sky130_fd_sc_hd__decap_3
XTAP_TAPCELL_ROW_82_920 VGND VPWR sky130_fd_sc_hd__tapvpwrvgnd_1
XFILLER_43_159 VGND VGND VPWR VPWR sky130_fd_sc_hd__decap_3
XTAP_TAPCELL_ROW_54_666 VGND VPWR sky130_fd_sc_hd__tapvpwrvgnd_1
XFILLER_61_34 VGND VGND VPWR VPWR sky130_fd_sc_hd__fill_1
XFILLER_6_29 VGND VGND VPWR VPWR sky130_fd_sc_hd__fill_1
XFILLER_3_233 VGND VGND VPWR VPWR sky130_fd_sc_hd__decap_3
XFILLER_10_93 VGND VGND VPWR VPWR sky130_fd_sc_hd__fill_2
XFILLER_66_207 VGND VGND VPWR VPWR sky130_fd_sc_hd__decap_3
XFILLER_19_178 VGND VGND VPWR VPWR sky130_fd_sc_hd__decap_3
XFILLER_47_487 VGND VGND VPWR VPWR sky130_fd_sc_hd__decap_3
XFILLER_74_262 VGND VGND VPWR VPWR sky130_fd_sc_hd__decap_3
XFILLER_62_402 VGND VGND VPWR VPWR sky130_fd_sc_hd__decap_3
XFILLER_34_137 VGND VGND VPWR VPWR sky130_fd_sc_hd__decap_3
XTAP_TAPCELL_ROW_17_335 VGND VPWR sky130_fd_sc_hd__tapvpwrvgnd_1
XFILLER_74_295 VGND VGND VPWR VPWR sky130_fd_sc_hd__decap_3
XFILLER_30_332 VGND VGND VPWR VPWR sky130_fd_sc_hd__decap_3
XFILLER_30_365 VGND VGND VPWR VPWR sky130_fd_sc_hd__decap_3
XFILLER_30_398 VGND VGND VPWR VPWR sky130_fd_sc_hd__decap_3
X_4550_ _3830_/B _3836_/X _4757_/S VGND VGND VPWR VPWR _4550_/X sky130_fd_sc_hd__mux2_2
Xmax_cap225 _4312_/X VGND VGND VPWR VPWR _4526_/A sky130_fd_sc_hd__buf_2
Xmax_cap214 _4883_/X VGND VGND VPWR VPWR _5951_/A1 sky130_fd_sc_hd__clkbuf_2
Xmax_cap203 _5760_/Y VGND VGND VPWR VPWR _6495_/C sky130_fd_sc_hd__buf_1
X_4481_ _6189_/A VGND VGND VPWR VPWR _6185_/A sky130_fd_sc_hd__inv_2
X_3501_ _3559_/D _6100_/B VGND VGND VPWR VPWR _3501_/Y sky130_fd_sc_hd__nor2_2
X_6220_ _6196_/X _6211_/X _6219_/X _6198_/C VGND VGND VPWR VPWR _6239_/B sky130_fd_sc_hd__a22o_2
Xmax_cap269 _4800_/B VGND VGND VPWR VPWR _4207_/A sky130_fd_sc_hd__clkbuf_2
Xmax_cap258 _3370_/X VGND VGND VPWR VPWR _4168_/A sky130_fd_sc_hd__buf_2
X_3432_ _3432_/A _4019_/A VGND VGND VPWR VPWR _4473_/A sky130_fd_sc_hd__nand2_2
X_6151_ _6151_/A _6151_/B _6151_/C _6151_/D VGND VGND VPWR VPWR _6156_/B sky130_fd_sc_hd__and4_2
X_3363_ _4332_/A _3594_/B VGND VGND VPWR VPWR _3363_/Y sky130_fd_sc_hd__nand2_2
Xload_slew431 _3306_/C VGND VGND VPWR VPWR _3625_/A sky130_fd_sc_hd__clkbuf_4
X_5102_ _3714_/Y _4841_/Y _5094_/X _5095_/X _5101_/X VGND VGND VPWR VPWR _5102_/Y
+ sky130_fd_sc_hd__o221ai_2
X_6082_ _6275_/A _6264_/B _6080_/Y _6081_/X _5110_/B VGND VGND VPWR VPWR _6082_/Y
+ sky130_fd_sc_hd__a311oi_2
Xload_slew442 _3411_/A1 VGND VGND VPWR VPWR _3262_/A sky130_fd_sc_hd__buf_4
X_3294_ _4374_/A _3399_/B VGND VGND VPWR VPWR _3302_/A sky130_fd_sc_hd__nor2_2
XFILLER_38_421 VGND VGND VPWR VPWR sky130_fd_sc_hd__decap_3
X_5033_ _6270_/B _5030_/B _5109_/A VGND VGND VPWR VPWR _5033_/Y sky130_fd_sc_hd__a21oi_2
XFILLER_65_240 VGND VGND VPWR VPWR sky130_fd_sc_hd__decap_3
XFILLER_65_273 VGND VGND VPWR VPWR sky130_fd_sc_hd__decap_3
XFILLER_15_16 VGND VGND VPWR VPWR sky130_fd_sc_hd__fill_1
X_5935_ _5935_/A _5935_/B _5935_/C _5942_/S VGND VGND VPWR VPWR _5935_/X sky130_fd_sc_hd__or4_2
XFILLER_33_181 VGND VGND VPWR VPWR sky130_fd_sc_hd__decap_3
X_5866_ _5866_/A _6400_/A VGND VGND VPWR VPWR _5866_/Y sky130_fd_sc_hd__nor2_2
XTAP_TAPCELL_ROW_51_636 VGND VPWR sky130_fd_sc_hd__tapvpwrvgnd_1
X_4817_ _4817_/A _4916_/B VGND VGND VPWR VPWR _4975_/B sky130_fd_sc_hd__nand2_2
XFILLER_21_387 VGND VGND VPWR VPWR sky130_fd_sc_hd__decap_3
X_5797_ _5906_/A1 _5809_/B _5796_/X VGND VGND VPWR VPWR _5797_/Y sky130_fd_sc_hd__a21oi_2
X_4748_ _5178_/A _6244_/A VGND VGND VPWR VPWR _4748_/X sky130_fd_sc_hd__or2_2
X_4679_ _4679_/A _4679_/B _6243_/C VGND VGND VPWR VPWR _4679_/X sky130_fd_sc_hd__and3_2
X_6418_ _5866_/A _6407_/B _6417_/Y VGND VGND VPWR VPWR _6419_/C sky130_fd_sc_hd__a21oi_2
XPHY_EDGE_ROW_1_Right_1 VGND VGND VPWR VPWR sky130_fd_sc_hd__decap_3
X_6349_ _6349_/A _6349_/B VGND VGND VPWR VPWR _6349_/X sky130_fd_sc_hd__or2_2
Xinput104 operand_b[40] VGND VGND VPWR VPWR _5196_/A2 sky130_fd_sc_hd__clkdlybuf4s25_1
Xinput126 operand_b[60] VGND VGND VPWR VPWR _6419_/A sky130_fd_sc_hd__clkdlybuf4s25_1
Xinput115 operand_b[50] VGND VGND VPWR VPWR input115/X sky130_fd_sc_hd__clkdlybuf4s25_1
XTAP_TAPCELL_ROW_59_714 VGND VPWR sky130_fd_sc_hd__tapvpwrvgnd_1
XFILLER_44_402 VGND VGND VPWR VPWR sky130_fd_sc_hd__decap_3
XFILLER_56_251 VGND VGND VPWR VPWR sky130_fd_sc_hd__fill_1
XFILLER_44_424 VGND VGND VPWR VPWR sky130_fd_sc_hd__fill_2
XTAP_TAPCELL_ROW_67_780 VGND VPWR sky130_fd_sc_hd__tapvpwrvgnd_1
XFILLER_31_129 VGND VGND VPWR VPWR sky130_fd_sc_hd__fill_1
XTAP_TAPCELL_ROW_14_305 VGND VPWR sky130_fd_sc_hd__tapvpwrvgnd_1
XFILLER_12_365 VGND VGND VPWR VPWR sky130_fd_sc_hd__decap_3
XFILLER_21_92 VGND VGND VPWR VPWR sky130_fd_sc_hd__decap_3
XFILLER_39_207 VGND VGND VPWR VPWR sky130_fd_sc_hd__decap_3
XFILLER_47_240 VGND VGND VPWR VPWR sky130_fd_sc_hd__decap_3
XFILLER_35_402 VGND VGND VPWR VPWR sky130_fd_sc_hd__decap_3
XFILLER_47_284 VGND VGND VPWR VPWR sky130_fd_sc_hd__fill_1
X_3981_ _4241_/B VGND VGND VPWR VPWR _3981_/X sky130_fd_sc_hd__clkbuf_1
XFILLER_62_265 VGND VGND VPWR VPWR sky130_fd_sc_hd__decap_3
XFILLER_62_243 VGND VGND VPWR VPWR sky130_fd_sc_hd__decap_3
X_5720_ _5734_/S _5752_/B VGND VGND VPWR VPWR _5721_/B sky130_fd_sc_hd__and2_2
XFILLER_30_162 VGND VGND VPWR VPWR sky130_fd_sc_hd__decap_3
X_5651_ _5574_/A _6494_/C _6494_/B VGND VGND VPWR VPWR _5653_/A sky130_fd_sc_hd__a21oi_2
XFILLER_30_195 VGND VGND VPWR VPWR sky130_fd_sc_hd__fill_1
X_5582_ _5635_/B _5582_/B VGND VGND VPWR VPWR _5583_/B sky130_fd_sc_hd__nor2_2
X_4602_ _6233_/B _5099_/B _5352_/C _4614_/B _4601_/X VGND VGND VPWR VPWR _4602_/X
+ sky130_fd_sc_hd__a221o_2
X_4533_ _4614_/A _4533_/B VGND VGND VPWR VPWR _4534_/A sky130_fd_sc_hd__or2_2
X_6203_ _6173_/A _6217_/A _6173_/B VGND VGND VPWR VPWR _6203_/Y sky130_fd_sc_hd__a21oi_2
X_4464_ _5138_/A _4457_/Y _4463_/Y _4840_/B VGND VGND VPWR VPWR _4464_/X sky130_fd_sc_hd__a211o_2
X_4395_ _6176_/A _6174_/A _4354_/S _4394_/B _4394_/X VGND VGND VPWR VPWR _4399_/B
+ sky130_fd_sc_hd__o221a_2
X_3415_ _3563_/A _3667_/C _4094_/A _3413_/X _3486_/D VGND VGND VPWR VPWR _3415_/X
+ sky130_fd_sc_hd__a221o_2
X_6134_ _6098_/B _6090_/C _6015_/D _6015_/A VGND VGND VPWR VPWR _6134_/X sky130_fd_sc_hd__a31o_2
X_3346_ _3410_/B _3344_/X _3345_/X _3486_/C VGND VGND VPWR VPWR _3346_/Y sky130_fd_sc_hd__o211ai_2
X_6065_ _6151_/B _6151_/C _6085_/B _6065_/D VGND VGND VPWR VPWR _6066_/A sky130_fd_sc_hd__and4_2
X_5016_ _3598_/X _5010_/X _5012_/X _5015_/X VGND VGND VPWR VPWR _5023_/B sky130_fd_sc_hd__o211a_2
X_3277_ _4181_/A _4239_/A _6199_/B _6208_/A _3654_/S0 _3653_/S VGND VGND VPWR VPWR
+ _3800_/B sky130_fd_sc_hd__mux4_2
XFILLER_38_262 VGND VGND VPWR VPWR sky130_fd_sc_hd__fill_2
XFILLER_26_26 VGND VGND VPWR VPWR sky130_fd_sc_hd__fill_2
XFILLER_26_37 VGND VGND VPWR VPWR sky130_fd_sc_hd__decap_3
XFILLER_53_254 VGND VGND VPWR VPWR sky130_fd_sc_hd__decap_3
XFILLER_13_107 VGND VGND VPWR VPWR sky130_fd_sc_hd__decap_3
XFILLER_41_427 VGND VGND VPWR VPWR sky130_fd_sc_hd__decap_3
XFILLER_41_449 VGND VGND VPWR VPWR sky130_fd_sc_hd__decap_3
X_5918_ _5918_/A VGND VGND VPWR VPWR _5938_/S sky130_fd_sc_hd__inv_2
X_5849_ _6400_/B _5849_/B VGND VGND VPWR VPWR _5849_/Y sky130_fd_sc_hd__nand2_2
XFILLER_1_512 VGND VGND VPWR VPWR sky130_fd_sc_hd__decap_3
XFILLER_49_505 VGND VGND VPWR VPWR sky130_fd_sc_hd__decap_3
XFILLER_29_240 VGND VGND VPWR VPWR sky130_fd_sc_hd__decap_3
XFILLER_29_284 VGND VGND VPWR VPWR sky130_fd_sc_hd__fill_1
XFILLER_44_232 VGND VGND VPWR VPWR sky130_fd_sc_hd__decap_3
XFILLER_44_265 VGND VGND VPWR VPWR sky130_fd_sc_hd__decap_3
XFILLER_12_162 VGND VGND VPWR VPWR sky130_fd_sc_hd__decap_3
XFILLER_8_100 VGND VGND VPWR VPWR sky130_fd_sc_hd__fill_2
XFILLER_8_155 VGND VGND VPWR VPWR sky130_fd_sc_hd__fill_1
X_4180_ _4606_/A VGND VGND VPWR VPWR _5007_/A sky130_fd_sc_hd__clkbuf_1
XFILLER_67_346 VGND VGND VPWR VPWR sky130_fd_sc_hd__decap_3
XFILLER_35_210 VGND VGND VPWR VPWR sky130_fd_sc_hd__decap_3
XFILLER_35_243 VGND VGND VPWR VPWR sky130_fd_sc_hd__decap_3
XFILLER_35_287 VGND VGND VPWR VPWR sky130_fd_sc_hd__decap_3
XFILLER_50_202 VGND VGND VPWR VPWR sky130_fd_sc_hd__decap_3
XFILLER_50_235 VGND VGND VPWR VPWR sky130_fd_sc_hd__decap_3
X_3964_ _3965_/A _6086_/A _3917_/A _4076_/B VGND VGND VPWR VPWR _3967_/C sky130_fd_sc_hd__o211a_2
XTAP_TAPCELL_ROW_61_731 VGND VPWR sky130_fd_sc_hd__tapvpwrvgnd_1
X_5703_ _5237_/X _5379_/X _5546_/X _5702_/X _5616_/A _5548_/S VGND VGND VPWR VPWR
+ _5704_/B sky130_fd_sc_hd__mux4_2
X_3895_ _4025_/S0 _3895_/A2 _4800_/A VGND VGND VPWR VPWR _3895_/Y sky130_fd_sc_hd__o21ai_2
XTAP_TAPCELL_ROW_33_477 VGND VPWR sky130_fd_sc_hd__tapvpwrvgnd_1
X_5634_ _5688_/A1 _5579_/X _5633_/X _5580_/X VGND VGND VPWR VPWR _5639_/A sky130_fd_sc_hd__a211o_2
X_5565_ _5604_/A VGND VGND VPWR VPWR _5566_/B sky130_fd_sc_hd__inv_2
X_5496_ _5497_/B _5497_/C _5505_/A VGND VGND VPWR VPWR _5498_/A sky130_fd_sc_hd__a21oi_2
X_4516_ _4288_/X _4515_/X _4546_/A VGND VGND VPWR VPWR _4516_/X sky130_fd_sc_hd__mux2_2
X_4447_ _4447_/A _4447_/B _4447_/C _4447_/D VGND VGND VPWR VPWR _4447_/X sky130_fd_sc_hd__and4_2
Xfanout602 _3679_/B VGND VGND VPWR VPWR _6014_/B sky130_fd_sc_hd__clkdlybuf4s25_1
Xfanout613 _6474_/A VGND VGND VPWR VPWR wire614/A sky130_fd_sc_hd__clkdlybuf4s25_1
Xfanout624 _6417_/A VGND VGND VPWR VPWR _6400_/A sky130_fd_sc_hd__clkdlybuf4s25_1
X_6117_ _6090_/X _6116_/Y _6122_/A1 VGND VGND VPWR VPWR _6118_/B sky130_fd_sc_hd__o21a_2
Xfanout635 input117/X VGND VGND VPWR VPWR _5604_/A sky130_fd_sc_hd__clkdlybuf4s25_1
Xfanout657 _4027_/A VGND VGND VPWR VPWR _6013_/A sky130_fd_sc_hd__clkdlybuf4s25_1
X_4378_ _4190_/X _4377_/X _4721_/S VGND VGND VPWR VPWR _4378_/X sky130_fd_sc_hd__mux2_2
Xfanout668 input11/X VGND VGND VPWR VPWR _6467_/A1 sky130_fd_sc_hd__clkdlybuf4s25_1
X_3329_ _6467_/A1 _4175_/A _4014_/S VGND VGND VPWR VPWR _3329_/X sky130_fd_sc_hd__mux2_2
XFILLER_58_346 VGND VGND VPWR VPWR sky130_fd_sc_hd__decap_3
X_6048_ _6033_/B _6051_/B _6051_/A VGND VGND VPWR VPWR _6050_/B sky130_fd_sc_hd__nand3b_2
XFILLER_58_368 VGND VGND VPWR VPWR sky130_fd_sc_hd__decap_3
XFILLER_26_243 VGND VGND VPWR VPWR sky130_fd_sc_hd__decap_3
XFILLER_26_276 VGND VGND VPWR VPWR sky130_fd_sc_hd__decap_3
XFILLER_41_202 VGND VGND VPWR VPWR sky130_fd_sc_hd__decap_3
XFILLER_41_235 VGND VGND VPWR VPWR sky130_fd_sc_hd__decap_3
XFILLER_41_279 VGND VGND VPWR VPWR sky130_fd_sc_hd__fill_1
XFILLER_49_313 VGND VGND VPWR VPWR sky130_fd_sc_hd__decap_3
XFILLER_49_346 VGND VGND VPWR VPWR sky130_fd_sc_hd__decap_3
XTAP_TAPCELL_ROW_75_856 VGND VPWR sky130_fd_sc_hd__tapvpwrvgnd_1
XFILLER_72_360 VGND VGND VPWR VPWR sky130_fd_sc_hd__decap_3
X_3680_ _3479_/A _3479_/C _3679_/X VGND VGND VPWR VPWR _3818_/C sky130_fd_sc_hd__a21oi_2
XTAP_TAPCELL_ROW_30_447 VGND VPWR sky130_fd_sc_hd__tapvpwrvgnd_1
X_5350_ _4846_/A _5224_/A _5418_/C VGND VGND VPWR VPWR _5350_/X sky130_fd_sc_hd__mux2_2
X_5281_ _6449_/A0 _5338_/A3 _5225_/S _5281_/A3 wire423/A wire374/X VGND VGND VPWR
+ VPWR _5281_/X sky130_fd_sc_hd__mux4_2
X_4301_ _4301_/A _4301_/B VGND VGND VPWR VPWR _4355_/C sky130_fd_sc_hd__nor2_2
X_4232_ _4267_/B _4228_/Y _4231_/X VGND VGND VPWR VPWR _4232_/Y sky130_fd_sc_hd__o21ai_2
X_4163_ _5485_/A _4154_/Y _4155_/X _3976_/X _4162_/X VGND VGND VPWR VPWR _4163_/X
+ sky130_fd_sc_hd__a221o_2
XFILLER_55_316 VGND VGND VPWR VPWR sky130_fd_sc_hd__decap_3
X_4094_ _4094_/A VGND VGND VPWR VPWR _4118_/A sky130_fd_sc_hd__clkbuf_1
XFILLER_55_349 VGND VGND VPWR VPWR sky130_fd_sc_hd__fill_2
XTAP_TAPCELL_ROW_38_525 VGND VPWR sky130_fd_sc_hd__tapvpwrvgnd_1
XFILLER_82_113 VGND VGND VPWR VPWR sky130_fd_sc_hd__fill_1
XFILLER_23_213 VGND VGND VPWR VPWR sky130_fd_sc_hd__decap_3
XFILLER_63_371 VGND VGND VPWR VPWR sky130_fd_sc_hd__decap_3
X_4996_ _6270_/B _5108_/B _4994_/Y _6265_/A VGND VGND VPWR VPWR _4999_/B sky130_fd_sc_hd__o22ai_2
XTAP_TAPCELL_ROW_46_591 VGND VPWR sky130_fd_sc_hd__tapvpwrvgnd_1
XFILLER_23_268 VGND VGND VPWR VPWR sky130_fd_sc_hd__decap_3
XFILLER_23_279 VGND VGND VPWR VPWR sky130_fd_sc_hd__fill_1
X_3947_ _3947_/A _3947_/B _3947_/C VGND VGND VPWR VPWR _3947_/Y sky130_fd_sc_hd__nor3_2
X_3878_ _3841_/X _3877_/X _4221_/S VGND VGND VPWR VPWR _3878_/X sky130_fd_sc_hd__mux2_2
X_5617_ _5173_/X _5325_/X _5481_/X _5615_/X _5947_/S _5239_/X VGND VGND VPWR VPWR
+ _5618_/B sky130_fd_sc_hd__mux4_2
X_5548_ _5238_/X _5547_/X _5548_/S VGND VGND VPWR VPWR _5548_/X sky130_fd_sc_hd__mux2_2
X_5479_ _5939_/A _5474_/X _5475_/Y _5476_/X _5478_/Y VGND VGND VPWR VPWR _5479_/X
+ sky130_fd_sc_hd__o221a_2
Xfanout410 _6161_/A VGND VGND VPWR VPWR _6171_/A sky130_fd_sc_hd__clkdlybuf4s25_1
Xfanout432 input70/X VGND VGND VPWR VPWR _3706_/S sky130_fd_sc_hd__clkdlybuf4s25_1
Xfanout443 fanout444/X VGND VGND VPWR VPWR _6100_/A sky130_fd_sc_hd__clkdlybuf4s25_1
Xfanout454 _4057_/B VGND VGND VPWR VPWR _6476_/A sky130_fd_sc_hd__clkdlybuf4s25_1
Xfanout465 input62/X VGND VGND VPWR VPWR _6428_/A2 sky130_fd_sc_hd__clkdlybuf4s25_1
XFILLER_58_121 VGND VGND VPWR VPWR sky130_fd_sc_hd__decap_3
Xfanout476 input58/X VGND VGND VPWR VPWR _6431_/A0 sky130_fd_sc_hd__clkdlybuf4s25_1
Xfanout487 input52/X VGND VGND VPWR VPWR _5712_/A sky130_fd_sc_hd__clkdlybuf4s25_1
Xfanout498 wire500/A VGND VGND VPWR VPWR _3735_/A sky130_fd_sc_hd__clkdlybuf4s25_1
XFILLER_46_338 VGND VGND VPWR VPWR sky130_fd_sc_hd__decap_3
XFILLER_73_113 VGND VGND VPWR VPWR sky130_fd_sc_hd__fill_2
XFILLER_73_102 VGND VGND VPWR VPWR sky130_fd_sc_hd__fill_2
XFILLER_61_308 VGND VGND VPWR VPWR sky130_fd_sc_hd__decap_3
XFILLER_54_371 VGND VGND VPWR VPWR sky130_fd_sc_hd__fill_2
XTAP_TAPCELL_ROW_72_826 VGND VPWR sky130_fd_sc_hd__tapvpwrvgnd_1
XFILLER_14_246 VGND VGND VPWR VPWR sky130_fd_sc_hd__decap_3
XFILLER_10_430 VGND VGND VPWR VPWR sky130_fd_sc_hd__fill_2
XTAP_TAPCELL_ROW_9_261 VGND VPWR sky130_fd_sc_hd__tapvpwrvgnd_1
XFILLER_49_110 VGND VGND VPWR VPWR sky130_fd_sc_hd__fill_2
XFILLER_37_349 VGND VGND VPWR VPWR sky130_fd_sc_hd__decap_3
XFILLER_49_198 VGND VGND VPWR VPWR sky130_fd_sc_hd__decap_3
XFILLER_45_360 VGND VGND VPWR VPWR sky130_fd_sc_hd__decap_3
XFILLER_64_179 VGND VGND VPWR VPWR sky130_fd_sc_hd__decap_3
XFILLER_45_393 VGND VGND VPWR VPWR sky130_fd_sc_hd__decap_3
X_4850_ _5007_/A _4844_/X _4848_/Y _4849_/X _5061_/A VGND VGND VPWR VPWR _4850_/X
+ sky130_fd_sc_hd__o2111a_2
X_3801_ _3842_/S _3314_/X _3800_/X _4061_/S1 VGND VGND VPWR VPWR _3801_/X sky130_fd_sc_hd__o211a_2
X_4781_ _4751_/A _4751_/B _4780_/X VGND VGND VPWR VPWR _4782_/A sky130_fd_sc_hd__o21ai_2
X_3732_ _3777_/C _3693_/B _3731_/X VGND VGND VPWR VPWR _3732_/X sky130_fd_sc_hd__a21o_2
X_6451_ _6449_/X _6450_/X _6469_/S VGND VGND VPWR VPWR _6451_/X sky130_fd_sc_hd__mux2_2
X_3663_ _3716_/S _6015_/A VGND VGND VPWR VPWR _3728_/A sky130_fd_sc_hd__or2_2
XFILLER_9_272 VGND VGND VPWR VPWR sky130_fd_sc_hd__fill_1
X_6382_ _5256_/A _6381_/X _6391_/C VGND VGND VPWR VPWR _6382_/X sky130_fd_sc_hd__a21bo_2
X_5402_ _5466_/A _6339_/A VGND VGND VPWR VPWR _6322_/B sky130_fd_sc_hd__or2_2
X_5333_ _4883_/X _5319_/B _5319_/X _4526_/A _5332_/X VGND VGND VPWR VPWR _5981_/A
+ sky130_fd_sc_hd__a221o_2
X_3594_ _4332_/A _3594_/B VGND VGND VPWR VPWR _3594_/X sky130_fd_sc_hd__and2_2
X_5264_ _5260_/X _5261_/Y _5264_/S VGND VGND VPWR VPWR _5264_/X sky130_fd_sc_hd__mux2_2
X_5195_ _4776_/B _5193_/B _5274_/B _5194_/X VGND VGND VPWR VPWR _5195_/Y sky130_fd_sc_hd__o31ai_4
X_4215_ _4267_/B _4215_/B VGND VGND VPWR VPWR _4217_/B sky130_fd_sc_hd__xnor2_2
XFILLER_68_430 VGND VGND VPWR VPWR sky130_fd_sc_hd__fill_1
X_4146_ _4146_/A VGND VGND VPWR VPWR _4800_/B sky130_fd_sc_hd__clkbuf_1
XFILLER_55_113 VGND VGND VPWR VPWR sky130_fd_sc_hd__decap_3
X_4077_ _4077_/A _4077_/B _4077_/C VGND VGND VPWR VPWR _4078_/C sky130_fd_sc_hd__and3_2
XFILLER_36_360 VGND VGND VPWR VPWR sky130_fd_sc_hd__decap_3
XFILLER_36_382 VGND VGND VPWR VPWR sky130_fd_sc_hd__decap_3
XFILLER_63_190 VGND VGND VPWR VPWR sky130_fd_sc_hd__decap_3
XFILLER_51_374 VGND VGND VPWR VPWR sky130_fd_sc_hd__decap_3
X_4979_ _4939_/Y _4978_/X _4943_/S VGND VGND VPWR VPWR _4979_/X sky130_fd_sc_hd__a21o_2
XFILLER_3_426 VGND VGND VPWR VPWR sky130_fd_sc_hd__fill_2
XTAP_TAPCELL_ROW_6_231 VGND VPWR sky130_fd_sc_hd__tapvpwrvgnd_1
XFILLER_78_238 VGND VGND VPWR VPWR sky130_fd_sc_hd__decap_3
XFILLER_59_463 VGND VGND VPWR VPWR sky130_fd_sc_hd__fill_2
XFILLER_74_466 VGND VGND VPWR VPWR sky130_fd_sc_hd__fill_1
XFILLER_27_393 VGND VGND VPWR VPWR sky130_fd_sc_hd__decap_3
XFILLER_61_149 VGND VGND VPWR VPWR sky130_fd_sc_hd__decap_3
XFILLER_61_127 VGND VGND VPWR VPWR sky130_fd_sc_hd__decap_3
XFILLER_42_363 VGND VGND VPWR VPWR sky130_fd_sc_hd__fill_1
XTAP_TAPCELL_ROW_40_542 VGND VPWR sky130_fd_sc_hd__tapvpwrvgnd_1
XTAP_TAPCELL_ROW_12_288 VGND VPWR sky130_fd_sc_hd__tapvpwrvgnd_1
XFILLER_69_216 VGND VGND VPWR VPWR sky130_fd_sc_hd__decap_3
Xload_slew646 _4057_/A VGND VGND VPWR VPWR _5138_/A sky130_fd_sc_hd__clkbuf_4
Xload_slew679 _4507_/S VGND VGND VPWR VPWR _4025_/S0 sky130_fd_sc_hd__buf_4
X_4000_ _3925_/A _3925_/B _3925_/C _3999_/X VGND VGND VPWR VPWR _4004_/A sky130_fd_sc_hd__a31o_2
XFILLER_77_271 VGND VGND VPWR VPWR sky130_fd_sc_hd__fill_2
XFILLER_18_360 VGND VGND VPWR VPWR sky130_fd_sc_hd__decap_3
XFILLER_18_371 VGND VGND VPWR VPWR sky130_fd_sc_hd__fill_1
XFILLER_25_319 VGND VGND VPWR VPWR sky130_fd_sc_hd__decap_3
X_5951_ _5951_/A1 _5929_/Y _5930_/Y _5627_/A _5950_/X VGND VGND VPWR VPWR _6005_/B
+ sky130_fd_sc_hd__a221o_2
XFILLER_45_190 VGND VGND VPWR VPWR sky130_fd_sc_hd__decap_3
XFILLER_52_127 VGND VGND VPWR VPWR sky130_fd_sc_hd__decap_3
X_4902_ _4975_/D _4898_/Y _4901_/X VGND VGND VPWR VPWR _4902_/Y sky130_fd_sc_hd__o21ai_2
XFILLER_21_503 VGND VGND VPWR VPWR sky130_fd_sc_hd__fill_1
X_5882_ _6420_/A _6419_/B VGND VGND VPWR VPWR _5883_/A sky130_fd_sc_hd__or2_2
X_4833_ _4675_/X _4832_/X _5442_/S VGND VGND VPWR VPWR _4833_/X sky130_fd_sc_hd__mux2_2
X_4764_ _4124_/X _4736_/X _4745_/Y _5685_/A _4763_/X VGND VGND VPWR VPWR _5986_/C
+ sky130_fd_sc_hd__a221o_2
XFILLER_60_193 VGND VGND VPWR VPWR sky130_fd_sc_hd__decap_3
X_3715_ _3716_/S _6015_/A VGND VGND VPWR VPWR _4077_/A sky130_fd_sc_hd__nor2_2
X_6434_ _6472_/S _6434_/B VGND VGND VPWR VPWR _6434_/X sky130_fd_sc_hd__or2_2
X_4695_ _4695_/A _6061_/B VGND VGND VPWR VPWR _4698_/A sky130_fd_sc_hd__nor2_2
XFILLER_20_17 VGND VGND VPWR VPWR sky130_fd_sc_hd__decap_3
X_3646_ _3427_/B _3645_/X _3942_/A VGND VGND VPWR VPWR _3647_/B sky130_fd_sc_hd__mux2_2
X_6365_ _6365_/A _6365_/B VGND VGND VPWR VPWR _6365_/Y sky130_fd_sc_hd__nor2_2
X_3577_ _3573_/X _3574_/X _3575_/X _3576_/X _3559_/D _3698_/S VGND VGND VPWR VPWR
+ _3578_/B sky130_fd_sc_hd__mux4_2
X_6296_ _6296_/A _6293_/B VGND VGND VPWR VPWR _6296_/X sky130_fd_sc_hd__or2b_2
X_5316_ _5316_/A _6293_/A _5341_/B VGND VGND VPWR VPWR _6296_/A sky130_fd_sc_hd__or3_2
X_5247_ _5270_/A2 _4987_/B _5939_/A _5256_/A VGND VGND VPWR VPWR _5247_/X sky130_fd_sc_hd__o2bb2a_2
XFILLER_56_411 VGND VGND VPWR VPWR sky130_fd_sc_hd__decap_3
X_5178_ _5178_/A _5180_/A VGND VGND VPWR VPWR _5178_/Y sky130_fd_sc_hd__nor2_2
XFILLER_75_219 VGND VGND VPWR VPWR sky130_fd_sc_hd__decap_3
X_4129_ input77/X _4075_/B _4136_/A _4128_/X VGND VGND VPWR VPWR _4129_/Y sky130_fd_sc_hd__o211ai_2
XFILLER_43_105 VGND VGND VPWR VPWR sky130_fd_sc_hd__decap_3
XFILLER_43_116 VGND VGND VPWR VPWR sky130_fd_sc_hd__decap_3
XFILLER_56_477 VGND VGND VPWR VPWR sky130_fd_sc_hd__fill_2
XTAP_TAPCELL_ROW_82_921 VGND VPWR sky130_fd_sc_hd__tapvpwrvgnd_1
XFILLER_36_190 VGND VGND VPWR VPWR sky130_fd_sc_hd__decap_3
XTAP_TAPCELL_ROW_54_667 VGND VPWR sky130_fd_sc_hd__tapvpwrvgnd_1
XFILLER_24_374 VGND VGND VPWR VPWR sky130_fd_sc_hd__decap_3
XFILLER_24_396 VGND VGND VPWR VPWR sky130_fd_sc_hd__decap_3
XFILLER_51_193 VGND VGND VPWR VPWR sky130_fd_sc_hd__decap_3
XFILLER_79_503 VGND VGND VPWR VPWR sky130_fd_sc_hd__fill_1
XFILLER_10_83 VGND VGND VPWR VPWR sky130_fd_sc_hd__fill_1
XFILLER_19_102 VGND VGND VPWR VPWR sky130_fd_sc_hd__decap_3
XFILLER_19_113 VGND VGND VPWR VPWR sky130_fd_sc_hd__decap_3
XFILLER_34_116 VGND VGND VPWR VPWR sky130_fd_sc_hd__decap_3
XTAP_TAPCELL_ROW_17_336 VGND VPWR sky130_fd_sc_hd__tapvpwrvgnd_1
XFILLER_74_285 VGND VGND VPWR VPWR sky130_fd_sc_hd__decap_3
XFILLER_15_396 VGND VGND VPWR VPWR sky130_fd_sc_hd__decap_3
XFILLER_35_91 VGND VGND VPWR VPWR sky130_fd_sc_hd__fill_2
XFILLER_42_171 VGND VGND VPWR VPWR sky130_fd_sc_hd__decap_3
XFILLER_30_344 VGND VGND VPWR VPWR sky130_fd_sc_hd__fill_2
X_3500_ _3222_/X _3499_/X _3500_/S VGND VGND VPWR VPWR _3500_/X sky130_fd_sc_hd__mux2_2
Xmax_cap226 _5137_/A VGND VGND VPWR VPWR _5176_/S sky130_fd_sc_hd__buf_2
Xmax_cap215 _5049_/S VGND VGND VPWR VPWR _4879_/S sky130_fd_sc_hd__buf_2
X_4480_ _4480_/A VGND VGND VPWR VPWR _5996_/C sky130_fd_sc_hd__buf_1
Xmax_cap259 _5322_/A VGND VGND VPWR VPWR _5405_/B sky130_fd_sc_hd__buf_2
Xmax_cap237 _4191_/X VGND VGND VPWR VPWR _4721_/S sky130_fd_sc_hd__buf_2
X_3431_ _3571_/S _3464_/A VGND VGND VPWR VPWR _3479_/A sky130_fd_sc_hd__nand2_2
X_6150_ _6155_/C _6155_/B _3982_/S VGND VGND VPWR VPWR _6150_/X sky130_fd_sc_hd__a21o_2
X_3362_ _5732_/A _4057_/A VGND VGND VPWR VPWR _3594_/B sky130_fd_sc_hd__nor2_2
Xload_slew421 _5173_/S0 VGND VGND VPWR VPWR _5008_/S0 sky130_fd_sc_hd__buf_4
X_5101_ _5263_/A _5100_/X _4801_/A VGND VGND VPWR VPWR _5101_/X sky130_fd_sc_hd__o21a_2
X_6081_ _6274_/A _6298_/C _5057_/S VGND VGND VPWR VPWR _6081_/X sky130_fd_sc_hd__o21a_2
X_3293_ _3293_/A VGND VGND VPWR VPWR _3399_/B sky130_fd_sc_hd__clkbuf_1
X_5032_ _4997_/B _4997_/C _5034_/S _5109_/A _5108_/A VGND VGND VPWR VPWR _5032_/Y
+ sky130_fd_sc_hd__a2111oi_2
XPHY_EDGE_ROW_69_Left_152 VGND VGND VPWR VPWR sky130_fd_sc_hd__decap_3
XFILLER_65_252 VGND VGND VPWR VPWR sky130_fd_sc_hd__fill_2
XFILLER_25_116 VGND VGND VPWR VPWR sky130_fd_sc_hd__fill_1
XFILLER_53_425 VGND VGND VPWR VPWR sky130_fd_sc_hd__decap_3
X_5934_ _5934_/A VGND VGND VPWR VPWR _5934_/Y sky130_fd_sc_hd__inv_2
XFILLER_80_244 VGND VGND VPWR VPWR sky130_fd_sc_hd__decap_3
XFILLER_40_119 VGND VGND VPWR VPWR sky130_fd_sc_hd__decap_3
X_5865_ _4642_/B _4885_/X _5858_/X _5859_/Y _5864_/Y VGND VGND VPWR VPWR _5865_/X
+ sky130_fd_sc_hd__a221o_2
XTAP_TAPCELL_ROW_51_637 VGND VPWR sky130_fd_sc_hd__tapvpwrvgnd_1
XFILLER_21_322 VGND VGND VPWR VPWR sky130_fd_sc_hd__decap_3
X_4816_ _4923_/B _4821_/A VGND VGND VPWR VPWR _4916_/B sky130_fd_sc_hd__or2_2
X_5796_ wire282/X wire281/X _5886_/A VGND VGND VPWR VPWR _5796_/X sky130_fd_sc_hd__mux2_2
XFILLER_21_399 VGND VGND VPWR VPWR sky130_fd_sc_hd__decap_3
X_4747_ _4196_/B _6474_/B _4800_/B VGND VGND VPWR VPWR _4747_/X sky130_fd_sc_hd__a21o_2
XPHY_EDGE_ROW_78_Left_161 VGND VGND VPWR VPWR sky130_fd_sc_hd__decap_3
X_4678_ _3979_/X _4677_/X _4757_/S VGND VGND VPWR VPWR _4678_/X sky130_fd_sc_hd__mux2_2
X_6417_ _6417_/A _6417_/B VGND VGND VPWR VPWR _6417_/Y sky130_fd_sc_hd__nor2_2
X_3629_ _3592_/S _3628_/X _3626_/X VGND VGND VPWR VPWR _3629_/X sky130_fd_sc_hd__a21o_2
X_6348_ _6374_/B _6374_/D _6374_/C VGND VGND VPWR VPWR _6349_/B sky130_fd_sc_hd__a21oi_2
X_6279_ _6275_/B _6275_/C _6278_/Y VGND VGND VPWR VPWR _6279_/Y sky130_fd_sc_hd__a21oi_2
Xinput127 operand_b[61] VGND VGND VPWR VPWR _5932_/B sky130_fd_sc_hd__buf_1
Xinput116 operand_b[51] VGND VGND VPWR VPWR input116/X sky130_fd_sc_hd__clkdlybuf4s25_1
Xinput105 operand_b[41] VGND VGND VPWR VPWR _5180_/A sky130_fd_sc_hd__clkdlybuf4s25_1
XFILLER_56_230 VGND VGND VPWR VPWR sky130_fd_sc_hd__decap_3
XFILLER_44_414 VGND VGND VPWR VPWR sky130_fd_sc_hd__decap_3
XTAP_TAPCELL_ROW_67_781 VGND VPWR sky130_fd_sc_hd__tapvpwrvgnd_1
XFILLER_71_222 VGND VGND VPWR VPWR sky130_fd_sc_hd__fill_2
XFILLER_71_244 VGND VGND VPWR VPWR sky130_fd_sc_hd__decap_3
XTAP_TAPCELL_ROW_14_306 VGND VPWR sky130_fd_sc_hd__tapvpwrvgnd_1
XFILLER_79_333 VGND VGND VPWR VPWR sky130_fd_sc_hd__decap_3
XFILLER_47_252 VGND VGND VPWR VPWR sky130_fd_sc_hd__decap_3
X_3980_ _3581_/X _3583_/X _3625_/B _3587_/X _4674_/S _3592_/S VGND VGND VPWR VPWR
+ _3980_/X sky130_fd_sc_hd__mux4_2
XFILLER_50_439 VGND VGND VPWR VPWR sky130_fd_sc_hd__fill_2
XFILLER_62_277 VGND VGND VPWR VPWR sky130_fd_sc_hd__decap_3
X_5650_ _5712_/D _5650_/B VGND VGND VPWR VPWR _6494_/B sky130_fd_sc_hd__xnor2_2
XFILLER_30_141 VGND VGND VPWR VPWR sky130_fd_sc_hd__decap_3
X_4601_ _4469_/A _6233_/B _4600_/X VGND VGND VPWR VPWR _4601_/X sky130_fd_sc_hd__o21a_2
XFILLER_30_174 VGND VGND VPWR VPWR sky130_fd_sc_hd__decap_3
X_5581_ _5688_/A1 _5579_/X _5580_/X VGND VGND VPWR VPWR _5582_/B sky130_fd_sc_hd__a21o_2
X_4532_ _6193_/S _6233_/A VGND VGND VPWR VPWR _4533_/B sky130_fd_sc_hd__and2b_2
Xwire290 _3620_/X VGND VGND VPWR VPWR _4606_/A sky130_fd_sc_hd__clkbuf_4
X_4463_ _5138_/A _4463_/B VGND VGND VPWR VPWR _4463_/Y sky130_fd_sc_hd__nor2_2
X_6202_ _6173_/A _6217_/A _6173_/B VGND VGND VPWR VPWR _6202_/Y sky130_fd_sc_hd__o21ai_2
X_3414_ _6098_/A _3464_/A VGND VGND VPWR VPWR _3486_/D sky130_fd_sc_hd__xor2_2
X_4394_ _4394_/A _4394_/B VGND VGND VPWR VPWR _4394_/X sky130_fd_sc_hd__or2_2
XPHY_EDGE_ROW_15_Right_15 VGND VGND VPWR VPWR sky130_fd_sc_hd__decap_3
X_6133_ _6133_/A _6133_/B VGND VGND VPWR VPWR _6133_/Y sky130_fd_sc_hd__xnor2_2
X_3345_ _3410_/B _3344_/X _3262_/A VGND VGND VPWR VPWR _3345_/X sky130_fd_sc_hd__a21o_2
X_6064_ _6162_/A _6164_/A _6170_/A _6156_/A VGND VGND VPWR VPWR _6065_/D sky130_fd_sc_hd__and4_2
X_3276_ _3273_/X _3274_/X _3529_/S VGND VGND VPWR VPWR _3276_/X sky130_fd_sc_hd__mux2_2
X_5015_ _5013_/X _5014_/Y _5906_/A1 VGND VGND VPWR VPWR _5015_/X sky130_fd_sc_hd__a21o_2
XFILLER_26_403 VGND VGND VPWR VPWR sky130_fd_sc_hd__fill_2
XFILLER_38_241 VGND VGND VPWR VPWR sky130_fd_sc_hd__decap_3
XFILLER_53_233 VGND VGND VPWR VPWR sky130_fd_sc_hd__fill_2
XFILLER_53_266 VGND VGND VPWR VPWR sky130_fd_sc_hd__decap_3
XTAP_TAPCELL_ROW_64_751 VGND VPWR sky130_fd_sc_hd__tapvpwrvgnd_1
XPHY_EDGE_ROW_24_Right_24 VGND VGND VPWR VPWR sky130_fd_sc_hd__decap_3
XFILLER_53_277 VGND VGND VPWR VPWR sky130_fd_sc_hd__decap_3
X_5917_ _5918_/A _5917_/B VGND VGND VPWR VPWR _6479_/B sky130_fd_sc_hd__nand2_2
X_5848_ _5849_/B _5847_/Y _5869_/A VGND VGND VPWR VPWR _5851_/A sky130_fd_sc_hd__a21bo_2
XFILLER_21_185 VGND VGND VPWR VPWR sky130_fd_sc_hd__decap_3
X_5779_ _5886_/A _5885_/A VGND VGND VPWR VPWR _5847_/A sky130_fd_sc_hd__nor2_2
XPHY_EDGE_ROW_33_Right_33 VGND VGND VPWR VPWR sky130_fd_sc_hd__decap_3
XFILLER_76_325 VGND VGND VPWR VPWR sky130_fd_sc_hd__fill_2
XFILLER_67_45 VGND VGND VPWR VPWR sky130_fd_sc_hd__fill_2
XFILLER_29_274 VGND VGND VPWR VPWR sky130_fd_sc_hd__decap_3
XFILLER_44_200 VGND VGND VPWR VPWR sky130_fd_sc_hd__decap_3
XPHY_EDGE_ROW_42_Right_42 VGND VGND VPWR VPWR sky130_fd_sc_hd__decap_3
XFILLER_44_244 VGND VGND VPWR VPWR sky130_fd_sc_hd__decap_3
XTAP_TAPCELL_ROW_27_420 VGND VPWR sky130_fd_sc_hd__tapvpwrvgnd_1
XFILLER_16_71 VGND VGND VPWR VPWR sky130_fd_sc_hd__decap_3
XFILLER_32_439 VGND VGND VPWR VPWR sky130_fd_sc_hd__decap_3
XFILLER_44_277 VGND VGND VPWR VPWR sky130_fd_sc_hd__decap_3
XPHY_EDGE_ROW_51_Right_51 VGND VGND VPWR VPWR sky130_fd_sc_hd__decap_3
XFILLER_4_340 VGND VGND VPWR VPWR sky130_fd_sc_hd__decap_3
XFILLER_67_358 VGND VGND VPWR VPWR sky130_fd_sc_hd__decap_3
XPHY_EDGE_ROW_60_Right_60 VGND VGND VPWR VPWR sky130_fd_sc_hd__decap_3
XFILLER_35_222 VGND VGND VPWR VPWR sky130_fd_sc_hd__fill_2
XFILLER_35_266 VGND VGND VPWR VPWR sky130_fd_sc_hd__decap_3
XFILLER_50_214 VGND VGND VPWR VPWR sky130_fd_sc_hd__decap_3
XFILLER_50_247 VGND VGND VPWR VPWR sky130_fd_sc_hd__decap_3
X_3963_ _3982_/S _6152_/A VGND VGND VPWR VPWR _4076_/B sky130_fd_sc_hd__xor2_2
XTAP_TAPCELL_ROW_61_732 VGND VPWR sky130_fd_sc_hd__tapvpwrvgnd_1
X_5702_ _6349_/A _5658_/A _5637_/A _6440_/A0 _5764_/S0 _5801_/S1 VGND VGND VPWR VPWR
+ _5702_/X sky130_fd_sc_hd__mux4_2
X_3894_ _3594_/X _3880_/X _3884_/X _3888_/X _3893_/Y VGND VGND VPWR VPWR _3894_/X
+ sky130_fd_sc_hd__a2111o_2
XTAP_TAPCELL_ROW_33_478 VGND VPWR sky130_fd_sc_hd__tapvpwrvgnd_1
X_5633_ _6344_/A _5635_/B _5635_/C VGND VGND VPWR VPWR _5633_/X sky130_fd_sc_hd__or3_2
X_5564_ _5591_/S _6344_/A VGND VGND VPWR VPWR _5647_/A sky130_fd_sc_hd__nor2_2
X_4515_ _4515_/A VGND VGND VPWR VPWR _4515_/X sky130_fd_sc_hd__clkbuf_1
X_5495_ _6317_/S _5530_/A VGND VGND VPWR VPWR _5505_/A sky130_fd_sc_hd__xor2_2
X_4446_ _4268_/B _4449_/A _4449_/B _4449_/C VGND VGND VPWR VPWR _4447_/D sky130_fd_sc_hd__and4b_2
Xfanout603 _4175_/A VGND VGND VPWR VPWR _6167_/A sky130_fd_sc_hd__clkdlybuf4s25_1
X_4377_ _4328_/X _4376_/X _4460_/S VGND VGND VPWR VPWR _4377_/X sky130_fd_sc_hd__mux2_2
X_6116_ _6116_/A _6121_/S VGND VGND VPWR VPWR _6116_/Y sky130_fd_sc_hd__nor2_2
Xfanout636 input116/X VGND VGND VPWR VPWR _6333_/A sky130_fd_sc_hd__clkdlybuf4s25_1
Xfanout647 _5704_/A VGND VGND VPWR VPWR _4234_/C1 sky130_fd_sc_hd__clkdlybuf4s25_1
X_3328_ _3283_/X _3327_/X _3800_/A VGND VGND VPWR VPWR _3798_/B sky130_fd_sc_hd__mux2_2
XFILLER_58_303 VGND VGND VPWR VPWR sky130_fd_sc_hd__decap_3
Xfanout669 _5406_/B1 VGND VGND VPWR VPWR _6359_/A sky130_fd_sc_hd__clkdlybuf4s25_1
X_6047_ _5932_/A _6039_/X _6043_/X _6046_/X VGND VGND VPWR VPWR _6047_/X sky130_fd_sc_hd__a211o_2
X_3259_ _3735_/A _3361_/C _3349_/A VGND VGND VPWR VPWR _3259_/X sky130_fd_sc_hd__mux2_2
XFILLER_26_200 VGND VGND VPWR VPWR sky130_fd_sc_hd__fill_2
XFILLER_26_288 VGND VGND VPWR VPWR sky130_fd_sc_hd__fill_2
XFILLER_41_214 VGND VGND VPWR VPWR sky130_fd_sc_hd__decap_3
XFILLER_41_258 VGND VGND VPWR VPWR sky130_fd_sc_hd__decap_3
XFILLER_1_332 VGND VGND VPWR VPWR sky130_fd_sc_hd__decap_3
XFILLER_49_325 VGND VGND VPWR VPWR sky130_fd_sc_hd__decap_3
XFILLER_49_369 VGND VGND VPWR VPWR sky130_fd_sc_hd__decap_3
XTAP_TAPCELL_ROW_75_857 VGND VPWR sky130_fd_sc_hd__tapvpwrvgnd_1
XFILLER_17_277 VGND VGND VPWR VPWR sky130_fd_sc_hd__decap_3
XFILLER_32_203 VGND VGND VPWR VPWR sky130_fd_sc_hd__decap_3
XFILLER_32_247 VGND VGND VPWR VPWR sky130_fd_sc_hd__decap_3
XTAP_TAPCELL_ROW_30_448 VGND VPWR sky130_fd_sc_hd__tapvpwrvgnd_1
XFILLER_71_6 VGND VGND VPWR VPWR sky130_fd_sc_hd__fill_1
X_5280_ _5341_/A _5280_/B VGND VGND VPWR VPWR _5299_/A sky130_fd_sc_hd__xnor2_2
X_4300_ _6199_/B _6021_/D VGND VGND VPWR VPWR _4301_/B sky130_fd_sc_hd__nor2b_2
X_4231_ _4263_/C _4231_/B _4230_/X VGND VGND VPWR VPWR _4231_/X sky130_fd_sc_hd__or3b_2
X_4162_ input77/X _3993_/A _4072_/X _4183_/B _4161_/Y VGND VGND VPWR VPWR _4162_/X
+ sky130_fd_sc_hd__a41o_2
X_4093_ _4093_/A _4743_/A VGND VGND VPWR VPWR _4093_/Y sky130_fd_sc_hd__xnor2_2
XFILLER_48_391 VGND VGND VPWR VPWR sky130_fd_sc_hd__fill_1
XFILLER_82_169 VGND VGND VPWR VPWR sky130_fd_sc_hd__fill_1
XFILLER_23_225 VGND VGND VPWR VPWR sky130_fd_sc_hd__decap_3
XFILLER_23_247 VGND VGND VPWR VPWR sky130_fd_sc_hd__fill_2
X_4995_ _4994_/Y _4997_/B _4997_/C VGND VGND VPWR VPWR _4999_/A sky130_fd_sc_hd__and3b_2
XTAP_TAPCELL_ROW_46_592 VGND VPWR sky130_fd_sc_hd__tapvpwrvgnd_1
XFILLER_63_383 VGND VGND VPWR VPWR sky130_fd_sc_hd__fill_1
X_3946_ _3704_/A _3895_/Y _3945_/Y _4636_/S VGND VGND VPWR VPWR _3947_/C sky130_fd_sc_hd__o211a_2
X_3877_ _3908_/A _3812_/A _4014_/S VGND VGND VPWR VPWR _3877_/X sky130_fd_sc_hd__mux2_2
X_5616_ _5616_/A VGND VGND VPWR VPWR _5947_/S sky130_fd_sc_hd__clkbuf_2
X_5547_ _5379_/X _5546_/X _5616_/A VGND VGND VPWR VPWR _5547_/X sky130_fd_sc_hd__mux2_2
X_5478_ _6322_/A _5478_/B VGND VGND VPWR VPWR _5478_/Y sky130_fd_sc_hd__nand2_2
X_4429_ _4429_/A _4513_/A VGND VGND VPWR VPWR _4627_/A sky130_fd_sc_hd__xor2_2
Xfanout400 _3520_/S VGND VGND VPWR VPWR _3348_/A sky130_fd_sc_hd__clkdlybuf4s25_1
Xfanout411 input78/X VGND VGND VPWR VPWR _6170_/A sky130_fd_sc_hd__clkdlybuf4s25_1
Xfanout422 _3503_/S0 VGND VGND VPWR VPWR wire423/A sky130_fd_sc_hd__clkdlybuf4s25_1
XFILLER_48_36 VGND VGND VPWR VPWR sky130_fd_sc_hd__fill_2
Xfanout433 _4026_/S1 VGND VGND VPWR VPWR _3881_/S1 sky130_fd_sc_hd__clkdlybuf4s25_1
Xfanout444 input70/X VGND VGND VPWR VPWR fanout444/X sky130_fd_sc_hd__clkdlybuf4s25_1
Xfanout455 _5590_/A1 VGND VGND VPWR VPWR _4422_/A sky130_fd_sc_hd__clkdlybuf4s25_1
Xfanout466 _3612_/A VGND VGND VPWR VPWR _3600_/B sky130_fd_sc_hd__clkdlybuf4s25_1
Xfanout477 _6428_/A0 VGND VGND VPWR VPWR _5752_/A sky130_fd_sc_hd__clkdlybuf4s25_1
Xfanout488 input52/X VGND VGND VPWR VPWR _6439_/A2 sky130_fd_sc_hd__clkdlybuf4s25_1
Xfanout499 _3872_/A VGND VGND VPWR VPWR wire500/A sky130_fd_sc_hd__clkdlybuf4s25_1
XFILLER_58_144 VGND VGND VPWR VPWR sky130_fd_sc_hd__decap_3
XFILLER_54_361 VGND VGND VPWR VPWR sky130_fd_sc_hd__decap_3
XTAP_TAPCELL_ROW_72_827 VGND VPWR sky130_fd_sc_hd__tapvpwrvgnd_1
XTAP_TAPCELL_ROW_1_184 VGND VPWR sky130_fd_sc_hd__tapvpwrvgnd_1
XFILLER_73_169 VGND VGND VPWR VPWR sky130_fd_sc_hd__fill_2
XFILLER_14_225 VGND VGND VPWR VPWR sky130_fd_sc_hd__fill_1
XFILLER_14_236 VGND VGND VPWR VPWR sky130_fd_sc_hd__fill_1
XFILLER_22_280 VGND VGND VPWR VPWR sky130_fd_sc_hd__decap_3
XPHY_EDGE_ROW_23_Left_106 VGND VGND VPWR VPWR sky130_fd_sc_hd__decap_3
XTAP_TAPCELL_ROW_9_262 VGND VPWR sky130_fd_sc_hd__tapvpwrvgnd_1
XFILLER_49_122 VGND VGND VPWR VPWR sky130_fd_sc_hd__decap_3
XFILLER_49_155 VGND VGND VPWR VPWR sky130_fd_sc_hd__decap_3
XFILLER_37_328 VGND VGND VPWR VPWR sky130_fd_sc_hd__decap_3
XPHY_EDGE_ROW_32_Left_115 VGND VGND VPWR VPWR sky130_fd_sc_hd__decap_3
XFILLER_38_91 VGND VGND VPWR VPWR sky130_fd_sc_hd__fill_1
XFILLER_45_372 VGND VGND VPWR VPWR sky130_fd_sc_hd__decap_3
X_4780_ _4751_/A _4751_/B _4660_/Y _4778_/Y _4779_/Y VGND VGND VPWR VPWR _4780_/X
+ sky130_fd_sc_hd__a221o_2
X_3800_ _3800_/A _3800_/B VGND VGND VPWR VPWR _3800_/X sky130_fd_sc_hd__or2_2
XFILLER_20_206 VGND VGND VPWR VPWR sky130_fd_sc_hd__fill_1
X_3731_ _3733_/A _3733_/B _3733_/C VGND VGND VPWR VPWR _3731_/X sky130_fd_sc_hd__or3_4
XTAP_TAPCELL_ROW_43_562 VGND VPWR sky130_fd_sc_hd__tapvpwrvgnd_1
X_6450_ _6450_/A0 _6450_/A1 _5096_/A _6450_/A3 _6450_/S0 _6468_/S1 VGND VGND VPWR
+ VPWR _6450_/X sky130_fd_sc_hd__mux4_2
X_3662_ _3664_/A VGND VGND VPWR VPWR _3716_/S sky130_fd_sc_hd__inv_2
XPHY_EDGE_ROW_41_Left_124 VGND VGND VPWR VPWR sky130_fd_sc_hd__decap_3
X_6381_ _6391_/D _6379_/Y _6309_/C _6393_/B VGND VGND VPWR VPWR _6381_/X sky130_fd_sc_hd__a2bb2o_2
X_5401_ _5460_/A VGND VGND VPWR VPWR _5466_/A sky130_fd_sc_hd__inv_2
X_3593_ _4154_/B _5014_/B _3592_/X _3310_/Y VGND VGND VPWR VPWR _3593_/X sky130_fd_sc_hd__a2bb2o_2
X_5332_ _4813_/A _5322_/Y _5324_/X _5327_/X _5331_/X VGND VGND VPWR VPWR _5332_/X
+ sky130_fd_sc_hd__a221o_2
X_5263_ _5263_/A _5438_/A _5359_/C VGND VGND VPWR VPWR _5264_/S sky130_fd_sc_hd__or3b_2
X_5194_ _5129_/Y _5193_/X _5274_/B VGND VGND VPWR VPWR _5194_/X sky130_fd_sc_hd__a21o_2
X_4214_ _6171_/A _4263_/B _4213_/X VGND VGND VPWR VPWR _4215_/B sky130_fd_sc_hd__a21oi_2
X_4145_ _5216_/A _3366_/X _4143_/Y _5739_/B VGND VGND VPWR VPWR _4145_/X sky130_fd_sc_hd__a211o_2
XPHY_EDGE_ROW_50_Left_133 VGND VGND VPWR VPWR sky130_fd_sc_hd__decap_3
XFILLER_28_339 VGND VGND VPWR VPWR sky130_fd_sc_hd__decap_3
XFILLER_68_475 VGND VGND VPWR VPWR sky130_fd_sc_hd__fill_1
XFILLER_55_158 VGND VGND VPWR VPWR sky130_fd_sc_hd__decap_3
X_4076_ _4076_/A _4076_/B _6154_/B _4076_/D VGND VGND VPWR VPWR _4076_/Y sky130_fd_sc_hd__nor4_2
XFILLER_34_27 VGND VGND VPWR VPWR sky130_fd_sc_hd__fill_1
XFILLER_36_394 VGND VGND VPWR VPWR sky130_fd_sc_hd__decap_3
XFILLER_51_331 VGND VGND VPWR VPWR sky130_fd_sc_hd__decap_3
XFILLER_51_364 VGND VGND VPWR VPWR sky130_fd_sc_hd__fill_1
XFILLER_11_239 VGND VGND VPWR VPWR sky130_fd_sc_hd__fill_2
XFILLER_51_386 VGND VGND VPWR VPWR sky130_fd_sc_hd__decap_3
X_4978_ _4817_/A _4898_/B _4977_/Y _4901_/C VGND VGND VPWR VPWR _4978_/X sky130_fd_sc_hd__a31o_2
X_3929_ _4360_/A _4360_/B VGND VGND VPWR VPWR _3929_/Y sky130_fd_sc_hd__xnor2_2
XFILLER_3_449 VGND VGND VPWR VPWR sky130_fd_sc_hd__fill_2
XFILLER_59_57 VGND VGND VPWR VPWR sky130_fd_sc_hd__fill_2
XTAP_TAPCELL_ROW_6_232 VGND VPWR sky130_fd_sc_hd__tapvpwrvgnd_1
XFILLER_46_147 VGND VGND VPWR VPWR sky130_fd_sc_hd__fill_1
XFILLER_42_320 VGND VGND VPWR VPWR sky130_fd_sc_hd__decap_3
XFILLER_54_180 VGND VGND VPWR VPWR sky130_fd_sc_hd__decap_3
XFILLER_42_342 VGND VGND VPWR VPWR sky130_fd_sc_hd__decap_3
XTAP_TAPCELL_ROW_40_543 VGND VPWR sky130_fd_sc_hd__tapvpwrvgnd_1
XFILLER_10_261 VGND VGND VPWR VPWR sky130_fd_sc_hd__decap_3
XFILLER_10_283 VGND VGND VPWR VPWR sky130_fd_sc_hd__decap_3
XTAP_TAPCELL_ROW_12_289 VGND VPWR sky130_fd_sc_hd__tapvpwrvgnd_1
XFILLER_69_228 VGND VGND VPWR VPWR sky130_fd_sc_hd__decap_3
XFILLER_49_90 VGND VGND VPWR VPWR sky130_fd_sc_hd__decap_3
Xload_slew658 _6013_/A VGND VGND VPWR VPWR _6114_/A sky130_fd_sc_hd__clkbuf_4
XFILLER_77_250 VGND VGND VPWR VPWR sky130_fd_sc_hd__decap_3
XTAP_TAPCELL_ROW_48_610 VGND VPWR sky130_fd_sc_hd__tapvpwrvgnd_1
XFILLER_37_125 VGND VGND VPWR VPWR sky130_fd_sc_hd__decap_3
XFILLER_65_434 VGND VGND VPWR VPWR sky130_fd_sc_hd__fill_1
X_5950_ _5975_/A _5934_/Y _5936_/X _5945_/X _5949_/X VGND VGND VPWR VPWR _5950_/X
+ sky130_fd_sc_hd__a311o_2
XFILLER_18_383 VGND VGND VPWR VPWR sky130_fd_sc_hd__decap_3
XFILLER_52_139 VGND VGND VPWR VPWR sky130_fd_sc_hd__fill_1
X_4901_ _4901_/A _4954_/D _4901_/C VGND VGND VPWR VPWR _4901_/X sky130_fd_sc_hd__or3_2
X_5881_ _5932_/A _5881_/B VGND VGND VPWR VPWR _6419_/B sky130_fd_sc_hd__nor2_2
XFILLER_21_515 VGND VGND VPWR VPWR sky130_fd_sc_hd__fill_1
X_4832_ _4849_/A _4923_/A _6460_/A2 _6460_/A1 _5008_/S0 wire372/X VGND VGND VPWR VPWR
+ _4832_/X sky130_fd_sc_hd__mux4_2
X_4763_ _4763_/A _4763_/B VGND VGND VPWR VPWR _4763_/X sky130_fd_sc_hd__or2_2
X_4694_ _4694_/A _4694_/B VGND VGND VPWR VPWR _4778_/A sky130_fd_sc_hd__nand2_2
X_3714_ _3949_/S _3714_/B VGND VGND VPWR VPWR _3714_/Y sky130_fd_sc_hd__nand2_2
X_6433_ _3394_/B _6429_/B _6472_/S _6432_/X _6429_/A VGND VGND VPWR VPWR _6433_/X
+ sky130_fd_sc_hd__o311a_2
X_3645_ _3595_/X _3644_/X _3842_/S VGND VGND VPWR VPWR _3645_/X sky130_fd_sc_hd__mux2_2
X_6364_ _6319_/A _6358_/B _6363_/X _5388_/S VGND VGND VPWR VPWR _6364_/X sky130_fd_sc_hd__a31o_2
X_3576_ _6461_/A3 _6461_/A2 _6457_/A3 _6457_/A2 _3695_/S0 _3948_/S1 VGND VGND VPWR
+ VPWR _3576_/X sky130_fd_sc_hd__mux4_2
XFILLER_0_419 VGND VGND VPWR VPWR sky130_fd_sc_hd__fill_1
X_6295_ _6294_/A _6359_/B _6294_/Y _5405_/B VGND VGND VPWR VPWR _6295_/X sky130_fd_sc_hd__a211o_2
X_5315_ _6358_/A _6359_/A VGND VGND VPWR VPWR _5341_/B sky130_fd_sc_hd__xnor2_2
X_5246_ _6392_/B _6391_/D VGND VGND VPWR VPWR _5256_/A sky130_fd_sc_hd__or2b_2
XTAP_TAPCELL_ROW_3_202 VGND VPWR sky130_fd_sc_hd__tapvpwrvgnd_1
X_5177_ _5177_/A _5177_/B VGND VGND VPWR VPWR _5177_/Y sky130_fd_sc_hd__nand2_2
XFILLER_28_125 VGND VGND VPWR VPWR sky130_fd_sc_hd__decap_3
XFILLER_28_147 VGND VGND VPWR VPWR sky130_fd_sc_hd__fill_2
X_4128_ _6164_/A _4075_/B _6167_/A VGND VGND VPWR VPWR _4128_/X sky130_fd_sc_hd__a21o_2
XFILLER_45_26 VGND VGND VPWR VPWR sky130_fd_sc_hd__fill_2
X_4059_ _5010_/S _4056_/X _4058_/Y VGND VGND VPWR VPWR _4059_/X sky130_fd_sc_hd__a21o_2
XFILLER_71_415 VGND VGND VPWR VPWR sky130_fd_sc_hd__fill_1
XTAP_TAPCELL_ROW_82_922 VGND VPWR sky130_fd_sc_hd__tapvpwrvgnd_1
XTAP_TAPCELL_ROW_54_668 VGND VPWR sky130_fd_sc_hd__tapvpwrvgnd_1
XFILLER_51_161 VGND VGND VPWR VPWR sky130_fd_sc_hd__decap_3
XFILLER_59_272 VGND VGND VPWR VPWR sky130_fd_sc_hd__fill_1
XFILLER_19_82 VGND VGND VPWR VPWR sky130_fd_sc_hd__decap_3
XFILLER_74_231 VGND VGND VPWR VPWR sky130_fd_sc_hd__decap_3
XFILLER_34_128 VGND VGND VPWR VPWR sky130_fd_sc_hd__decap_3
XFILLER_27_191 VGND VGND VPWR VPWR sky130_fd_sc_hd__decap_3
XFILLER_15_364 VGND VGND VPWR VPWR sky130_fd_sc_hd__fill_2
XFILLER_30_312 VGND VGND VPWR VPWR sky130_fd_sc_hd__decap_3
XFILLER_42_150 VGND VGND VPWR VPWR sky130_fd_sc_hd__decap_3
XFILLER_42_183 VGND VGND VPWR VPWR sky130_fd_sc_hd__decap_3
Xmax_cap216 _5739_/A VGND VGND VPWR VPWR _5284_/S sky130_fd_sc_hd__clkbuf_2
Xmax_cap205 _4927_/B VGND VGND VPWR VPWR _4669_/B sky130_fd_sc_hd__buf_1
Xmax_cap238 _4168_/X VGND VGND VPWR VPWR _4320_/A sky130_fd_sc_hd__buf_2
X_3430_ _4106_/A _3299_/A _3429_/X VGND VGND VPWR VPWR _3430_/X sky130_fd_sc_hd__a21o_2
X_3361_ _3367_/A _3367_/B _3361_/C _3361_/D VGND VGND VPWR VPWR _4332_/A sky130_fd_sc_hd__and4_2
X_6080_ _6080_/A _6298_/C VGND VGND VPWR VPWR _6080_/Y sky130_fd_sc_hd__nand2_2
X_5100_ _5097_/S _5099_/A _4473_/A _5098_/Y _5099_/Y VGND VGND VPWR VPWR _5100_/X
+ sky130_fd_sc_hd__o311a_2
X_5031_ _6265_/B input100/X VGND VGND VPWR VPWR _5034_/S sky130_fd_sc_hd__nor2b_2
X_3292_ _3292_/A _3367_/B _3361_/C _3361_/D VGND VGND VPWR VPWR _3293_/A sky130_fd_sc_hd__and4_2
XFILLER_38_412 VGND VGND VPWR VPWR sky130_fd_sc_hd__decap_3
XFILLER_57_209 VGND VGND VPWR VPWR sky130_fd_sc_hd__decap_3
XFILLER_65_231 VGND VGND VPWR VPWR sky130_fd_sc_hd__decap_3
XFILLER_25_106 VGND VGND VPWR VPWR sky130_fd_sc_hd__fill_1
XFILLER_65_264 VGND VGND VPWR VPWR sky130_fd_sc_hd__decap_3
XFILLER_80_234 VGND VGND VPWR VPWR sky130_fd_sc_hd__fill_1
X_5933_ _5908_/B _5935_/C _5932_/Y VGND VGND VPWR VPWR _5934_/A sky130_fd_sc_hd__o21ai_2
XFILLER_33_161 VGND VGND VPWR VPWR sky130_fd_sc_hd__decap_3
XFILLER_33_172 VGND VGND VPWR VPWR sky130_fd_sc_hd__decap_3
X_5864_ _5853_/A _5863_/X _5061_/A VGND VGND VPWR VPWR _5864_/Y sky130_fd_sc_hd__o21ai_2
XTAP_TAPCELL_ROW_51_638 VGND VPWR sky130_fd_sc_hd__tapvpwrvgnd_1
XFILLER_21_334 VGND VGND VPWR VPWR sky130_fd_sc_hd__fill_2
X_4815_ _4923_/B _4821_/A VGND VGND VPWR VPWR _4817_/A sky130_fd_sc_hd__nand2_2
X_5795_ _6404_/S _5795_/B VGND VGND VPWR VPWR _5795_/Y sky130_fd_sc_hd__xnor2_2
X_4746_ _5138_/A _6453_/B VGND VGND VPWR VPWR _6474_/B sky130_fd_sc_hd__nor2_2
X_4677_ _4329_/X _4676_/X _6106_/A VGND VGND VPWR VPWR _4677_/X sky130_fd_sc_hd__mux2_2
X_6416_ _5874_/B _6415_/X _5925_/Y _5923_/A VGND VGND VPWR VPWR _6420_/C sky130_fd_sc_hd__o211a_2
X_3628_ _5962_/A _4422_/A _6442_/B VGND VGND VPWR VPWR _3628_/X sky130_fd_sc_hd__mux2_2
X_6347_ _5599_/B _6345_/X _6346_/X _5637_/A VGND VGND VPWR VPWR _6347_/X sky130_fd_sc_hd__a22o_2
X_3559_ _3668_/A _3559_/B _3559_/C _3559_/D VGND VGND VPWR VPWR _3559_/X sky130_fd_sc_hd__and4b_2
X_6278_ _6266_/X _6277_/X _6271_/X VGND VGND VPWR VPWR _6278_/Y sky130_fd_sc_hd__a21oi_2
Xinput117 operand_b[52] VGND VGND VPWR VPWR input117/X sky130_fd_sc_hd__clkdlybuf4s25_1
Xinput106 operand_b[42] VGND VGND VPWR VPWR input106/X sky130_fd_sc_hd__clkdlybuf4s25_1
Xinput128 operand_b[62] VGND VGND VPWR VPWR _5962_/B sky130_fd_sc_hd__buf_1
X_5229_ _4829_/X _5227_/X wire230/X VGND VGND VPWR VPWR _5229_/Y sky130_fd_sc_hd__a21oi_2
XFILLER_56_25 VGND VGND VPWR VPWR sky130_fd_sc_hd__decap_3
XFILLER_56_242 VGND VGND VPWR VPWR sky130_fd_sc_hd__decap_3
XFILLER_56_253 VGND VGND VPWR VPWR sky130_fd_sc_hd__decap_3
XFILLER_56_58 VGND VGND VPWR VPWR sky130_fd_sc_hd__fill_2
XFILLER_56_69 VGND VGND VPWR VPWR sky130_fd_sc_hd__fill_2
XFILLER_16_128 VGND VGND VPWR VPWR sky130_fd_sc_hd__decap_3
XFILLER_56_286 VGND VGND VPWR VPWR sky130_fd_sc_hd__decap_3
XTAP_TAPCELL_ROW_67_782 VGND VPWR sky130_fd_sc_hd__tapvpwrvgnd_1
XFILLER_71_201 VGND VGND VPWR VPWR sky130_fd_sc_hd__decap_3
XTAP_TAPCELL_ROW_14_307 VGND VPWR sky130_fd_sc_hd__tapvpwrvgnd_1
XFILLER_71_278 VGND VGND VPWR VPWR sky130_fd_sc_hd__fill_2
XFILLER_8_327 VGND VGND VPWR VPWR sky130_fd_sc_hd__fill_2
XTAP_TAPCELL_ROW_22_373 VGND VPWR sky130_fd_sc_hd__tapvpwrvgnd_1
XFILLER_47_220 VGND VGND VPWR VPWR sky130_fd_sc_hd__decap_3
XFILLER_47_231 VGND VGND VPWR VPWR sky130_fd_sc_hd__decap_3
XFILLER_47_264 VGND VGND VPWR VPWR sky130_fd_sc_hd__decap_3
XFILLER_50_407 VGND VGND VPWR VPWR sky130_fd_sc_hd__decap_3
XFILLER_62_256 VGND VGND VPWR VPWR sky130_fd_sc_hd__decap_3
XFILLER_62_289 VGND VGND VPWR VPWR sky130_fd_sc_hd__fill_1
XFILLER_15_172 VGND VGND VPWR VPWR sky130_fd_sc_hd__decap_3
XFILLER_43_492 VGND VGND VPWR VPWR sky130_fd_sc_hd__decap_3
XFILLER_30_153 VGND VGND VPWR VPWR sky130_fd_sc_hd__decap_3
X_4600_ _4681_/A1 _4681_/A0 _6232_/B VGND VGND VPWR VPWR _4600_/X sky130_fd_sc_hd__mux2_2
XFILLER_30_186 VGND VGND VPWR VPWR sky130_fd_sc_hd__decap_3
XFILLER_30_197 VGND VGND VPWR VPWR sky130_fd_sc_hd__fill_1
X_5580_ _5580_/A _5580_/B _5580_/C VGND VGND VPWR VPWR _5580_/X sky130_fd_sc_hd__and3_2
X_4531_ _6192_/A _6193_/S VGND VGND VPWR VPWR _4614_/A sky130_fd_sc_hd__and2b_2
XFILLER_7_360 VGND VGND VPWR VPWR sky130_fd_sc_hd__fill_2
X_4462_ _4100_/X _4461_/X _4462_/S VGND VGND VPWR VPWR _4463_/B sky130_fd_sc_hd__mux2_2
XFILLER_7_382 VGND VGND VPWR VPWR sky130_fd_sc_hd__decap_3
X_6201_ _6178_/A _4408_/X _6200_/X _4436_/X VGND VGND VPWR VPWR _6201_/X sky130_fd_sc_hd__o22a_2
X_3413_ _3408_/Y _3411_/X _3412_/Y VGND VGND VPWR VPWR _3413_/X sky130_fd_sc_hd__a21o_2
X_4393_ _6176_/A _4393_/B VGND VGND VPWR VPWR _4394_/B sky130_fd_sc_hd__or2_2
X_6132_ _3907_/C _6130_/X _6131_/X _3864_/Y VGND VGND VPWR VPWR _6132_/X sky130_fd_sc_hd__a22o_2
X_3344_ _3515_/B _3417_/A _3344_/C VGND VGND VPWR VPWR _3344_/X sky130_fd_sc_hd__or3_2
X_6063_ _6152_/A _6158_/A VGND VGND VPWR VPWR _6156_/A sky130_fd_sc_hd__and2_2
X_3275_ _3571_/S VGND VGND VPWR VPWR _3500_/S sky130_fd_sc_hd__clkbuf_1
X_5014_ _5014_/A _5014_/B VGND VGND VPWR VPWR _5014_/Y sky130_fd_sc_hd__nand2_2
XFILLER_38_253 VGND VGND VPWR VPWR sky130_fd_sc_hd__decap_3
XFILLER_38_275 VGND VGND VPWR VPWR sky130_fd_sc_hd__decap_3
XTAP_TAPCELL_ROW_64_752 VGND VPWR sky130_fd_sc_hd__tapvpwrvgnd_1
X_5916_ _6410_/A VGND VGND VPWR VPWR _5917_/B sky130_fd_sc_hd__inv_2
X_5847_ _5847_/A _5847_/B VGND VGND VPWR VPWR _5847_/Y sky130_fd_sc_hd__nand2_2
XFILLER_21_197 VGND VGND VPWR VPWR sky130_fd_sc_hd__decap_3
X_5778_ _5874_/A VGND VGND VPWR VPWR _5886_/A sky130_fd_sc_hd__inv_2
X_4729_ _4124_/X _4699_/Y _4711_/X _4312_/X _4728_/X VGND VGND VPWR VPWR _5986_/B
+ sky130_fd_sc_hd__a221o_2
XFILLER_44_212 VGND VGND VPWR VPWR sky130_fd_sc_hd__fill_2
XTAP_TAPCELL_ROW_27_421 VGND VPWR sky130_fd_sc_hd__tapvpwrvgnd_1
XFILLER_16_50 VGND VGND VPWR VPWR sky130_fd_sc_hd__fill_1
XFILLER_32_418 VGND VGND VPWR VPWR sky130_fd_sc_hd__fill_2
XFILLER_12_153 VGND VGND VPWR VPWR sky130_fd_sc_hd__decap_3
XFILLER_4_352 VGND VGND VPWR VPWR sky130_fd_sc_hd__fill_2
XFILLER_4_374 VGND VGND VPWR VPWR sky130_fd_sc_hd__fill_2
XFILLER_67_337 VGND VGND VPWR VPWR sky130_fd_sc_hd__decap_3
XTAP_TAPCELL_ROW_78_877 VGND VPWR sky130_fd_sc_hd__tapvpwrvgnd_1
XFILLER_35_201 VGND VGND VPWR VPWR sky130_fd_sc_hd__decap_3
XFILLER_35_234 VGND VGND VPWR VPWR sky130_fd_sc_hd__decap_3
XFILLER_50_226 VGND VGND VPWR VPWR sky130_fd_sc_hd__fill_2
X_5701_ _5739_/A _5701_/B VGND VGND VPWR VPWR _5701_/Y sky130_fd_sc_hd__nor2_2
X_3962_ _3937_/S input73/X _3926_/A _3926_/B _3966_/S VGND VGND VPWR VPWR _3967_/B
+ sky130_fd_sc_hd__o2111a_2
X_3893_ _3890_/Y _3892_/X _3872_/A VGND VGND VPWR VPWR _3893_/Y sky130_fd_sc_hd__a21oi_2
XTAP_TAPCELL_ROW_33_479 VGND VPWR sky130_fd_sc_hd__tapvpwrvgnd_1
X_5632_ _5637_/A _6332_/A VGND VGND VPWR VPWR _5635_/C sky130_fd_sc_hd__and2_2
X_5563_ _6346_/A VGND VGND VPWR VPWR _5591_/S sky130_fd_sc_hd__inv_2
X_4514_ _3782_/B _5732_/B _4422_/Y VGND VGND VPWR VPWR _4514_/X sky130_fd_sc_hd__o21a_2
X_5494_ _5117_/A _5117_/B _5530_/B _5530_/C VGND VGND VPWR VPWR _5497_/C sky130_fd_sc_hd__a211o_2
X_4445_ _4544_/A _4482_/B _4478_/D _4498_/B VGND VGND VPWR VPWR _4479_/A sky130_fd_sc_hd__o211a_2
Xfanout604 input13/X VGND VGND VPWR VPWR _4175_/A sky130_fd_sc_hd__clkdlybuf4s25_1
Xfanout615 _6474_/A VGND VGND VPWR VPWR _4884_/A sky130_fd_sc_hd__clkdlybuf4s25_1
X_4376_ _6199_/C input18/X _4504_/S VGND VGND VPWR VPWR _4376_/X sky130_fd_sc_hd__mux2_2
X_6115_ _6121_/S _6114_/Y input50/X VGND VGND VPWR VPWR _6118_/A sky130_fd_sc_hd__o21a_2
Xfanout626 _5773_/A1 VGND VGND VPWR VPWR _6033_/B sky130_fd_sc_hd__clkdlybuf4s25_1
Xfanout637 input116/X VGND VGND VPWR VPWR _5710_/B sky130_fd_sc_hd__clkdlybuf4s25_1
X_3327_ _6464_/A1 _3965_/A _3327_/S VGND VGND VPWR VPWR _3327_/X sky130_fd_sc_hd__mux2_2
XTAP_TAPCELL_ROW_69_800 VGND VPWR sky130_fd_sc_hd__tapvpwrvgnd_1
XFILLER_58_315 VGND VGND VPWR VPWR sky130_fd_sc_hd__decap_3
Xfanout659 input114/X VGND VGND VPWR VPWR _4027_/A sky130_fd_sc_hd__clkdlybuf4s25_1
XFILLER_58_337 VGND VGND VPWR VPWR sky130_fd_sc_hd__decap_3
X_6046_ _5866_/A _6417_/A _6417_/B _6045_/Y VGND VGND VPWR VPWR _6046_/X sky130_fd_sc_hd__a31o_2
X_3258_ _3361_/C _3260_/C VGND VGND VPWR VPWR _4849_/B sky130_fd_sc_hd__nand2_2
XFILLER_73_318 VGND VGND VPWR VPWR sky130_fd_sc_hd__decap_3
XFILLER_26_267 VGND VGND VPWR VPWR sky130_fd_sc_hd__decap_3
XFILLER_49_304 VGND VGND VPWR VPWR sky130_fd_sc_hd__decap_3
XFILLER_49_337 VGND VGND VPWR VPWR sky130_fd_sc_hd__decap_3
XFILLER_57_381 VGND VGND VPWR VPWR sky130_fd_sc_hd__fill_1
XTAP_TAPCELL_ROW_75_858 VGND VPWR sky130_fd_sc_hd__tapvpwrvgnd_1
XFILLER_72_351 VGND VGND VPWR VPWR sky130_fd_sc_hd__decap_3
XFILLER_32_215 VGND VGND VPWR VPWR sky130_fd_sc_hd__decap_3
XFILLER_32_237 VGND VGND VPWR VPWR sky130_fd_sc_hd__fill_1
XFILLER_43_70 VGND VGND VPWR VPWR sky130_fd_sc_hd__decap_3
XTAP_TAPCELL_ROW_30_449 VGND VPWR sky130_fd_sc_hd__tapvpwrvgnd_1
X_4230_ _4230_/A _6161_/A VGND VGND VPWR VPWR _4230_/X sky130_fd_sc_hd__or2_2
X_4161_ _4158_/Y _4160_/X _4211_/A VGND VGND VPWR VPWR _4161_/Y sky130_fd_sc_hd__a21oi_2
X_4092_ _4092_/A VGND VGND VPWR VPWR _4743_/A sky130_fd_sc_hd__buf_6
XFILLER_63_340 VGND VGND VPWR VPWR sky130_fd_sc_hd__decap_3
XFILLER_23_204 VGND VGND VPWR VPWR sky130_fd_sc_hd__decap_3
XFILLER_51_502 VGND VGND VPWR VPWR sky130_fd_sc_hd__fill_2
XFILLER_51_513 VGND VGND VPWR VPWR sky130_fd_sc_hd__decap_3
XFILLER_63_362 VGND VGND VPWR VPWR sky130_fd_sc_hd__decap_3
X_4994_ _6077_/C _5108_/B VGND VGND VPWR VPWR _4994_/Y sky130_fd_sc_hd__nand2_2
XTAP_TAPCELL_ROW_46_593 VGND VPWR sky130_fd_sc_hd__tapvpwrvgnd_1
X_3945_ _3945_/A _3985_/A VGND VGND VPWR VPWR _3945_/Y sky130_fd_sc_hd__nand2_2
XFILLER_31_281 VGND VGND VPWR VPWR sky130_fd_sc_hd__fill_1
X_5615_ _5637_/A _6346_/A _5712_/A _5615_/A3 _5764_/S0 _5801_/S1 VGND VGND VPWR VPWR
+ _5615_/X sky130_fd_sc_hd__mux4_2
X_3876_ _3873_/X _3875_/X _3876_/S VGND VGND VPWR VPWR _3876_/X sky130_fd_sc_hd__mux2_2
X_5546_ _5712_/A _5615_/A3 _5476_/S _5460_/A _5764_/S0 _5801_/S1 VGND VGND VPWR VPWR
+ _5546_/X sky130_fd_sc_hd__mux4_2
X_5477_ _5477_/A VGND VGND VPWR VPWR _5478_/B sky130_fd_sc_hd__clkbuf_1
X_4428_ _4498_/B _4401_/X _4402_/Y _4427_/X VGND VGND VPWR VPWR _5994_/C sky130_fd_sc_hd__a31o_2
Xfanout412 input77/X VGND VGND VPWR VPWR _6164_/A sky130_fd_sc_hd__clkdlybuf4s25_1
Xfanout445 _6464_/A1 VGND VGND VPWR VPWR _6130_/S sky130_fd_sc_hd__clkdlybuf4s25_1
Xfanout456 _5590_/A1 VGND VGND VPWR VPWR _3748_/B sky130_fd_sc_hd__clkdlybuf4s25_1
X_4359_ _4266_/B _4709_/C _4709_/B VGND VGND VPWR VPWR _4364_/A sky130_fd_sc_hd__o21ai_2
XFILLER_46_307 VGND VGND VPWR VPWR sky130_fd_sc_hd__fill_1
Xfanout467 _3612_/A VGND VGND VPWR VPWR _6122_/A1 sky130_fd_sc_hd__clkdlybuf4s25_1
Xfanout478 input57/X VGND VGND VPWR VPWR _6428_/A0 sky130_fd_sc_hd__clkdlybuf4s25_1
Xfanout489 _5615_/A3 VGND VGND VPWR VPWR _6317_/S sky130_fd_sc_hd__clkdlybuf4s25_1
XFILLER_58_156 VGND VGND VPWR VPWR sky130_fd_sc_hd__fill_1
XFILLER_46_318 VGND VGND VPWR VPWR sky130_fd_sc_hd__fill_2
X_6029_ _6330_/B _6333_/A _6330_/D VGND VGND VPWR VPWR _6344_/B sky130_fd_sc_hd__and3_2
XFILLER_58_189 VGND VGND VPWR VPWR sky130_fd_sc_hd__decap_3
XTAP_TAPCELL_ROW_72_828 VGND VPWR sky130_fd_sc_hd__tapvpwrvgnd_1
XTAP_TAPCELL_ROW_1_185 VGND VPWR sky130_fd_sc_hd__tapvpwrvgnd_1
XTAP_TAPCELL_ROW_9_263 VGND VPWR sky130_fd_sc_hd__tapvpwrvgnd_1
XFILLER_49_134 VGND VGND VPWR VPWR sky130_fd_sc_hd__fill_1
XFILLER_37_318 VGND VGND VPWR VPWR sky130_fd_sc_hd__fill_1
XFILLER_49_189 VGND VGND VPWR VPWR sky130_fd_sc_hd__decap_3
XFILLER_64_159 VGND VGND VPWR VPWR sky130_fd_sc_hd__decap_3
XFILLER_45_340 VGND VGND VPWR VPWR sky130_fd_sc_hd__decap_3
XFILLER_45_384 VGND VGND VPWR VPWR sky130_fd_sc_hd__decap_3
XFILLER_72_170 VGND VGND VPWR VPWR sky130_fd_sc_hd__fill_2
XFILLER_60_321 VGND VGND VPWR VPWR sky130_fd_sc_hd__decap_3
XFILLER_72_192 VGND VGND VPWR VPWR sky130_fd_sc_hd__fill_1
X_3730_ _4077_/A _3860_/B _3745_/A VGND VGND VPWR VPWR _3733_/C sky130_fd_sc_hd__mux2_2
XTAP_TAPCELL_ROW_43_563 VGND VPWR sky130_fd_sc_hd__tapvpwrvgnd_1
XFILLER_60_387 VGND VGND VPWR VPWR sky130_fd_sc_hd__fill_2
XFILLER_13_281 VGND VGND VPWR VPWR sky130_fd_sc_hd__decap_3
X_3661_ _6492_/A _3619_/Y _3660_/X VGND VGND VPWR VPWR _3661_/Y sky130_fd_sc_hd__o21ai_2
X_6380_ _6391_/A _6391_/B VGND VGND VPWR VPWR _6393_/B sky130_fd_sc_hd__nor2_2
X_5400_ _4527_/X _5370_/Y _5399_/X VGND VGND VPWR VPWR _6002_/A sky130_fd_sc_hd__a21o_2
X_3592_ _3588_/X _3591_/X _3592_/S VGND VGND VPWR VPWR _3592_/X sky130_fd_sc_hd__mux2_2
X_5331_ _3979_/X _4929_/X _5330_/X _4848_/A _5228_/A VGND VGND VPWR VPWR _5331_/X
+ sky130_fd_sc_hd__a221o_2
X_5262_ _5262_/A _5262_/B VGND VGND VPWR VPWR _5359_/C sky130_fd_sc_hd__and2_2
X_5193_ _5193_/A _5193_/B VGND VGND VPWR VPWR _5193_/X sky130_fd_sc_hd__or2_2
X_4213_ _6171_/A _4263_/B _4230_/A VGND VGND VPWR VPWR _4213_/X sky130_fd_sc_hd__o21ba_2
X_4144_ _4840_/B VGND VGND VPWR VPWR _5739_/B sky130_fd_sc_hd__clkbuf_2
X_4075_ _4183_/A _4075_/B VGND VGND VPWR VPWR _4075_/Y sky130_fd_sc_hd__xnor2_2
XFILLER_36_373 VGND VGND VPWR VPWR sky130_fd_sc_hd__decap_3
XFILLER_51_310 VGND VGND VPWR VPWR sky130_fd_sc_hd__decap_3
X_4977_ _4923_/B _4821_/A _6071_/B _4818_/A VGND VGND VPWR VPWR _4977_/Y sky130_fd_sc_hd__o211ai_2
X_3928_ _3928_/A _3928_/B _3928_/C _3928_/D VGND VGND VPWR VPWR _4360_/B sky130_fd_sc_hd__nand4_2
XFILLER_50_27 VGND VGND VPWR VPWR sky130_fd_sc_hd__fill_1
X_3859_ _3727_/A _3814_/B _4077_/A VGND VGND VPWR VPWR _3859_/Y sky130_fd_sc_hd__a21oi_2
X_5529_ _5434_/X _5527_/X _5528_/X VGND VGND VPWR VPWR _5532_/B sky130_fd_sc_hd__o21a_2
XFILLER_59_25 VGND VGND VPWR VPWR sky130_fd_sc_hd__fill_2
XFILLER_78_218 VGND VGND VPWR VPWR sky130_fd_sc_hd__decap_3
XTAP_TAPCELL_ROW_6_233 VGND VPWR sky130_fd_sc_hd__tapvpwrvgnd_1
XFILLER_46_115 VGND VGND VPWR VPWR sky130_fd_sc_hd__decap_3
XFILLER_46_137 VGND VGND VPWR VPWR sky130_fd_sc_hd__decap_3
XFILLER_27_340 VGND VGND VPWR VPWR sky130_fd_sc_hd__decap_3
XTAP_TAPCELL_ROW_57_688 VGND VPWR sky130_fd_sc_hd__tapvpwrvgnd_1
XFILLER_15_513 VGND VGND VPWR VPWR sky130_fd_sc_hd__decap_3
XFILLER_61_118 VGND VGND VPWR VPWR sky130_fd_sc_hd__decap_3
XFILLER_42_354 VGND VGND VPWR VPWR sky130_fd_sc_hd__decap_3
XFILLER_42_365 VGND VGND VPWR VPWR sky130_fd_sc_hd__decap_3
XFILLER_10_251 VGND VGND VPWR VPWR sky130_fd_sc_hd__fill_1
Xwire621 wire621/A VGND VGND VPWR VPWR _3748_/A sky130_fd_sc_hd__clkbuf_4
XFILLER_6_200 VGND VGND VPWR VPWR sky130_fd_sc_hd__fill_1
XFILLER_69_207 VGND VGND VPWR VPWR sky130_fd_sc_hd__decap_3
Xload_slew648 _4234_/C1 VGND VGND VPWR VPWR _5014_/A sky130_fd_sc_hd__clkbuf_4
XFILLER_37_104 VGND VGND VPWR VPWR sky130_fd_sc_hd__fill_2
XTAP_TAPCELL_ROW_48_611 VGND VPWR sky130_fd_sc_hd__tapvpwrvgnd_1
XFILLER_65_402 VGND VGND VPWR VPWR sky130_fd_sc_hd__fill_2
XFILLER_37_148 VGND VGND VPWR VPWR sky130_fd_sc_hd__decap_3
XFILLER_77_284 VGND VGND VPWR VPWR sky130_fd_sc_hd__decap_3
XFILLER_45_181 VGND VGND VPWR VPWR sky130_fd_sc_hd__decap_3
X_5880_ _6040_/B VGND VGND VPWR VPWR _5881_/B sky130_fd_sc_hd__inv_2
X_4900_ _4900_/A _6077_/A VGND VGND VPWR VPWR _4901_/C sky130_fd_sc_hd__nor2_2
XFILLER_33_332 VGND VGND VPWR VPWR sky130_fd_sc_hd__decap_3
XFILLER_33_343 VGND VGND VPWR VPWR sky130_fd_sc_hd__decap_3
X_4831_ _5136_/A VGND VGND VPWR VPWR _5966_/A sky130_fd_sc_hd__clkbuf_1
XFILLER_33_387 VGND VGND VPWR VPWR sky130_fd_sc_hd__decap_3
X_4762_ wire227/X _4757_/X _4760_/X _5177_/A VGND VGND VPWR VPWR _4763_/B sky130_fd_sc_hd__a22o_2
XFILLER_60_184 VGND VGND VPWR VPWR sky130_fd_sc_hd__decap_3
X_6501_ _6501_/A VGND VGND VPWR VPWR _6501_/X sky130_fd_sc_hd__buf_2
X_4693_ _4734_/A _6247_/A VGND VGND VPWR VPWR _4694_/B sky130_fd_sc_hd__or2b_2
X_3713_ _3470_/B _3712_/X _3942_/A VGND VGND VPWR VPWR _3714_/B sky130_fd_sc_hd__mux2_2
X_6432_ _6473_/S _6434_/B VGND VGND VPWR VPWR _6432_/X sky130_fd_sc_hd__or2_2
X_3644_ _3681_/A _3548_/B _3711_/S VGND VGND VPWR VPWR _3644_/X sky130_fd_sc_hd__mux2_2
X_6363_ _6363_/A _6365_/B VGND VGND VPWR VPWR _6363_/X sky130_fd_sc_hd__or2_2
X_3575_ _6460_/A3 _6460_/A2 _6447_/A3 input34/X _3575_/S0 _3575_/S1 VGND VGND VPWR
+ VPWR _3575_/X sky130_fd_sc_hd__mux4_2
XFILLER_0_409 VGND VGND VPWR VPWR sky130_fd_sc_hd__fill_2
X_6294_ _6294_/A _6294_/B VGND VGND VPWR VPWR _6294_/Y sky130_fd_sc_hd__nor2_2
X_5314_ _6294_/A _6292_/A _5278_/Y _5405_/B VGND VGND VPWR VPWR _5314_/X sky130_fd_sc_hd__a211o_2
X_5245_ _5348_/A _6392_/B _5244_/X VGND VGND VPWR VPWR _5245_/Y sky130_fd_sc_hd__o21ai_2
XFILLER_28_104 VGND VGND VPWR VPWR sky130_fd_sc_hd__decap_3
X_5176_ _4508_/B _5175_/X _5176_/S VGND VGND VPWR VPWR _5177_/B sky130_fd_sc_hd__mux2_2
XTAP_TAPCELL_ROW_3_203 VGND VPWR sky130_fd_sc_hd__tapvpwrvgnd_1
XFILLER_68_251 VGND VGND VPWR VPWR sky130_fd_sc_hd__fill_1
XFILLER_28_137 VGND VGND VPWR VPWR sky130_fd_sc_hd__decap_3
X_4127_ _4252_/A _4251_/C VGND VGND VPWR VPWR _4136_/A sky130_fd_sc_hd__nand2_2
X_4058_ _3704_/A _6453_/B _4057_/Y VGND VGND VPWR VPWR _4058_/Y sky130_fd_sc_hd__a21oi_2
XFILLER_43_129 VGND VGND VPWR VPWR sky130_fd_sc_hd__decap_3
XTAP_TAPCELL_ROW_82_923 VGND VPWR sky130_fd_sc_hd__tapvpwrvgnd_1
XFILLER_36_181 VGND VGND VPWR VPWR sky130_fd_sc_hd__decap_3
XTAP_TAPCELL_ROW_54_669 VGND VPWR sky130_fd_sc_hd__tapvpwrvgnd_1
XFILLER_51_140 VGND VGND VPWR VPWR sky130_fd_sc_hd__decap_3
XFILLER_47_446 VGND VGND VPWR VPWR sky130_fd_sc_hd__fill_2
XFILLER_74_265 VGND VGND VPWR VPWR sky130_fd_sc_hd__fill_2
XFILLER_62_405 VGND VGND VPWR VPWR sky130_fd_sc_hd__fill_2
XFILLER_74_298 VGND VGND VPWR VPWR sky130_fd_sc_hd__fill_2
XFILLER_27_181 VGND VGND VPWR VPWR sky130_fd_sc_hd__decap_3
XFILLER_30_335 VGND VGND VPWR VPWR sky130_fd_sc_hd__decap_3
Xmax_cap206 _6354_/B VGND VGND VPWR VPWR _6051_/B sky130_fd_sc_hd__buf_2
Xmax_cap228 _6438_/A VGND VGND VPWR VPWR _6468_/S1 sky130_fd_sc_hd__buf_2
X_3360_ _3367_/B _3360_/B VGND VGND VPWR VPWR _3360_/Y sky130_fd_sc_hd__nand2_2
Xload_slew401 _3348_/A VGND VGND VPWR VPWR _6012_/B sky130_fd_sc_hd__clkbuf_2
Xload_slew434 _3881_/S1 VGND VGND VPWR VPWR _4025_/S1 sky130_fd_sc_hd__clkbuf_4
X_5030_ _6270_/B _5030_/B _5109_/A VGND VGND VPWR VPWR _5030_/X sky130_fd_sc_hd__and3_2
X_3291_ _3291_/A VGND VGND VPWR VPWR _4374_/A sky130_fd_sc_hd__buf_1
XFILLER_25_3 VGND VGND VPWR VPWR sky130_fd_sc_hd__fill_1
XFILLER_38_424 VGND VGND VPWR VPWR sky130_fd_sc_hd__decap_3
XFILLER_65_221 VGND VGND VPWR VPWR sky130_fd_sc_hd__decap_3
XFILLER_65_243 VGND VGND VPWR VPWR sky130_fd_sc_hd__decap_3
XFILLER_18_170 VGND VGND VPWR VPWR sky130_fd_sc_hd__decap_3
X_5932_ _5932_/A _5932_/B VGND VGND VPWR VPWR _5932_/Y sky130_fd_sc_hd__nand2_2
XFILLER_65_276 VGND VGND VPWR VPWR sky130_fd_sc_hd__decap_3
XFILLER_53_449 VGND VGND VPWR VPWR sky130_fd_sc_hd__decap_3
X_5863_ _5939_/A _5844_/A _5860_/Y _5861_/X _5862_/Y VGND VGND VPWR VPWR _5863_/X
+ sky130_fd_sc_hd__o221a_2
XFILLER_33_184 VGND VGND VPWR VPWR sky130_fd_sc_hd__decap_3
X_5794_ _5818_/B _5818_/C VGND VGND VPWR VPWR _5795_/B sky130_fd_sc_hd__nor2_2
X_4814_ _4818_/A _6071_/B VGND VGND VPWR VPWR _4916_/C sky130_fd_sc_hd__nand2_2
XTAP_TAPCELL_ROW_51_639 VGND VPWR sky130_fd_sc_hd__tapvpwrvgnd_1
XFILLER_61_482 VGND VGND VPWR VPWR sky130_fd_sc_hd__fill_2
X_4745_ _4789_/B _4745_/B VGND VGND VPWR VPWR _4745_/Y sky130_fd_sc_hd__xnor2_2
X_4676_ _4674_/X _4675_/X _5442_/S VGND VGND VPWR VPWR _4676_/X sky130_fd_sc_hd__mux2_2
X_6415_ _5932_/A _6407_/B _6414_/Y _5866_/A VGND VGND VPWR VPWR _6415_/X sky130_fd_sc_hd__o22a_2
X_3627_ _3592_/S _4010_/B _4010_/C _3626_/X VGND VGND VPWR VPWR _3627_/X sky130_fd_sc_hd__a31o_2
X_6346_ _6346_/A _6346_/B VGND VGND VPWR VPWR _6346_/X sky130_fd_sc_hd__or2_2
X_3558_ _3667_/B _3558_/B _3558_/C VGND VGND VPWR VPWR _3559_/B sky130_fd_sc_hd__or3_2
X_6277_ _6274_/A _6275_/D _6275_/A VGND VGND VPWR VPWR _6277_/X sky130_fd_sc_hd__a21o_2
Xinput118 operand_b[53] VGND VGND VPWR VPWR _6332_/A sky130_fd_sc_hd__clkdlybuf4s25_1
Xinput107 operand_b[43] VGND VGND VPWR VPWR input107/X sky130_fd_sc_hd__clkdlybuf4s25_1
X_3489_ _3489_/A _3538_/B VGND VGND VPWR VPWR _3489_/Y sky130_fd_sc_hd__nand2_2
Xinput129 operand_b[63] VGND VGND VPWR VPWR _6476_/B sky130_fd_sc_hd__buf_1
X_5228_ _5228_/A VGND VGND VPWR VPWR _5228_/X sky130_fd_sc_hd__clkbuf_1
XTAP_TAPCELL_ROW_59_706 VGND VPWR sky130_fd_sc_hd__tapvpwrvgnd_1
XFILLER_56_221 VGND VGND VPWR VPWR sky130_fd_sc_hd__decap_3
X_5159_ _5159_/A VGND VGND VPWR VPWR _5160_/B sky130_fd_sc_hd__inv_2
XFILLER_44_405 VGND VGND VPWR VPWR sky130_fd_sc_hd__decap_3
XTAP_TAPCELL_ROW_67_783 VGND VPWR sky130_fd_sc_hd__tapvpwrvgnd_1
XFILLER_71_235 VGND VGND VPWR VPWR sky130_fd_sc_hd__decap_3
XTAP_TAPCELL_ROW_14_308 VGND VPWR sky130_fd_sc_hd__tapvpwrvgnd_1
XFILLER_24_173 VGND VGND VPWR VPWR sky130_fd_sc_hd__decap_3
XTAP_TAPCELL_ROW_22_374 VGND VPWR sky130_fd_sc_hd__tapvpwrvgnd_1
XFILLER_35_405 VGND VGND VPWR VPWR sky130_fd_sc_hd__decap_3
XFILLER_47_243 VGND VGND VPWR VPWR sky130_fd_sc_hd__decap_3
XFILLER_35_449 VGND VGND VPWR VPWR sky130_fd_sc_hd__decap_3
XFILLER_62_246 VGND VGND VPWR VPWR sky130_fd_sc_hd__decap_3
XFILLER_62_268 VGND VGND VPWR VPWR sky130_fd_sc_hd__decap_3
XFILLER_15_195 VGND VGND VPWR VPWR sky130_fd_sc_hd__fill_2
XFILLER_30_165 VGND VGND VPWR VPWR sky130_fd_sc_hd__decap_3
X_4530_ _4443_/A _4443_/B _4616_/B VGND VGND VPWR VPWR _4536_/C sky130_fd_sc_hd__a21o_2
XFILLER_7_350 VGND VGND VPWR VPWR sky130_fd_sc_hd__fill_2
Xwire281 _4941_/X VGND VGND VPWR VPWR wire281/X sky130_fd_sc_hd__buf_2
X_4461_ _4458_/X _4460_/X _4461_/S VGND VGND VPWR VPWR _4461_/X sky130_fd_sc_hd__mux2_2
X_6200_ _6199_/A _6200_/B _6200_/C VGND VGND VPWR VPWR _6200_/X sky130_fd_sc_hd__and3b_2
X_3412_ _3412_/A _6012_/B VGND VGND VPWR VPWR _3412_/Y sky130_fd_sc_hd__nor2b_2
X_6131_ _6131_/A _6144_/C VGND VGND VPWR VPWR _6131_/X sky130_fd_sc_hd__and2_2
X_4392_ _4168_/X _4709_/B _4364_/Y _4498_/B _4391_/X VGND VGND VPWR VPWR _5995_/A
+ sky130_fd_sc_hd__a221o_2
X_3343_ _3262_/A _3340_/X _3342_/X VGND VGND VPWR VPWR _3343_/X sky130_fd_sc_hd__a21o_2
X_6062_ _6126_/A _6126_/B _6062_/C _6062_/D VGND VGND VPWR VPWR _6085_/B sky130_fd_sc_hd__and4_2
X_3274_ _4429_/A _4546_/A _6457_/A1 _4599_/A _4025_/S1 _3695_/S0 VGND VGND VPWR VPWR
+ _3274_/X sky130_fd_sc_hd__mux4_2
X_5013_ _5014_/A _5013_/B VGND VGND VPWR VPWR _5013_/X sky130_fd_sc_hd__or2_2
XFILLER_38_232 VGND VGND VPWR VPWR sky130_fd_sc_hd__decap_3
XFILLER_53_257 VGND VGND VPWR VPWR sky130_fd_sc_hd__decap_3
XTAP_TAPCELL_ROW_64_753 VGND VPWR sky130_fd_sc_hd__tapvpwrvgnd_1
XPHY_EDGE_ROW_5_Right_5 VGND VGND VPWR VPWR sky130_fd_sc_hd__decap_3
X_5915_ _5627_/A _5896_/X _5913_/X _5914_/Y VGND VGND VPWR VPWR _6005_/A sky130_fd_sc_hd__a211o_2
X_5846_ _5874_/A _5809_/B _5817_/S _5874_/C _5869_/A VGND VGND VPWR VPWR _5852_/B
+ sky130_fd_sc_hd__a2111o_2
XTAP_TAPCELL_ROW_36_499 VGND VPWR sky130_fd_sc_hd__tapvpwrvgnd_1
XFILLER_21_132 VGND VGND VPWR VPWR sky130_fd_sc_hd__fill_1
X_5777_ _5975_/A _5754_/X _5763_/Y _5685_/A _5776_/Y VGND VGND VPWR VPWR _6003_/B
+ sky130_fd_sc_hd__a221o_2
X_4728_ _4728_/A1 _4967_/C _4719_/X _4727_/X VGND VGND VPWR VPWR _4728_/X sky130_fd_sc_hd__a211o_2
X_4659_ _4657_/X _4659_/B VGND VGND VPWR VPWR _4768_/B sky130_fd_sc_hd__nand2b_2
XFILLER_1_515 VGND VGND VPWR VPWR sky130_fd_sc_hd__fill_1
X_6329_ _6317_/S _5712_/A _6344_/B VGND VGND VPWR VPWR _6329_/Y sky130_fd_sc_hd__o21ai_2
XPHY_EDGE_ROW_10_Left_93 VGND VGND VPWR VPWR sky130_fd_sc_hd__decap_3
XFILLER_29_265 VGND VGND VPWR VPWR sky130_fd_sc_hd__decap_3
XFILLER_44_235 VGND VGND VPWR VPWR sky130_fd_sc_hd__decap_3
XTAP_TAPCELL_ROW_27_422 VGND VPWR sky130_fd_sc_hd__tapvpwrvgnd_1
XFILLER_44_268 VGND VGND VPWR VPWR sky130_fd_sc_hd__decap_3
XFILLER_40_430 VGND VGND VPWR VPWR sky130_fd_sc_hd__decap_3
XFILLER_12_165 VGND VGND VPWR VPWR sky130_fd_sc_hd__decap_3
XFILLER_67_349 VGND VGND VPWR VPWR sky130_fd_sc_hd__decap_3
XTAP_TAPCELL_ROW_78_878 VGND VPWR sky130_fd_sc_hd__tapvpwrvgnd_1
XFILLER_35_213 VGND VGND VPWR VPWR sky130_fd_sc_hd__decap_3
XFILLER_35_246 VGND VGND VPWR VPWR sky130_fd_sc_hd__decap_3
XFILLER_50_205 VGND VGND VPWR VPWR sky130_fd_sc_hd__decap_3
X_3961_ _3937_/S input73/X _3926_/B _3966_/S VGND VGND VPWR VPWR _3967_/A sky130_fd_sc_hd__a211oi_2
XFILLER_50_238 VGND VGND VPWR VPWR sky130_fd_sc_hd__decap_3
X_5700_ _5609_/A _5699_/X wire230/X VGND VGND VPWR VPWR _5707_/C sky130_fd_sc_hd__a21o_2
X_3892_ _6062_/D _4111_/A _4473_/A _3891_/X VGND VGND VPWR VPWR _3892_/X sky130_fd_sc_hd__o2bb2a_2
X_5631_ _5658_/A _6374_/B VGND VGND VPWR VPWR _5712_/D sky130_fd_sc_hd__xnor2_2
X_5562_ _5627_/A _5540_/X _5561_/X VGND VGND VPWR VPWR _5982_/B sky130_fd_sc_hd__a21o_2
X_4513_ _4513_/A _4513_/B _4538_/B _4539_/B VGND VGND VPWR VPWR _4513_/X sky130_fd_sc_hd__or4_2
X_5493_ _5493_/A _5493_/B VGND VGND VPWR VPWR _5497_/B sky130_fd_sc_hd__and2_2
X_4444_ _4627_/A _4541_/S VGND VGND VPWR VPWR _4478_/D sky130_fd_sc_hd__xnor2_2
X_4375_ _3627_/X _5485_/B _4373_/X _4842_/B _4842_/A VGND VGND VPWR VPWR _4375_/X
+ sky130_fd_sc_hd__a221o_2
X_6114_ _6114_/A _6114_/B VGND VGND VPWR VPWR _6114_/Y sky130_fd_sc_hd__nor2_2
Xfanout627 _6051_/A VGND VGND VPWR VPWR _5752_/B sky130_fd_sc_hd__clkdlybuf4s25_1
Xfanout638 _6330_/B VGND VGND VPWR VPWR _5530_/A sky130_fd_sc_hd__clkdlybuf4s25_1
Xfanout649 _5508_/A1 VGND VGND VPWR VPWR _5704_/A sky130_fd_sc_hd__clkdlybuf4s25_1
X_3326_ _3233_/X _3234_/X _3324_/X _3325_/X _3572_/S _4026_/S1 VGND VGND VPWR VPWR
+ _4837_/B sky130_fd_sc_hd__mux4_2
XTAP_TAPCELL_ROW_69_801 VGND VPWR sky130_fd_sc_hd__tapvpwrvgnd_1
X_6045_ _6417_/A _6040_/B _5844_/A _6417_/B _6044_/X VGND VGND VPWR VPWR _6045_/Y
+ sky130_fd_sc_hd__o32ai_2
XFILLER_58_349 VGND VGND VPWR VPWR sky130_fd_sc_hd__decap_3
X_3257_ _3361_/D VGND VGND VPWR VPWR _3260_/C sky130_fd_sc_hd__clkbuf_1
XFILLER_26_213 VGND VGND VPWR VPWR sky130_fd_sc_hd__fill_1
XFILLER_26_246 VGND VGND VPWR VPWR sky130_fd_sc_hd__decap_3
XFILLER_26_279 VGND VGND VPWR VPWR sky130_fd_sc_hd__decap_3
XFILLER_41_205 VGND VGND VPWR VPWR sky130_fd_sc_hd__decap_3
XFILLER_41_238 VGND VGND VPWR VPWR sky130_fd_sc_hd__decap_3
XFILLER_34_290 VGND VGND VPWR VPWR sky130_fd_sc_hd__decap_3
X_5829_ _5702_/X _5828_/X _5947_/S VGND VGND VPWR VPWR _5829_/X sky130_fd_sc_hd__mux2_2
XFILLER_49_316 VGND VGND VPWR VPWR sky130_fd_sc_hd__decap_3
XFILLER_49_349 VGND VGND VPWR VPWR sky130_fd_sc_hd__decap_3
XFILLER_17_202 VGND VGND VPWR VPWR sky130_fd_sc_hd__decap_3
XFILLER_17_235 VGND VGND VPWR VPWR sky130_fd_sc_hd__decap_3
XFILLER_72_363 VGND VGND VPWR VPWR sky130_fd_sc_hd__fill_1
XFILLER_60_514 VGND VGND VPWR VPWR sky130_fd_sc_hd__fill_2
XFILLER_40_293 VGND VGND VPWR VPWR sky130_fd_sc_hd__decap_3
XFILLER_9_478 VGND VGND VPWR VPWR sky130_fd_sc_hd__fill_1
X_4160_ _6170_/A _4202_/A _4370_/A _4252_/A VGND VGND VPWR VPWR _4160_/X sky130_fd_sc_hd__o2bb2a_2
XFILLER_67_113 VGND VGND VPWR VPWR sky130_fd_sc_hd__fill_2
X_4091_ _4265_/A _4708_/A _4360_/D VGND VGND VPWR VPWR _4092_/A sky130_fd_sc_hd__or3_4
XFILLER_48_371 VGND VGND VPWR VPWR sky130_fd_sc_hd__fill_1
XFILLER_55_319 VGND VGND VPWR VPWR sky130_fd_sc_hd__decap_3
XTAP_TAPCELL_ROW_38_517 VGND VPWR sky130_fd_sc_hd__tapvpwrvgnd_1
XFILLER_63_330 VGND VGND VPWR VPWR sky130_fd_sc_hd__decap_3
XFILLER_23_216 VGND VGND VPWR VPWR sky130_fd_sc_hd__decap_3
X_4993_ _6265_/B _6270_/A VGND VGND VPWR VPWR _5039_/B sky130_fd_sc_hd__xor2_2
XTAP_TAPCELL_ROW_46_594 VGND VPWR sky130_fd_sc_hd__tapvpwrvgnd_1
XFILLER_63_374 VGND VGND VPWR VPWR sky130_fd_sc_hd__decap_3
X_3944_ _4636_/S _3944_/B VGND VGND VPWR VPWR _3947_/B sky130_fd_sc_hd__nor2_2
X_3875_ _3907_/C _3875_/B VGND VGND VPWR VPWR _3875_/X sky130_fd_sc_hd__and2b_2
X_5614_ _5014_/A _5009_/X _4884_/A VGND VGND VPWR VPWR _5614_/Y sky130_fd_sc_hd__a21oi_2
X_5545_ _5951_/A1 _5544_/Y _5538_/B VGND VGND VPWR VPWR _5545_/X sky130_fd_sc_hd__o21a_2
X_5476_ wire281/X wire282/X _5476_/S VGND VGND VPWR VPWR _5476_/X sky130_fd_sc_hd__mux2_2
X_4427_ _4168_/A _4482_/B _4407_/X _4124_/A _4426_/Y VGND VGND VPWR VPWR _4427_/X
+ sky130_fd_sc_hd__a221o_2
Xfanout402 _3711_/S VGND VGND VPWR VPWR _6100_/C sky130_fd_sc_hd__clkdlybuf4s25_1
Xfanout413 input76/X VGND VGND VPWR VPWR _6162_/A sky130_fd_sc_hd__clkdlybuf4s25_1
XFILLER_48_27 VGND VGND VPWR VPWR sky130_fd_sc_hd__fill_1
Xfanout424 _3706_/S VGND VGND VPWR VPWR _3503_/S0 sky130_fd_sc_hd__clkdlybuf4s25_1
Xfanout435 fanout444/X VGND VGND VPWR VPWR _4026_/S1 sky130_fd_sc_hd__clkdlybuf4s25_1
Xfanout446 input7/X VGND VGND VPWR VPWR _6464_/A1 sky130_fd_sc_hd__clkdlybuf4s25_1
Xfanout457 _4057_/B VGND VGND VPWR VPWR _5590_/A1 sky130_fd_sc_hd__clkdlybuf4s25_1
X_4358_ _4358_/A _4358_/B VGND VGND VPWR VPWR _4709_/C sky130_fd_sc_hd__nor2_2
XFILLER_58_124 VGND VGND VPWR VPWR sky130_fd_sc_hd__decap_3
Xfanout468 input61/X VGND VGND VPWR VPWR _3612_/A sky130_fd_sc_hd__clkdlybuf4s25_1
Xfanout479 input56/X VGND VGND VPWR VPWR _6349_/A sky130_fd_sc_hd__clkdlybuf4s25_1
X_4289_ _4288_/X _4515_/A _6199_/A VGND VGND VPWR VPWR _4289_/X sky130_fd_sc_hd__mux2_2
X_3309_ _3308_/X _3748_/B _3451_/S VGND VGND VPWR VPWR _3309_/X sky130_fd_sc_hd__mux2_2
XFILLER_39_371 VGND VGND VPWR VPWR sky130_fd_sc_hd__decap_3
X_6028_ _6339_/A _6322_/A _6337_/A _6337_/B VGND VGND VPWR VPWR _6330_/D sky130_fd_sc_hd__and4_2
XFILLER_39_393 VGND VGND VPWR VPWR sky130_fd_sc_hd__decap_3
XFILLER_54_352 VGND VGND VPWR VPWR sky130_fd_sc_hd__decap_3
XTAP_TAPCELL_ROW_72_829 VGND VPWR sky130_fd_sc_hd__tapvpwrvgnd_1
XFILLER_42_514 VGND VGND VPWR VPWR sky130_fd_sc_hd__fill_2
XTAP_TAPCELL_ROW_1_186 VGND VPWR sky130_fd_sc_hd__tapvpwrvgnd_1
XFILLER_14_249 VGND VGND VPWR VPWR sky130_fd_sc_hd__decap_3
XTAP_TAPCELL_ROW_80_895 VGND VPWR sky130_fd_sc_hd__tapvpwrvgnd_1
XTAP_TAPCELL_ROW_9_264 VGND VPWR sky130_fd_sc_hd__tapvpwrvgnd_1
XFILLER_49_113 VGND VGND VPWR VPWR sky130_fd_sc_hd__decap_3
XFILLER_77_411 VGND VGND VPWR VPWR sky130_fd_sc_hd__fill_2
XFILLER_45_363 VGND VGND VPWR VPWR sky130_fd_sc_hd__decap_3
XFILLER_45_396 VGND VGND VPWR VPWR sky130_fd_sc_hd__decap_3
XTAP_TAPCELL_ROW_43_564 VGND VPWR sky130_fd_sc_hd__tapvpwrvgnd_1
X_3660_ _3620_/X _3623_/Y _3635_/Y _3659_/X VGND VGND VPWR VPWR _3660_/X sky130_fd_sc_hd__o211a_2
XFILLER_9_286 VGND VGND VPWR VPWR sky130_fd_sc_hd__decap_3
X_3591_ _3748_/B _3308_/X _4010_/B VGND VGND VPWR VPWR _3591_/X sky130_fd_sc_hd__mux2_2
XFILLER_55_3 VGND VGND VPWR VPWR sky130_fd_sc_hd__fill_2
X_5330_ _6359_/A _5290_/B _5658_/C _5309_/A _5329_/Y VGND VGND VPWR VPWR _5330_/X
+ sky130_fd_sc_hd__a221o_2
X_5261_ _6492_/A _5302_/B VGND VGND VPWR VPWR _5261_/Y sky130_fd_sc_hd__nor2_2
XFILLER_5_470 VGND VGND VPWR VPWR sky130_fd_sc_hd__decap_3
X_4212_ _4239_/A _6171_/B VGND VGND VPWR VPWR _4267_/B sky130_fd_sc_hd__xnor2_2
X_5192_ _5131_/B _5191_/Y _5274_/B VGND VGND VPWR VPWR _5192_/X sky130_fd_sc_hd__o21a_2
X_4143_ _5216_/A _4143_/B VGND VGND VPWR VPWR _4143_/Y sky130_fd_sc_hd__nor2_2
XFILLER_55_116 VGND VGND VPWR VPWR sky130_fd_sc_hd__decap_3
X_4074_ _3745_/B _4447_/A _4447_/B _4073_/X VGND VGND VPWR VPWR _4075_/B sky130_fd_sc_hd__a31o_2
XFILLER_55_138 VGND VGND VPWR VPWR sky130_fd_sc_hd__decap_3
XFILLER_36_363 VGND VGND VPWR VPWR sky130_fd_sc_hd__fill_1
XFILLER_36_385 VGND VGND VPWR VPWR sky130_fd_sc_hd__decap_3
XFILLER_51_322 VGND VGND VPWR VPWR sky130_fd_sc_hd__decap_3
XFILLER_51_355 VGND VGND VPWR VPWR sky130_fd_sc_hd__decap_3
XFILLER_63_193 VGND VGND VPWR VPWR sky130_fd_sc_hd__decap_3
XFILLER_11_219 VGND VGND VPWR VPWR sky130_fd_sc_hd__fill_1
XFILLER_51_377 VGND VGND VPWR VPWR sky130_fd_sc_hd__decap_3
X_4976_ _5193_/A _4776_/B _5123_/A VGND VGND VPWR VPWR _5004_/B sky130_fd_sc_hd__a21o_2
X_3927_ _4001_/A _3927_/B VGND VGND VPWR VPWR _4360_/A sky130_fd_sc_hd__xnor2_2
X_3858_ _3921_/A _3858_/B VGND VGND VPWR VPWR _4006_/C sky130_fd_sc_hd__xnor2_2
X_3789_ _6088_/A _3641_/B _4241_/B _3786_/X _3788_/X VGND VGND VPWR VPWR _3789_/X
+ sky130_fd_sc_hd__a221o_2
X_5528_ _5530_/A _5493_/A _6330_/A VGND VGND VPWR VPWR _5528_/X sky130_fd_sc_hd__a21o_2
X_5459_ _5459_/A _5459_/B VGND VGND VPWR VPWR _5467_/B sky130_fd_sc_hd__nor2_2
XTAP_TAPCELL_ROW_6_234 VGND VPWR sky130_fd_sc_hd__tapvpwrvgnd_1
XFILLER_19_319 VGND VGND VPWR VPWR sky130_fd_sc_hd__decap_3
XFILLER_27_396 VGND VGND VPWR VPWR sky130_fd_sc_hd__decap_3
XFILLER_42_300 VGND VGND VPWR VPWR sky130_fd_sc_hd__decap_3
XFILLER_54_160 VGND VGND VPWR VPWR sky130_fd_sc_hd__fill_2
XTAP_TAPCELL_ROW_57_689 VGND VPWR sky130_fd_sc_hd__tapvpwrvgnd_1
XFILLER_42_333 VGND VGND VPWR VPWR sky130_fd_sc_hd__decap_3
XFILLER_54_193 VGND VGND VPWR VPWR sky130_fd_sc_hd__decap_3
XFILLER_10_241 VGND VGND VPWR VPWR sky130_fd_sc_hd__fill_2
XFILLER_40_83 VGND VGND VPWR VPWR sky130_fd_sc_hd__fill_1
Xload_slew616 _4884_/A VGND VGND VPWR VPWR _5732_/A sky130_fd_sc_hd__clkbuf_4
XFILLER_69_219 VGND VGND VPWR VPWR sky130_fd_sc_hd__decap_3
XTAP_TAPCELL_ROW_48_612 VGND VPWR sky130_fd_sc_hd__tapvpwrvgnd_1
XFILLER_65_447 VGND VGND VPWR VPWR sky130_fd_sc_hd__fill_1
XFILLER_18_363 VGND VGND VPWR VPWR sky130_fd_sc_hd__fill_1
XFILLER_45_193 VGND VGND VPWR VPWR sky130_fd_sc_hd__decap_3
X_4830_ _4829_/X _4789_/B _4791_/A _4849_/C input4/X VGND VGND VPWR VPWR _4830_/X
+ sky130_fd_sc_hd__a311o_2
X_4761_ _4761_/A VGND VGND VPWR VPWR _4761_/X sky130_fd_sc_hd__clkbuf_1
X_6500_ _6477_/A _6490_/X _6499_/X VGND VGND VPWR VPWR _6500_/Y sky130_fd_sc_hd__o21ai_2
X_4692_ _6247_/A _4734_/A VGND VGND VPWR VPWR _4694_/A sky130_fd_sc_hd__or2b_2
X_3712_ _3644_/X _3711_/X _3842_/S VGND VGND VPWR VPWR _3712_/X sky130_fd_sc_hd__mux2_2
X_6431_ _6431_/A0 _6431_/A1 _6470_/S VGND VGND VPWR VPWR _6434_/B sky130_fd_sc_hd__mux2_2
X_3643_ _3949_/S VGND VGND VPWR VPWR _4462_/S sky130_fd_sc_hd__clkbuf_2
X_6362_ _6363_/A _5416_/A _6290_/B _6365_/B _5388_/S VGND VGND VPWR VPWR _6362_/X
+ sky130_fd_sc_hd__o41a_2
XTAP_TAPCELL_ROW_11_280 VGND VPWR sky130_fd_sc_hd__tapvpwrvgnd_1
X_5313_ _6294_/A _6292_/A _5278_/Y _5423_/A _5405_/B VGND VGND VPWR VPWR _5313_/Y
+ sky130_fd_sc_hd__o2111ai_2
X_3574_ _6199_/C _4429_/A _6457_/A1 _6460_/A0 _3695_/S0 _3948_/S1 VGND VGND VPWR VPWR
+ _3574_/X sky130_fd_sc_hd__mux4_2
X_6293_ _6293_/A _6293_/B VGND VGND VPWR VPWR _6294_/B sky130_fd_sc_hd__xnor2_2
X_5244_ _5224_/X wire263/X _6391_/D VGND VGND VPWR VPWR _5244_/X sky130_fd_sc_hd__mux2_2
X_5175_ _4833_/X _5174_/X _5175_/S VGND VGND VPWR VPWR _5175_/X sky130_fd_sc_hd__mux2_2
XFILLER_56_414 VGND VGND VPWR VPWR sky130_fd_sc_hd__decap_3
X_4126_ _4181_/A _6170_/A VGND VGND VPWR VPWR _4251_/C sky130_fd_sc_hd__nand2b_2
XTAP_TAPCELL_ROW_3_204 VGND VPWR sky130_fd_sc_hd__tapvpwrvgnd_1
X_4057_ _4057_/A _4057_/B VGND VGND VPWR VPWR _4057_/Y sky130_fd_sc_hd__nand2_2
XFILLER_24_300 VGND VGND VPWR VPWR sky130_fd_sc_hd__decap_3
XFILLER_43_108 VGND VGND VPWR VPWR sky130_fd_sc_hd__decap_3
XFILLER_43_119 VGND VGND VPWR VPWR sky130_fd_sc_hd__fill_2
XTAP_TAPCELL_ROW_82_924 VGND VPWR sky130_fd_sc_hd__tapvpwrvgnd_1
XTAP_TAPCELL_ROW_82_913 VGND VPWR sky130_fd_sc_hd__tapvpwrvgnd_1
XFILLER_36_193 VGND VGND VPWR VPWR sky130_fd_sc_hd__decap_3
XFILLER_24_377 VGND VGND VPWR VPWR sky130_fd_sc_hd__decap_3
XFILLER_24_399 VGND VGND VPWR VPWR sky130_fd_sc_hd__decap_3
XFILLER_51_196 VGND VGND VPWR VPWR sky130_fd_sc_hd__decap_3
X_4959_ _6265_/A _6077_/C VGND VGND VPWR VPWR _4982_/A sky130_fd_sc_hd__xor2_2
XFILLER_19_105 VGND VGND VPWR VPWR sky130_fd_sc_hd__decap_3
XFILLER_59_263 VGND VGND VPWR VPWR sky130_fd_sc_hd__decap_3
XFILLER_19_116 VGND VGND VPWR VPWR sky130_fd_sc_hd__fill_2
XFILLER_74_222 VGND VGND VPWR VPWR sky130_fd_sc_hd__decap_3
XFILLER_74_211 VGND VGND VPWR VPWR sky130_fd_sc_hd__decap_3
XFILLER_74_200 VGND VGND VPWR VPWR sky130_fd_sc_hd__fill_2
XFILLER_34_119 VGND VGND VPWR VPWR sky130_fd_sc_hd__decap_3
XFILLER_55_480 VGND VGND VPWR VPWR sky130_fd_sc_hd__fill_1
XTAP_TAPCELL_ROW_17_328 VGND VPWR sky130_fd_sc_hd__tapvpwrvgnd_1
XFILLER_15_355 VGND VGND VPWR VPWR sky130_fd_sc_hd__decap_3
XFILLER_42_141 VGND VGND VPWR VPWR sky130_fd_sc_hd__decap_3
XFILLER_15_388 VGND VGND VPWR VPWR sky130_fd_sc_hd__decap_3
XFILLER_15_399 VGND VGND VPWR VPWR sky130_fd_sc_hd__decap_3
XFILLER_42_174 VGND VGND VPWR VPWR sky130_fd_sc_hd__decap_3
Xmax_cap207 _5239_/X VGND VGND VPWR VPWR _5948_/S0 sky130_fd_sc_hd__clkbuf_2
Xmax_cap229 _5609_/X VGND VGND VPWR VPWR _6486_/C sky130_fd_sc_hd__buf_2
Xmax_cap218 _4527_/A VGND VGND VPWR VPWR _5669_/B2 sky130_fd_sc_hd__buf_2
X_3290_ _3367_/B _3735_/A _3369_/B _3367_/A VGND VGND VPWR VPWR _3291_/A sky130_fd_sc_hd__and4b_2
XPHY_EDGE_ROW_29_Left_112 VGND VGND VPWR VPWR sky130_fd_sc_hd__decap_3
XFILLER_18_3 VGND VGND VPWR VPWR sky130_fd_sc_hd__decap_3
XFILLER_53_428 VGND VGND VPWR VPWR sky130_fd_sc_hd__fill_1
X_5931_ _5932_/A _5932_/B VGND VGND VPWR VPWR _5935_/C sky130_fd_sc_hd__nor2_2
XFILLER_18_182 VGND VGND VPWR VPWR sky130_fd_sc_hd__fill_1
XFILLER_80_247 VGND VGND VPWR VPWR sky130_fd_sc_hd__decap_3
XFILLER_33_152 VGND VGND VPWR VPWR sky130_fd_sc_hd__decap_3
X_5862_ _6040_/A _5970_/B VGND VGND VPWR VPWR _5862_/Y sky130_fd_sc_hd__nand2_2
XPHY_EDGE_ROW_38_Left_121 VGND VGND VPWR VPWR sky130_fd_sc_hd__decap_3
XFILLER_21_325 VGND VGND VPWR VPWR sky130_fd_sc_hd__decap_3
X_5793_ _6050_/A _6033_/B _5792_/X VGND VGND VPWR VPWR _5818_/C sky130_fd_sc_hd__a21o_2
X_4813_ _4813_/A VGND VGND VPWR VPWR _4813_/X sky130_fd_sc_hd__clkbuf_1
X_4744_ _5263_/A _5624_/A VGND VGND VPWR VPWR _4745_/B sky130_fd_sc_hd__nor2_2
X_4675_ _4695_/A _4679_/A _4599_/A _6457_/A1 _4675_/S0 _4675_/S1 VGND VGND VPWR VPWR
+ _4675_/X sky130_fd_sc_hd__mux4_2
X_6414_ _6417_/A _6417_/B VGND VGND VPWR VPWR _6414_/Y sky130_fd_sc_hd__xnor2_2
X_3626_ _3970_/A _3624_/X _3625_/X _3750_/A VGND VGND VPWR VPWR _3626_/X sky130_fd_sc_hd__o211a_2
X_6345_ _6346_/A _6344_/Y _6346_/B _5637_/A VGND VGND VPWR VPWR _6345_/X sky130_fd_sc_hd__a211o_2
X_3557_ _3553_/X _3556_/X _3559_/D VGND VGND VPWR VPWR _3557_/Y sky130_fd_sc_hd__a21oi_2
XPHY_EDGE_ROW_47_Left_130 VGND VGND VPWR VPWR sky130_fd_sc_hd__decap_3
X_6276_ _6275_/A _6271_/X _6275_/B _6080_/A VGND VGND VPWR VPWR _6276_/X sky130_fd_sc_hd__a211o_2
Xinput108 operand_b[44] VGND VGND VPWR VPWR _5406_/A2 sky130_fd_sc_hd__clkdlybuf4s25_1
X_5227_ _5200_/B _5477_/A _4946_/A _5223_/X _5226_/X VGND VGND VPWR VPWR _5227_/X
+ sky130_fd_sc_hd__a221o_2
X_3488_ _3489_/A _3538_/B VGND VGND VPWR VPWR _3488_/X sky130_fd_sc_hd__or2_2
Xinput119 operand_b[54] VGND VGND VPWR VPWR input119/X sky130_fd_sc_hd__clkdlybuf4s25_1
XTAP_TAPCELL_ROW_59_707 VGND VPWR sky130_fd_sc_hd__tapvpwrvgnd_1
XFILLER_56_200 VGND VGND VPWR VPWR sky130_fd_sc_hd__decap_3
X_5158_ _5180_/A _6391_/B VGND VGND VPWR VPWR _5159_/A sky130_fd_sc_hd__nor2b_2
XFILLER_29_447 VGND VGND VPWR VPWR sky130_fd_sc_hd__fill_1
XFILLER_56_233 VGND VGND VPWR VPWR sky130_fd_sc_hd__decap_3
X_5089_ _5085_/Y _5087_/Y _5089_/S VGND VGND VPWR VPWR _5089_/X sky130_fd_sc_hd__mux2_2
X_4109_ _4200_/A _4199_/A _4109_/S VGND VGND VPWR VPWR _4109_/X sky130_fd_sc_hd__mux2_2
XFILLER_44_417 VGND VGND VPWR VPWR sky130_fd_sc_hd__decap_3
XTAP_TAPCELL_ROW_67_784 VGND VPWR sky130_fd_sc_hd__tapvpwrvgnd_1
XFILLER_71_225 VGND VGND VPWR VPWR sky130_fd_sc_hd__fill_1
XTAP_TAPCELL_ROW_14_309 VGND VPWR sky130_fd_sc_hd__tapvpwrvgnd_1
XFILLER_12_325 VGND VGND VPWR VPWR sky130_fd_sc_hd__decap_3
XTAP_TAPCELL_ROW_22_375 VGND VPWR sky130_fd_sc_hd__tapvpwrvgnd_1
XFILLER_79_358 VGND VGND VPWR VPWR sky130_fd_sc_hd__fill_1
XFILLER_47_211 VGND VGND VPWR VPWR sky130_fd_sc_hd__decap_3
XFILLER_47_255 VGND VGND VPWR VPWR sky130_fd_sc_hd__decap_3
XFILLER_62_214 VGND VGND VPWR VPWR sky130_fd_sc_hd__decap_3
XFILLER_30_144 VGND VGND VPWR VPWR sky130_fd_sc_hd__decap_3
XFILLER_30_177 VGND VGND VPWR VPWR sky130_fd_sc_hd__decap_3
XFILLER_7_340 VGND VGND VPWR VPWR sky130_fd_sc_hd__fill_1
Xwire271 _3743_/Y VGND VGND VPWR VPWR _3744_/B sky130_fd_sc_hd__clkbuf_2
Xwire282 _4940_/X VGND VGND VPWR VPWR wire282/X sky130_fd_sc_hd__buf_2
X_4460_ _4413_/X _4459_/X _4460_/S VGND VGND VPWR VPWR _4460_/X sky130_fd_sc_hd__mux2_2
X_4391_ _4339_/X _4371_/X _4375_/X _4384_/Y _4390_/Y VGND VGND VPWR VPWR _4391_/X
+ sky130_fd_sc_hd__a221o_2
X_3411_ _3411_/A1 _3409_/X _3410_/X VGND VGND VPWR VPWR _3411_/X sky130_fd_sc_hd__a21o_2
X_6130_ _6128_/Y _6129_/Y _6130_/S VGND VGND VPWR VPWR _6130_/X sky130_fd_sc_hd__mux2_2
X_3342_ _3410_/B _3344_/C _3339_/Y _3486_/C VGND VGND VPWR VPWR _3342_/X sky130_fd_sc_hd__a31o_2
X_6061_ _6189_/A _6061_/B _6061_/C _6061_/D VGND VGND VPWR VPWR _6067_/B sky130_fd_sc_hd__and4_2
X_3273_ _6460_/A0 _6460_/A3 _6460_/A1 _6460_/A2 _4025_/S1 _3575_/S0 VGND VGND VPWR
+ VPWR _3273_/X sky130_fd_sc_hd__mux4_2
XFILLER_38_200 VGND VGND VPWR VPWR sky130_fd_sc_hd__decap_3
X_5012_ _6486_/A _6486_/B _5012_/C _5012_/D VGND VGND VPWR VPWR _5012_/X sky130_fd_sc_hd__and4_2
XFILLER_38_244 VGND VGND VPWR VPWR sky130_fd_sc_hd__decap_3
XFILLER_26_417 VGND VGND VPWR VPWR sky130_fd_sc_hd__decap_3
X_5914_ _6497_/A _6496_/D VGND VGND VPWR VPWR _5914_/Y sky130_fd_sc_hd__nor2_2
XTAP_TAPCELL_ROW_64_754 VGND VPWR sky130_fd_sc_hd__tapvpwrvgnd_1
X_5845_ _5874_/A _5809_/B _5817_/S _5847_/B _5869_/A VGND VGND VPWR VPWR _5852_/A
+ sky130_fd_sc_hd__o2111ai_2
XFILLER_21_188 VGND VGND VPWR VPWR sky130_fd_sc_hd__decap_3
X_5776_ _5768_/X _5769_/X _5775_/X VGND VGND VPWR VPWR _5776_/Y sky130_fd_sc_hd__o21ai_2
X_4727_ _4761_/A _4725_/Y _4726_/X wire227/X VGND VGND VPWR VPWR _4727_/X sky130_fd_sc_hd__a22o_2
X_4658_ _4695_/A _6061_/B VGND VGND VPWR VPWR _4659_/B sky130_fd_sc_hd__or2b_2
Xinput90 operand_b[28] VGND VGND VPWR VPWR input90/X sky130_fd_sc_hd__clkdlybuf4s25_1
X_3609_ _3667_/B _3558_/B _3558_/C _3608_/Y VGND VGND VPWR VPWR _3615_/A sky130_fd_sc_hd__o31ai_2
X_4589_ _6193_/S _6233_/A VGND VGND VPWR VPWR _4589_/X sky130_fd_sc_hd__or2_2
X_6328_ _6332_/B _6346_/B VGND VGND VPWR VPWR _6328_/Y sky130_fd_sc_hd__nor2_2
X_6259_ _6071_/B _6312_/C _4821_/A VGND VGND VPWR VPWR _6259_/Y sky130_fd_sc_hd__a21oi_2
XFILLER_29_200 VGND VGND VPWR VPWR sky130_fd_sc_hd__decap_3
XFILLER_29_222 VGND VGND VPWR VPWR sky130_fd_sc_hd__fill_2
XFILLER_17_417 VGND VGND VPWR VPWR sky130_fd_sc_hd__fill_1
XFILLER_29_277 VGND VGND VPWR VPWR sky130_fd_sc_hd__decap_3
XFILLER_44_203 VGND VGND VPWR VPWR sky130_fd_sc_hd__decap_3
XFILLER_44_247 VGND VGND VPWR VPWR sky130_fd_sc_hd__decap_3
XTAP_TAPCELL_ROW_27_423 VGND VPWR sky130_fd_sc_hd__tapvpwrvgnd_1
XFILLER_12_111 VGND VGND VPWR VPWR sky130_fd_sc_hd__decap_3
XFILLER_16_74 VGND VGND VPWR VPWR sky130_fd_sc_hd__fill_1
XFILLER_16_85 VGND VGND VPWR VPWR sky130_fd_sc_hd__decap_3
XPHY_EDGE_ROW_11_Right_11 VGND VGND VPWR VPWR sky130_fd_sc_hd__decap_3
XFILLER_8_126 VGND VGND VPWR VPWR sky130_fd_sc_hd__fill_1
XFILLER_8_115 VGND VGND VPWR VPWR sky130_fd_sc_hd__fill_2
XFILLER_4_343 VGND VGND VPWR VPWR sky130_fd_sc_hd__fill_2
XFILLER_4_365 VGND VGND VPWR VPWR sky130_fd_sc_hd__fill_2
XPHY_EDGE_ROW_20_Right_20 VGND VGND VPWR VPWR sky130_fd_sc_hd__decap_3
XTAP_TAPCELL_ROW_78_879 VGND VPWR sky130_fd_sc_hd__tapvpwrvgnd_1
XFILLER_35_225 VGND VGND VPWR VPWR sky130_fd_sc_hd__decap_3
XFILLER_35_269 VGND VGND VPWR VPWR sky130_fd_sc_hd__fill_2
X_3960_ _3960_/A _4360_/A _4006_/C _3928_/D VGND VGND VPWR VPWR _4709_/A sky130_fd_sc_hd__or4b_4
XFILLER_50_217 VGND VGND VPWR VPWR sky130_fd_sc_hd__decap_3
XTAP_TAPCELL_ROW_61_724 VGND VPWR sky130_fd_sc_hd__tapvpwrvgnd_1
XFILLER_43_291 VGND VGND VPWR VPWR sky130_fd_sc_hd__decap_3
X_3891_ _6062_/D _3908_/A VGND VGND VPWR VPWR _3891_/X sky130_fd_sc_hd__or2b_2
XFILLER_31_475 VGND VGND VPWR VPWR sky130_fd_sc_hd__decap_3
X_5630_ _5630_/A VGND VGND VPWR VPWR _6003_/A sky130_fd_sc_hd__buf_1
X_5561_ _5396_/A _5543_/X _5545_/X _5560_/X VGND VGND VPWR VPWR _5561_/X sky130_fd_sc_hd__a211o_2
X_5492_ _5434_/A _5434_/B _5434_/C _5530_/C VGND VGND VPWR VPWR _5493_/B sky130_fd_sc_hd__a31o_2
X_4512_ _6492_/A _4541_/S _4627_/B _4512_/D VGND VGND VPWR VPWR _4512_/X sky130_fd_sc_hd__or4_2
X_4443_ _4443_/A _4443_/B VGND VGND VPWR VPWR _4541_/S sky130_fd_sc_hd__nand2_2
X_4374_ _4374_/A VGND VGND VPWR VPWR _4842_/B sky130_fd_sc_hd__clkbuf_1
X_6113_ _6113_/A _6113_/B _6113_/C VGND VGND VPWR VPWR _6121_/S sky130_fd_sc_hd__and3_2
Xfanout617 input125/X VGND VGND VPWR VPWR _4568_/A1 sky130_fd_sc_hd__clkdlybuf4s25_1
Xfanout628 input121/X VGND VGND VPWR VPWR _6051_/A sky130_fd_sc_hd__clkdlybuf4s25_1
Xfanout639 input115/X VGND VGND VPWR VPWR _6330_/B sky130_fd_sc_hd__clkdlybuf4s25_1
X_3325_ _6447_/A1 _6450_/A0 _6450_/A1 _6446_/A0 _3584_/S0 _3895_/A2 VGND VGND VPWR
+ VPWR _3325_/X sky130_fd_sc_hd__mux4_2
XTAP_TAPCELL_ROW_69_802 VGND VPWR sky130_fd_sc_hd__tapvpwrvgnd_1
XFILLER_58_306 VGND VGND VPWR VPWR sky130_fd_sc_hd__fill_2
X_6044_ _6040_/B _5844_/A _5849_/B VGND VGND VPWR VPWR _6044_/X sky130_fd_sc_hd__o21a_2
X_3256_ _3735_/A VGND VGND VPWR VPWR _3361_/D sky130_fd_sc_hd__inv_2
XFILLER_66_361 VGND VGND VPWR VPWR sky130_fd_sc_hd__decap_3
X_5828_ _5946_/A3 _5874_/A _6050_/A _6428_/A0 _5963_/S0 _5963_/S1 VGND VGND VPWR VPWR
+ _5828_/X sky130_fd_sc_hd__mux4_2
X_5759_ _5734_/S _5723_/B _5723_/C _5770_/S _5758_/X VGND VGND VPWR VPWR _5760_/C
+ sky130_fd_sc_hd__a41o_2
XTAP_TAPCELL_ROW_32_470 VGND VPWR sky130_fd_sc_hd__tapvpwrvgnd_1
XFILLER_1_335 VGND VGND VPWR VPWR sky130_fd_sc_hd__fill_1
XFILLER_49_328 VGND VGND VPWR VPWR sky130_fd_sc_hd__decap_3
XFILLER_64_309 VGND VGND VPWR VPWR sky130_fd_sc_hd__decap_3
XFILLER_57_372 VGND VGND VPWR VPWR sky130_fd_sc_hd__decap_3
XFILLER_17_225 VGND VGND VPWR VPWR sky130_fd_sc_hd__decap_3
XFILLER_32_206 VGND VGND VPWR VPWR sky130_fd_sc_hd__decap_3
XFILLER_72_386 VGND VGND VPWR VPWR sky130_fd_sc_hd__fill_2
XFILLER_40_261 VGND VGND VPWR VPWR sky130_fd_sc_hd__decap_3
XFILLER_43_61 VGND VGND VPWR VPWR sky130_fd_sc_hd__decap_3
X_4090_ _4708_/B _4048_/A VGND VGND VPWR VPWR _4360_/D sky130_fd_sc_hd__or2b_2
XTAP_TAPCELL_ROW_38_518 VGND VPWR sky130_fd_sc_hd__tapvpwrvgnd_1
XFILLER_82_139 VGND VGND VPWR VPWR sky130_fd_sc_hd__fill_1
XFILLER_63_353 VGND VGND VPWR VPWR sky130_fd_sc_hd__decap_3
XFILLER_23_228 VGND VGND VPWR VPWR sky130_fd_sc_hd__fill_1
X_4992_ _4527_/A _4953_/X _4962_/X _4991_/X VGND VGND VPWR VPWR _6000_/C sky130_fd_sc_hd__a31o_2
X_3943_ _3222_/X _3503_/X _3499_/X _3504_/X _3949_/S _4139_/S VGND VGND VPWR VPWR
+ _3944_/B sky130_fd_sc_hd__mux4_2
XTAP_TAPCELL_ROW_46_595 VGND VPWR sky130_fd_sc_hd__tapvpwrvgnd_1
X_3874_ _3826_/A _6126_/B _6062_/C _6130_/S VGND VGND VPWR VPWR _3875_/B sky130_fd_sc_hd__a22oi_2
X_5613_ _3594_/B _3592_/X _5375_/X VGND VGND VPWR VPWR _5613_/X sky130_fd_sc_hd__a21o_2
X_5544_ _5628_/A _5572_/C VGND VGND VPWR VPWR _5544_/Y sky130_fd_sc_hd__nor2_2
X_5475_ _6485_/A _6322_/A VGND VGND VPWR VPWR _5475_/Y sky130_fd_sc_hd__nor2_2
X_4426_ _4211_/A _4412_/X _4425_/X VGND VGND VPWR VPWR _4426_/Y sky130_fd_sc_hd__o21ai_2
Xfanout414 input75/X VGND VGND VPWR VPWR _6158_/A sky130_fd_sc_hd__clkdlybuf4s25_1
Xfanout436 fanout444/X VGND VGND VPWR VPWR _3800_/A sky130_fd_sc_hd__clkdlybuf4s25_1
Xfanout447 input69/X VGND VGND VPWR VPWR _3812_/A sky130_fd_sc_hd__clkdlybuf4s25_1
X_4357_ _4355_/X _4356_/Y _4357_/S VGND VGND VPWR VPWR _4358_/B sky130_fd_sc_hd__mux2_2
Xfanout458 input65/X VGND VGND VPWR VPWR _4057_/B sky130_fd_sc_hd__clkdlybuf4s25_1
Xfanout469 _5946_/A3 VGND VGND VPWR VPWR _5866_/A sky130_fd_sc_hd__clkdlybuf4s25_1
X_4288_ _4288_/A VGND VGND VPWR VPWR _4288_/X sky130_fd_sc_hd__clkbuf_1
X_3308_ _6431_/A1 _5962_/A _6429_/A VGND VGND VPWR VPWR _3308_/X sky130_fd_sc_hd__mux2_2
XFILLER_58_147 VGND VGND VPWR VPWR sky130_fd_sc_hd__decap_3
XFILLER_46_309 VGND VGND VPWR VPWR sky130_fd_sc_hd__decap_3
X_6027_ _6312_/B _6250_/B _6078_/C VGND VGND VPWR VPWR _6337_/B sky130_fd_sc_hd__and3_2
X_3239_ _6453_/A _3239_/B VGND VGND VPWR VPWR _3239_/X sky130_fd_sc_hd__or2_2
XTAP_TAPCELL_ROW_1_187 VGND VPWR sky130_fd_sc_hd__tapvpwrvgnd_1
XTAP_TAPCELL_ROW_80_896 VGND VPWR sky130_fd_sc_hd__tapvpwrvgnd_1
XFILLER_22_283 VGND VGND VPWR VPWR sky130_fd_sc_hd__decap_3
XFILLER_49_125 VGND VGND VPWR VPWR sky130_fd_sc_hd__fill_1
XFILLER_37_309 VGND VGND VPWR VPWR sky130_fd_sc_hd__decap_3
XFILLER_38_50 VGND VGND VPWR VPWR sky130_fd_sc_hd__fill_1
XFILLER_49_158 VGND VGND VPWR VPWR sky130_fd_sc_hd__fill_2
XFILLER_49_169 VGND VGND VPWR VPWR sky130_fd_sc_hd__fill_2
XFILLER_45_320 VGND VGND VPWR VPWR sky130_fd_sc_hd__decap_3
XFILLER_64_139 VGND VGND VPWR VPWR sky130_fd_sc_hd__fill_1
XFILLER_45_375 VGND VGND VPWR VPWR sky130_fd_sc_hd__decap_3
XFILLER_60_312 VGND VGND VPWR VPWR sky130_fd_sc_hd__decap_3
XTAP_TAPCELL_ROW_43_565 VGND VPWR sky130_fd_sc_hd__tapvpwrvgnd_1
X_3590_ _3780_/A _3590_/B VGND VGND VPWR VPWR _4010_/B sky130_fd_sc_hd__nor2_2
X_5260_ _5685_/A _5302_/B VGND VGND VPWR VPWR _5260_/X sky130_fd_sc_hd__and2_2
X_4211_ _4211_/A _4211_/B VGND VGND VPWR VPWR _4217_/C sky130_fd_sc_hd__or2_2
X_5191_ _5191_/A _5191_/B VGND VGND VPWR VPWR _5191_/Y sky130_fd_sc_hd__nor2_2
X_4142_ _3790_/X _3792_/X _4137_/X _4139_/X _4674_/S _6106_/A VGND VGND VPWR VPWR
+ _4143_/B sky130_fd_sc_hd__mux4_2
X_4073_ _4069_/B _4070_/Y _4072_/X VGND VGND VPWR VPWR _4073_/X sky130_fd_sc_hd__a21o_2
XFILLER_36_320 VGND VGND VPWR VPWR sky130_fd_sc_hd__decap_3
XFILLER_48_180 VGND VGND VPWR VPWR sky130_fd_sc_hd__decap_3
XFILLER_36_397 VGND VGND VPWR VPWR sky130_fd_sc_hd__decap_3
XFILLER_51_334 VGND VGND VPWR VPWR sky130_fd_sc_hd__fill_2
X_4975_ _4975_/A _4975_/B _4975_/C _4975_/D VGND VGND VPWR VPWR _5123_/A sky130_fd_sc_hd__or4_2
XFILLER_51_389 VGND VGND VPWR VPWR sky130_fd_sc_hd__decap_3
X_3926_ _3926_/A _3926_/B VGND VGND VPWR VPWR _3927_/B sky130_fd_sc_hd__nand2_2
X_3857_ _3776_/A _3776_/B _3855_/X _3856_/Y _3731_/X VGND VGND VPWR VPWR _3960_/A
+ sky130_fd_sc_hd__a2111o_2
X_3788_ _3638_/A _6126_/B _3787_/X VGND VGND VPWR VPWR _3788_/X sky130_fd_sc_hd__o21a_2
X_5527_ _5434_/A _5526_/X _5530_/C _6330_/A VGND VGND VPWR VPWR _5527_/X sky130_fd_sc_hd__a211o_2
X_5458_ _5458_/A _5501_/B VGND VGND VPWR VPWR _5458_/X sky130_fd_sc_hd__and2_2
X_5389_ _5348_/A _6319_/B _5388_/X VGND VGND VPWR VPWR _5389_/X sky130_fd_sc_hd__o21a_2
X_4409_ _4469_/A _6059_/B VGND VGND VPWR VPWR _4409_/Y sky130_fd_sc_hd__nor2_2
XTAP_TAPCELL_ROW_6_235 VGND VPWR sky130_fd_sc_hd__tapvpwrvgnd_1
XFILLER_39_180 VGND VGND VPWR VPWR sky130_fd_sc_hd__decap_3
XFILLER_54_150 VGND VGND VPWR VPWR sky130_fd_sc_hd__decap_3
XFILLER_42_323 VGND VGND VPWR VPWR sky130_fd_sc_hd__fill_1
XFILLER_42_345 VGND VGND VPWR VPWR sky130_fd_sc_hd__decap_3
XTAP_TAPCELL_ROW_40_535 VGND VPWR sky130_fd_sc_hd__tapvpwrvgnd_1
XFILLER_10_220 VGND VGND VPWR VPWR sky130_fd_sc_hd__fill_2
XFILLER_10_264 VGND VGND VPWR VPWR sky130_fd_sc_hd__fill_1
XFILLER_10_286 VGND VGND VPWR VPWR sky130_fd_sc_hd__decap_3
XFILLER_6_235 VGND VGND VPWR VPWR sky130_fd_sc_hd__fill_1
XFILLER_40_62 VGND VGND VPWR VPWR sky130_fd_sc_hd__fill_1
XFILLER_77_231 VGND VGND VPWR VPWR sky130_fd_sc_hd__decap_3
XFILLER_77_220 VGND VGND VPWR VPWR sky130_fd_sc_hd__decap_3
XFILLER_49_93 VGND VGND VPWR VPWR sky130_fd_sc_hd__decap_3
XFILLER_37_128 VGND VGND VPWR VPWR sky130_fd_sc_hd__fill_2
XTAP_TAPCELL_ROW_48_613 VGND VPWR sky130_fd_sc_hd__tapvpwrvgnd_1
XFILLER_18_386 VGND VGND VPWR VPWR sky130_fd_sc_hd__decap_3
XFILLER_45_172 VGND VGND VPWR VPWR sky130_fd_sc_hd__decap_3
XFILLER_33_378 VGND VGND VPWR VPWR sky130_fd_sc_hd__decap_3
X_4760_ _4054_/X _4759_/X _5176_/S VGND VGND VPWR VPWR _4760_/X sky130_fd_sc_hd__mux2_2
XFILLER_60_197 VGND VGND VPWR VPWR sky130_fd_sc_hd__decap_3
XFILLER_60_175 VGND VGND VPWR VPWR sky130_fd_sc_hd__decap_3
X_4691_ _4320_/A _4967_/B _4669_/X _4312_/A _4690_/Y VGND VGND VPWR VPWR _4691_/X
+ sky130_fd_sc_hd__a221o_2
X_3711_ _3664_/A _3600_/B _3711_/S VGND VGND VPWR VPWR _3711_/X sky130_fd_sc_hd__mux2_2
X_6430_ _4674_/S _5962_/A _6472_/S _6429_/X VGND VGND VPWR VPWR _6430_/X sky130_fd_sc_hd__o31a_2
X_3642_ _4473_/A _3637_/Y _3638_/Y _3639_/X _3641_/Y VGND VGND VPWR VPWR _3642_/X
+ sky130_fd_sc_hd__o221a_2
X_6361_ _5328_/S _6357_/X _6360_/X VGND VGND VPWR VPWR _6365_/B sky130_fd_sc_hd__o21ai_2
XTAP_TAPCELL_ROW_11_281 VGND VPWR sky130_fd_sc_hd__tapvpwrvgnd_1
X_5312_ _6294_/A _6292_/A _5118_/X _5423_/A _5405_/B VGND VGND VPWR VPWR _5318_/B
+ sky130_fd_sc_hd__a2111o_2
X_3573_ _6460_/A1 _6447_/A0 _6447_/A1 _6450_/A0 _3575_/S0 _3575_/S1 VGND VGND VPWR
+ VPWR _3573_/X sky130_fd_sc_hd__mux4_2
XPHY_EDGE_ROW_49_Right_49 VGND VGND VPWR VPWR sky130_fd_sc_hd__decap_3
X_6292_ _6292_/A _6293_/B VGND VGND VPWR VPWR _6359_/B sky130_fd_sc_hd__or2_2
X_5243_ _3899_/X _5090_/B _5904_/A3 _3902_/Y VGND VGND VPWR VPWR _5243_/X sky130_fd_sc_hd__a2bb2o_2
XFILLER_29_19 VGND VGND VPWR VPWR sky130_fd_sc_hd__fill_1
X_5174_ _5008_/X _5173_/X _5662_/S VGND VGND VPWR VPWR _5174_/X sky130_fd_sc_hd__mux2_2
XFILLER_68_231 VGND VGND VPWR VPWR sky130_fd_sc_hd__decap_3
X_4125_ _6170_/A _4181_/A VGND VGND VPWR VPWR _4252_/A sky130_fd_sc_hd__nand2b_2
XTAP_TAPCELL_ROW_3_205 VGND VPWR sky130_fd_sc_hd__tapvpwrvgnd_1
XFILLER_68_253 VGND VGND VPWR VPWR sky130_fd_sc_hd__decap_3
XFILLER_28_128 VGND VGND VPWR VPWR sky130_fd_sc_hd__decap_3
X_4056_ _3226_/X _3631_/X _3705_/X _3624_/X _4460_/S _3592_/S VGND VGND VPWR VPWR
+ _4056_/X sky130_fd_sc_hd__mux4_2
XPHY_EDGE_ROW_58_Right_58 VGND VGND VPWR VPWR sky130_fd_sc_hd__decap_3
XTAP_TAPCELL_ROW_82_925 VGND VPWR sky130_fd_sc_hd__tapvpwrvgnd_1
XTAP_TAPCELL_ROW_82_914 VGND VPWR sky130_fd_sc_hd__tapvpwrvgnd_1
XFILLER_24_345 VGND VGND VPWR VPWR sky130_fd_sc_hd__fill_1
XFILLER_51_164 VGND VGND VPWR VPWR sky130_fd_sc_hd__decap_3
X_4958_ _5429_/A _5429_/B _5110_/A _4782_/A VGND VGND VPWR VPWR _4997_/C sky130_fd_sc_hd__o22a_2
X_4889_ _5178_/A _6077_/A _4888_/X VGND VGND VPWR VPWR _4889_/X sky130_fd_sc_hd__o21a_2
X_3909_ input8/X _6062_/D VGND VGND VPWR VPWR _3909_/Y sky130_fd_sc_hd__nand2_2
XPHY_EDGE_ROW_67_Right_67 VGND VGND VPWR VPWR sky130_fd_sc_hd__decap_3
XFILLER_59_231 VGND VGND VPWR VPWR sky130_fd_sc_hd__decap_3
XFILLER_59_220 VGND VGND VPWR VPWR sky130_fd_sc_hd__decap_3
XPHY_EDGE_ROW_76_Right_76 VGND VGND VPWR VPWR sky130_fd_sc_hd__decap_3
XFILLER_19_85 VGND VGND VPWR VPWR sky130_fd_sc_hd__fill_1
XFILLER_74_234 VGND VGND VPWR VPWR sky130_fd_sc_hd__decap_3
XFILLER_27_161 VGND VGND VPWR VPWR sky130_fd_sc_hd__decap_3
XFILLER_27_172 VGND VGND VPWR VPWR sky130_fd_sc_hd__decap_3
XFILLER_27_194 VGND VGND VPWR VPWR sky130_fd_sc_hd__decap_3
XFILLER_42_120 VGND VGND VPWR VPWR sky130_fd_sc_hd__decap_3
XTAP_TAPCELL_ROW_17_329 VGND VPWR sky130_fd_sc_hd__tapvpwrvgnd_1
XFILLER_35_62 VGND VGND VPWR VPWR sky130_fd_sc_hd__fill_1
XFILLER_42_153 VGND VGND VPWR VPWR sky130_fd_sc_hd__decap_3
XTAP_TAPCELL_ROW_53_660 VGND VPWR sky130_fd_sc_hd__tapvpwrvgnd_1
XFILLER_30_315 VGND VGND VPWR VPWR sky130_fd_sc_hd__fill_2
XFILLER_30_326 VGND VGND VPWR VPWR sky130_fd_sc_hd__decap_3
XFILLER_42_186 VGND VGND VPWR VPWR sky130_fd_sc_hd__decap_3
XFILLER_42_197 VGND VGND VPWR VPWR sky130_fd_sc_hd__decap_3
XFILLER_51_83 VGND VGND VPWR VPWR sky130_fd_sc_hd__decap_3
Xmax_cap208 _5478_/B VGND VGND VPWR VPWR _5970_/B sky130_fd_sc_hd__buf_2
Xwire497 wire497/A VGND VGND VPWR VPWR _4211_/A sky130_fd_sc_hd__clkbuf_4
Xmax_cap219 _3969_/B VGND VGND VPWR VPWR _4708_/A sky130_fd_sc_hd__buf_2
Xload_slew403 _6100_/C VGND VGND VPWR VPWR _3520_/S sky130_fd_sc_hd__buf_4
Xload_slew425 _3526_/S0 VGND VGND VPWR VPWR _4675_/S0 sky130_fd_sc_hd__buf_2
XFILLER_38_415 VGND VGND VPWR VPWR sky130_fd_sc_hd__decap_3
XFILLER_38_437 VGND VGND VPWR VPWR sky130_fd_sc_hd__decap_3
XFILLER_65_212 VGND VGND VPWR VPWR sky130_fd_sc_hd__decap_3
XFILLER_65_234 VGND VGND VPWR VPWR sky130_fd_sc_hd__decap_3
XFILLER_18_161 VGND VGND VPWR VPWR sky130_fd_sc_hd__decap_3
X_5930_ _5960_/A _6497_/C VGND VGND VPWR VPWR _5930_/Y sky130_fd_sc_hd__xnor2_2
XFILLER_65_267 VGND VGND VPWR VPWR sky130_fd_sc_hd__decap_3
X_5861_ wire282/X wire281/X _5884_/A VGND VGND VPWR VPWR _5861_/X sky130_fd_sc_hd__mux2_2
XFILLER_33_164 VGND VGND VPWR VPWR sky130_fd_sc_hd__decap_3
XFILLER_33_175 VGND VGND VPWR VPWR sky130_fd_sc_hd__decap_3
X_5792_ _6050_/A _6033_/B _5752_/B _5752_/A VGND VGND VPWR VPWR _5792_/X sky130_fd_sc_hd__o211a_2
X_4812_ _4813_/A _4777_/Y _4791_/Y _4526_/A _4811_/Y VGND VGND VPWR VPWR _5999_/B
+ sky130_fd_sc_hd__a221o_2
X_4743_ _4743_/A _5534_/B _4743_/C _5536_/B VGND VGND VPWR VPWR _5624_/A sky130_fd_sc_hd__or4b_4
X_6413_ _6410_/A _6423_/B _6479_/A _6409_/X _6412_/Y VGND VGND VPWR VPWR _6413_/X
+ sky130_fd_sc_hd__a311o_2
X_4674_ _4459_/X _4504_/X _4674_/S VGND VGND VPWR VPWR _4674_/X sky130_fd_sc_hd__mux2_2
X_3625_ _3625_/A _3625_/B VGND VGND VPWR VPWR _3625_/X sky130_fd_sc_hd__or2_2
X_6344_ _6344_/A _6344_/B VGND VGND VPWR VPWR _6344_/Y sky130_fd_sc_hd__nand2_2
X_3556_ _3556_/A _3558_/B _3558_/C _3679_/C VGND VGND VPWR VPWR _3556_/X sky130_fd_sc_hd__or4b_2
X_6275_ _6275_/A _6275_/B _6275_/C _6275_/D VGND VGND VPWR VPWR _6275_/X sky130_fd_sc_hd__or4_2
Xinput109 operand_b[45] VGND VGND VPWR VPWR _5406_/B1 sky130_fd_sc_hd__clkdlybuf4s25_1
X_5226_ _5348_/A _5200_/B _5225_/X VGND VGND VPWR VPWR _5226_/X sky130_fd_sc_hd__o21a_2
X_3487_ _3479_/A _3479_/C _3486_/Y VGND VGND VPWR VPWR _3538_/B sky130_fd_sc_hd__a21oi_2
XTAP_TAPCELL_ROW_59_708 VGND VPWR sky130_fd_sc_hd__tapvpwrvgnd_1
XFILLER_56_212 VGND VGND VPWR VPWR sky130_fd_sc_hd__decap_3
X_5157_ _6391_/B _6306_/C VGND VGND VPWR VPWR _5160_/A sky130_fd_sc_hd__or2b_2
XFILLER_56_245 VGND VGND VPWR VPWR sky130_fd_sc_hd__decap_3
XFILLER_56_256 VGND VGND VPWR VPWR sky130_fd_sc_hd__decap_3
X_5088_ _6270_/B _4962_/A _5030_/B _5034_/S VGND VGND VPWR VPWR _5089_/S sky130_fd_sc_hd__a31o_2
X_4108_ _6167_/A VGND VGND VPWR VPWR _4109_/S sky130_fd_sc_hd__inv_2
X_4039_ _4049_/S _6162_/A VGND VGND VPWR VPWR _4076_/D sky130_fd_sc_hd__xor2_2
XTAP_TAPCELL_ROW_67_785 VGND VPWR sky130_fd_sc_hd__tapvpwrvgnd_1
XFILLER_72_49 VGND VGND VPWR VPWR sky130_fd_sc_hd__fill_2
XFILLER_24_197 VGND VGND VPWR VPWR sky130_fd_sc_hd__decap_3
XTAP_TAPCELL_ROW_50_630 VGND VPWR sky130_fd_sc_hd__tapvpwrvgnd_1
XTAP_TAPCELL_ROW_22_376 VGND VPWR sky130_fd_sc_hd__tapvpwrvgnd_1
XFILLER_20_392 VGND VGND VPWR VPWR sky130_fd_sc_hd__fill_2
XFILLER_79_337 VGND VGND VPWR VPWR sky130_fd_sc_hd__fill_1
XFILLER_47_223 VGND VGND VPWR VPWR sky130_fd_sc_hd__fill_1
XFILLER_47_234 VGND VGND VPWR VPWR sky130_fd_sc_hd__decap_3
XFILLER_47_267 VGND VGND VPWR VPWR sky130_fd_sc_hd__fill_2
XFILLER_47_278 VGND VGND VPWR VPWR sky130_fd_sc_hd__fill_2
XFILLER_62_237 VGND VGND VPWR VPWR sky130_fd_sc_hd__decap_3
XFILLER_15_142 VGND VGND VPWR VPWR sky130_fd_sc_hd__decap_3
XFILLER_62_259 VGND VGND VPWR VPWR sky130_fd_sc_hd__decap_3
XFILLER_43_495 VGND VGND VPWR VPWR sky130_fd_sc_hd__fill_1
XFILLER_30_156 VGND VGND VPWR VPWR sky130_fd_sc_hd__decap_3
XFILLER_30_189 VGND VGND VPWR VPWR sky130_fd_sc_hd__decap_3
Xwire250 _4124_/X VGND VGND VPWR VPWR _4813_/A sky130_fd_sc_hd__buf_2
Xwire261 _4946_/A VGND VGND VPWR VPWR wire261/X sky130_fd_sc_hd__buf_2
X_4390_ _4606_/A _4390_/B VGND VGND VPWR VPWR _4390_/Y sky130_fd_sc_hd__nor2_2
X_3410_ _3371_/A _3410_/B VGND VGND VPWR VPWR _3410_/X sky130_fd_sc_hd__and2b_2
XFILLER_7_99 VGND VGND VPWR VPWR sky130_fd_sc_hd__fill_2
XFILLER_7_385 VGND VGND VPWR VPWR sky130_fd_sc_hd__fill_1
X_3341_ _6012_/B _3357_/B VGND VGND VPWR VPWR _3486_/C sky130_fd_sc_hd__xor2_2
X_6060_ _6189_/B _6192_/A _6233_/B _6060_/D VGND VGND VPWR VPWR _6061_/D sky130_fd_sc_hd__and4_2
X_3272_ _3735_/A _3252_/X _3263_/X _3367_/B _3271_/X VGND VGND VPWR VPWR _3272_/X
+ sky130_fd_sc_hd__o221a_2
XFILLER_38_212 VGND VGND VPWR VPWR sky130_fd_sc_hd__fill_2
X_5011_ _4332_/A _3597_/X _4456_/Y _4842_/A VGND VGND VPWR VPWR _5012_/D sky130_fd_sc_hd__a31o_2
XFILLER_38_223 VGND VGND VPWR VPWR sky130_fd_sc_hd__decap_3
XFILLER_38_256 VGND VGND VPWR VPWR sky130_fd_sc_hd__decap_3
XFILLER_38_278 VGND VGND VPWR VPWR sky130_fd_sc_hd__decap_3
X_5913_ _5975_/A _5908_/B _5900_/X _5912_/X VGND VGND VPWR VPWR _5913_/X sky130_fd_sc_hd__a31o_2
XTAP_TAPCELL_ROW_64_755 VGND VPWR sky130_fd_sc_hd__tapvpwrvgnd_1
X_5844_ _5844_/A _5844_/B VGND VGND VPWR VPWR _5869_/A sky130_fd_sc_hd__nand2_2
XFILLER_61_281 VGND VGND VPWR VPWR sky130_fd_sc_hd__decap_3
X_5775_ _5215_/X _5770_/X _5774_/Y _5061_/A VGND VGND VPWR VPWR _5775_/X sky130_fd_sc_hd__o211a_2
X_4726_ _4025_/X _4009_/X _4726_/S VGND VGND VPWR VPWR _4726_/X sky130_fd_sc_hd__mux2_2
X_4657_ _6061_/B _4695_/A VGND VGND VPWR VPWR _4657_/X sky130_fd_sc_hd__and2b_2
Xinput91 operand_b[29] VGND VGND VPWR VPWR _6251_/B sky130_fd_sc_hd__clkdlybuf4s25_1
Xinput80 operand_b[19] VGND VGND VPWR VPWR input80/X sky130_fd_sc_hd__clkdlybuf4s25_1
X_3608_ _6113_/B _3679_/C _3608_/C VGND VGND VPWR VPWR _3608_/Y sky130_fd_sc_hd__nor3_2
X_6327_ _6344_/A _6344_/B VGND VGND VPWR VPWR _6346_/B sky130_fd_sc_hd__nor2_2
X_4588_ _4612_/C _4588_/B VGND VGND VPWR VPWR _4588_/X sky130_fd_sc_hd__xor2_2
X_3539_ _3668_/A _3539_/B _3539_/C VGND VGND VPWR VPWR _3539_/X sky130_fd_sc_hd__and3_2
X_6258_ _6258_/A _6258_/B VGND VGND VPWR VPWR _6258_/X sky130_fd_sc_hd__or2_2
XFILLER_29_212 VGND VGND VPWR VPWR sky130_fd_sc_hd__fill_1
X_6189_ _6189_/A _6189_/B _6221_/C VGND VGND VPWR VPWR _6190_/A sky130_fd_sc_hd__and3_2
X_5209_ _5262_/A _5209_/B VGND VGND VPWR VPWR _5209_/X sky130_fd_sc_hd__xor2_2
XFILLER_29_234 VGND VGND VPWR VPWR sky130_fd_sc_hd__decap_3
XTAP_TAPCELL_ROW_27_424 VGND VPWR sky130_fd_sc_hd__tapvpwrvgnd_1
XFILLER_52_270 VGND VGND VPWR VPWR sky130_fd_sc_hd__decap_3
XFILLER_12_123 VGND VGND VPWR VPWR sky130_fd_sc_hd__decap_3
XFILLER_12_134 VGND VGND VPWR VPWR sky130_fd_sc_hd__decap_3
XFILLER_16_97 VGND VGND VPWR VPWR sky130_fd_sc_hd__decap_3
XFILLER_40_421 VGND VGND VPWR VPWR sky130_fd_sc_hd__decap_3
XTAP_TAPCELL_ROW_35_490 VGND VPWR sky130_fd_sc_hd__tapvpwrvgnd_1
XFILLER_12_156 VGND VGND VPWR VPWR sky130_fd_sc_hd__decap_3
XFILLER_32_85 VGND VGND VPWR VPWR sky130_fd_sc_hd__decap_3
XPHY_EDGE_ROW_66_Left_149 VGND VGND VPWR VPWR sky130_fd_sc_hd__decap_3
XFILLER_79_178 VGND VGND VPWR VPWR sky130_fd_sc_hd__fill_2
XFILLER_35_204 VGND VGND VPWR VPWR sky130_fd_sc_hd__decap_3
XFILLER_35_237 VGND VGND VPWR VPWR sky130_fd_sc_hd__decap_3
XFILLER_75_384 VGND VGND VPWR VPWR sky130_fd_sc_hd__fill_1
XTAP_TAPCELL_ROW_61_725 VGND VPWR sky130_fd_sc_hd__tapvpwrvgnd_1
X_3890_ _4365_/A _6062_/D _3889_/X VGND VGND VPWR VPWR _3890_/Y sky130_fd_sc_hd__o21ai_2
XPHY_EDGE_ROW_75_Left_158 VGND VGND VPWR VPWR sky130_fd_sc_hd__decap_3
X_5560_ _4235_/X _5050_/A _5551_/X _5552_/Y _5559_/X VGND VGND VPWR VPWR _5560_/X
+ sky130_fd_sc_hd__a221o_2
X_5491_ _5501_/A _5501_/B VGND VGND VPWR VPWR _5530_/C sky130_fd_sc_hd__or2_2
X_4511_ _6185_/A _4168_/A _6221_/B VGND VGND VPWR VPWR _4512_/D sky130_fd_sc_hd__o21ai_2
X_4442_ _4485_/B VGND VGND VPWR VPWR _4442_/X sky130_fd_sc_hd__clkbuf_1
X_4373_ _4502_/S _3629_/X _4057_/Y VGND VGND VPWR VPWR _4373_/X sky130_fd_sc_hd__a21bo_2
X_6112_ _6099_/X _6104_/X _6111_/X VGND VGND VPWR VPWR _6112_/Y sky130_fd_sc_hd__o21ai_2
Xfanout629 _5716_/A VGND VGND VPWR VPWR _6374_/C sky130_fd_sc_hd__clkdlybuf4s25_1
X_3324_ _5225_/S _6449_/A0 _6449_/A1 _6439_/A0 _6449_/S0 _3424_/B VGND VGND VPWR VPWR
+ _3324_/X sky130_fd_sc_hd__mux4_2
XTAP_TAPCELL_ROW_69_803 VGND VPWR sky130_fd_sc_hd__tapvpwrvgnd_1
X_6043_ _6407_/B _6041_/X _6042_/Y _5874_/A VGND VGND VPWR VPWR _6043_/X sky130_fd_sc_hd__a2bb2o_2
X_3255_ _3486_/A _3417_/A VGND VGND VPWR VPWR _3255_/X sky130_fd_sc_hd__or2_2
XFILLER_58_318 VGND VGND VPWR VPWR sky130_fd_sc_hd__fill_1
XFILLER_22_410 VGND VGND VPWR VPWR sky130_fd_sc_hd__decap_3
XFILLER_22_421 VGND VGND VPWR VPWR sky130_fd_sc_hd__fill_2
X_5827_ _6477_/A _5821_/Y _5826_/X VGND VGND VPWR VPWR _5827_/X sky130_fd_sc_hd__o21a_2
XFILLER_22_487 VGND VGND VPWR VPWR sky130_fd_sc_hd__fill_2
X_5758_ _5721_/A _5721_/B _5770_/S VGND VGND VPWR VPWR _5758_/X sky130_fd_sc_hd__mux2_2
XTAP_TAPCELL_ROW_32_471 VGND VPWR sky130_fd_sc_hd__tapvpwrvgnd_1
X_4709_ _4709_/A _4709_/B _4709_/C _4708_/Y VGND VGND VPWR VPWR _4968_/A sky130_fd_sc_hd__nor4b_2
X_5689_ _6344_/A _5635_/B _5580_/C _6346_/A VGND VGND VPWR VPWR _5689_/X sky130_fd_sc_hd__o31a_2
XFILLER_49_307 VGND VGND VPWR VPWR sky130_fd_sc_hd__decap_3
XFILLER_76_148 VGND VGND VPWR VPWR sky130_fd_sc_hd__fill_1
XFILLER_57_340 VGND VGND VPWR VPWR sky130_fd_sc_hd__decap_3
XFILLER_27_52 VGND VGND VPWR VPWR sky130_fd_sc_hd__decap_3
XFILLER_72_365 VGND VGND VPWR VPWR sky130_fd_sc_hd__decap_3
XFILLER_72_354 VGND VGND VPWR VPWR sky130_fd_sc_hd__decap_3
XFILLER_72_332 VGND VGND VPWR VPWR sky130_fd_sc_hd__decap_3
XFILLER_32_218 VGND VGND VPWR VPWR sky130_fd_sc_hd__fill_1
XFILLER_40_240 VGND VGND VPWR VPWR sky130_fd_sc_hd__decap_3
XFILLER_43_73 VGND VGND VPWR VPWR sky130_fd_sc_hd__fill_1
XFILLER_13_487 VGND VGND VPWR VPWR sky130_fd_sc_hd__fill_1
XFILLER_40_273 VGND VGND VPWR VPWR sky130_fd_sc_hd__fill_2
XFILLER_48_362 VGND VGND VPWR VPWR sky130_fd_sc_hd__fill_2
XTAP_TAPCELL_ROW_38_519 VGND VPWR sky130_fd_sc_hd__tapvpwrvgnd_1
XFILLER_67_159 VGND VGND VPWR VPWR sky130_fd_sc_hd__fill_1
XFILLER_63_321 VGND VGND VPWR VPWR sky130_fd_sc_hd__decap_3
XFILLER_63_343 VGND VGND VPWR VPWR sky130_fd_sc_hd__fill_1
XFILLER_23_207 VGND VGND VPWR VPWR sky130_fd_sc_hd__decap_3
X_4991_ _4962_/X _4964_/Y _4969_/X _4526_/A _4990_/Y VGND VGND VPWR VPWR _4991_/X
+ sky130_fd_sc_hd__a221o_2
XFILLER_63_365 VGND VGND VPWR VPWR sky130_fd_sc_hd__fill_1
XFILLER_16_270 VGND VGND VPWR VPWR sky130_fd_sc_hd__decap_3
X_3942_ _3942_/A VGND VGND VPWR VPWR _4139_/S sky130_fd_sc_hd__clkbuf_1
XTAP_TAPCELL_ROW_46_596 VGND VPWR sky130_fd_sc_hd__tapvpwrvgnd_1
X_3873_ _6130_/S _6062_/C _3825_/B _3907_/C VGND VGND VPWR VPWR _3873_/X sky130_fd_sc_hd__o211a_2
X_5612_ _6332_/A _5478_/B wire261/X _5647_/B _5611_/Y VGND VGND VPWR VPWR _5612_/X
+ sky130_fd_sc_hd__a221o_2
X_5543_ _5541_/X _5542_/Y _5543_/S VGND VGND VPWR VPWR _5543_/X sky130_fd_sc_hd__mux2_2
X_5474_ _6322_/A _5476_/S VGND VGND VPWR VPWR _5474_/X sky130_fd_sc_hd__or2b_2
X_4425_ _4417_/X _4419_/Y _4424_/X _3748_/A VGND VGND VPWR VPWR _4425_/X sky130_fd_sc_hd__a22o_2
Xfanout404 fanout406/X VGND VGND VPWR VPWR _3711_/S sky130_fd_sc_hd__clkdlybuf4s25_1
X_4356_ _4356_/A _4430_/B VGND VGND VPWR VPWR _4356_/Y sky130_fd_sc_hd__nor2_2
Xfanout415 _6133_/A VGND VGND VPWR VPWR _6152_/A sky130_fd_sc_hd__clkdlybuf4s25_1
Xfanout437 fanout444/X VGND VGND VPWR VPWR _3652_/S sky130_fd_sc_hd__clkdlybuf4s25_1
Xfanout448 input69/X VGND VGND VPWR VPWR _3826_/A sky130_fd_sc_hd__clkdlybuf4s25_1
X_3307_ _3596_/S _3220_/X _3306_/X VGND VGND VPWR VPWR _3985_/B sky130_fd_sc_hd__a21o_2
X_4287_ _5228_/A _4285_/X _4286_/Y VGND VGND VPWR VPWR _4287_/Y sky130_fd_sc_hd__a21oi_2
XFILLER_39_362 VGND VGND VPWR VPWR sky130_fd_sc_hd__decap_3
X_6026_ _6061_/B _6247_/A _6244_/A VGND VGND VPWR VPWR _6078_/C sky130_fd_sc_hd__and3_2
X_3238_ _3233_/X _3234_/X _3235_/X _3236_/X _3495_/A _3469_/S VGND VGND VPWR VPWR
+ _3239_/B sky130_fd_sc_hd__mux4_2
XFILLER_54_321 VGND VGND VPWR VPWR sky130_fd_sc_hd__decap_3
XFILLER_54_343 VGND VGND VPWR VPWR sky130_fd_sc_hd__decap_3
XFILLER_66_192 VGND VGND VPWR VPWR sky130_fd_sc_hd__decap_3
XFILLER_54_365 VGND VGND VPWR VPWR sky130_fd_sc_hd__decap_3
XTAP_TAPCELL_ROW_1_188 VGND VPWR sky130_fd_sc_hd__tapvpwrvgnd_1
XFILLER_81_162 VGND VGND VPWR VPWR sky130_fd_sc_hd__fill_1
XTAP_TAPCELL_ROW_80_897 VGND VPWR sky130_fd_sc_hd__tapvpwrvgnd_1
XFILLER_13_98 VGND VGND VPWR VPWR sky130_fd_sc_hd__decap_3
XFILLER_49_104 VGND VGND VPWR VPWR sky130_fd_sc_hd__decap_3
XFILLER_45_332 VGND VGND VPWR VPWR sky130_fd_sc_hd__decap_3
XFILLER_45_343 VGND VGND VPWR VPWR sky130_fd_sc_hd__fill_2
XFILLER_45_354 VGND VGND VPWR VPWR sky130_fd_sc_hd__decap_3
XFILLER_45_387 VGND VGND VPWR VPWR sky130_fd_sc_hd__decap_3
XFILLER_60_302 VGND VGND VPWR VPWR sky130_fd_sc_hd__decap_3
XTAP_TAPCELL_ROW_71_820 VGND VPWR sky130_fd_sc_hd__tapvpwrvgnd_1
XFILLER_60_324 VGND VGND VPWR VPWR sky130_fd_sc_hd__decap_3
XFILLER_13_251 VGND VGND VPWR VPWR sky130_fd_sc_hd__fill_2
XTAP_TAPCELL_ROW_43_566 VGND VPWR sky130_fd_sc_hd__tapvpwrvgnd_1
XFILLER_13_284 VGND VGND VPWR VPWR sky130_fd_sc_hd__fill_1
X_4210_ _4168_/X _4211_/B _4179_/Y _4498_/B _4209_/Y VGND VGND VPWR VPWR _5996_/A
+ sky130_fd_sc_hd__a221o_2
X_5190_ _5168_/Y _5170_/X _5172_/Y _5187_/X _5189_/X VGND VGND VPWR VPWR _5190_/X
+ sky130_fd_sc_hd__o2111a_2
X_4141_ _6108_/A VGND VGND VPWR VPWR _6106_/A sky130_fd_sc_hd__clkbuf_2
X_4072_ _4049_/S input76/X _4033_/X _4071_/X VGND VGND VPWR VPWR _4072_/X sky130_fd_sc_hd__o22a_2
XFILLER_36_332 VGND VGND VPWR VPWR sky130_fd_sc_hd__decap_3
XFILLER_36_376 VGND VGND VPWR VPWR sky130_fd_sc_hd__decap_3
XFILLER_51_313 VGND VGND VPWR VPWR sky130_fd_sc_hd__decap_3
XFILLER_63_140 VGND VGND VPWR VPWR sky130_fd_sc_hd__fill_2
X_4974_ _4884_/B _3542_/X _3509_/X _5242_/B _4973_/Y VGND VGND VPWR VPWR _4974_/X
+ sky130_fd_sc_hd__o221a_2
X_3925_ _3925_/A _3925_/B _3925_/C VGND VGND VPWR VPWR _3926_/B sky130_fd_sc_hd__and3_2
X_3856_ _3856_/A _3856_/B _3856_/C VGND VGND VPWR VPWR _3856_/Y sky130_fd_sc_hd__nand3_2
X_3787_ _4019_/A _4156_/A _3812_/A VGND VGND VPWR VPWR _3787_/X sky130_fd_sc_hd__mux2_2
X_5526_ _5278_/Y _5423_/A _5423_/B VGND VGND VPWR VPWR _5526_/X sky130_fd_sc_hd__a21o_2
X_5457_ _5457_/A VGND VGND VPWR VPWR _5457_/X sky130_fd_sc_hd__clkbuf_1
X_4408_ _6059_/B _6208_/A VGND VGND VPWR VPWR _4408_/X sky130_fd_sc_hd__or2b_2
X_5388_ _5224_/X wire263/X _5388_/S VGND VGND VPWR VPWR _5388_/X sky130_fd_sc_hd__mux2_2
XFILLER_59_402 VGND VGND VPWR VPWR sky130_fd_sc_hd__fill_1
X_4339_ _4339_/A VGND VGND VPWR VPWR _4339_/X sky130_fd_sc_hd__clkbuf_1
XTAP_TAPCELL_ROW_6_236 VGND VPWR sky130_fd_sc_hd__tapvpwrvgnd_1
XFILLER_46_118 VGND VGND VPWR VPWR sky130_fd_sc_hd__fill_1
X_6009_ _6319_/A _6319_/B _6283_/A VGND VGND VPWR VPWR _6337_/A sky130_fd_sc_hd__and3_2
XFILLER_27_343 VGND VGND VPWR VPWR sky130_fd_sc_hd__decap_3
XFILLER_42_357 VGND VGND VPWR VPWR sky130_fd_sc_hd__decap_3
XFILLER_42_368 VGND VGND VPWR VPWR sky130_fd_sc_hd__fill_1
XTAP_TAPCELL_ROW_40_536 VGND VPWR sky130_fd_sc_hd__tapvpwrvgnd_1
XFILLER_40_85 VGND VGND VPWR VPWR sky130_fd_sc_hd__fill_2
XFILLER_2_453 VGND VGND VPWR VPWR sky130_fd_sc_hd__fill_2
XFILLER_2_475 VGND VGND VPWR VPWR sky130_fd_sc_hd__fill_1
Xload_slew618 _4568_/A1 VGND VGND VPWR VPWR _6474_/A sky130_fd_sc_hd__clkbuf_4
XTAP_TAPCELL_ROW_48_614 VGND VPWR sky130_fd_sc_hd__tapvpwrvgnd_1
XFILLER_77_287 VGND VGND VPWR VPWR sky130_fd_sc_hd__decap_3
XFILLER_18_365 VGND VGND VPWR VPWR sky130_fd_sc_hd__decap_3
XFILLER_45_151 VGND VGND VPWR VPWR sky130_fd_sc_hd__decap_3
XFILLER_80_419 VGND VGND VPWR VPWR sky130_fd_sc_hd__fill_1
XFILLER_33_335 VGND VGND VPWR VPWR sky130_fd_sc_hd__fill_1
XFILLER_33_346 VGND VGND VPWR VPWR sky130_fd_sc_hd__decap_3
XFILLER_45_184 VGND VGND VPWR VPWR sky130_fd_sc_hd__decap_3
XTAP_TAPCELL_ROW_56_680 VGND VPWR sky130_fd_sc_hd__tapvpwrvgnd_1
X_3710_ _3710_/A _3710_/B _3710_/C VGND VGND VPWR VPWR _3710_/X sky130_fd_sc_hd__and3_2
XFILLER_60_187 VGND VGND VPWR VPWR sky130_fd_sc_hd__decap_3
X_4690_ _4497_/A _4672_/X _4689_/Y VGND VGND VPWR VPWR _4690_/Y sky130_fd_sc_hd__o21ai_2
XFILLER_81_92 VGND VGND VPWR VPWR sky130_fd_sc_hd__decap_3
X_3641_ _6014_/B _3641_/B VGND VGND VPWR VPWR _3641_/Y sky130_fd_sc_hd__nand2_2
X_6360_ _6294_/A _6358_/Y _6359_/X _6290_/B VGND VGND VPWR VPWR _6360_/X sky130_fd_sc_hd__a22o_2
X_3572_ _3570_/X _3571_/X _3572_/S VGND VGND VPWR VPWR _3572_/X sky130_fd_sc_hd__mux2_2
XTAP_TAPCELL_ROW_11_282 VGND VPWR sky130_fd_sc_hd__tapvpwrvgnd_1
X_5311_ _6294_/A _6292_/A _5118_/X _5278_/Y _5405_/B VGND VGND VPWR VPWR _5318_/A
+ sky130_fd_sc_hd__o2111ai_2
X_6291_ _6298_/A _6306_/A _6291_/C _6298_/C VGND VGND VPWR VPWR _6293_/B sky130_fd_sc_hd__and4_2
X_5242_ _5732_/A _5242_/B VGND VGND VPWR VPWR _5242_/Y sky130_fd_sc_hd__nor2_2
X_5173_ _5281_/A3 _5191_/A _5128_/A _5054_/A _5173_/S0 wire374/X VGND VGND VPWR VPWR
+ _5173_/X sky130_fd_sc_hd__mux4_2
XFILLER_56_405 VGND VGND VPWR VPWR sky130_fd_sc_hd__decap_3
X_4124_ _4124_/A VGND VGND VPWR VPWR _4124_/X sky130_fd_sc_hd__clkbuf_1
XTAP_TAPCELL_ROW_3_206 VGND VPWR sky130_fd_sc_hd__tapvpwrvgnd_1
XFILLER_28_107 VGND VGND VPWR VPWR sky130_fd_sc_hd__fill_2
Xinput1 carry_in VGND VGND VPWR VPWR input1/X sky130_fd_sc_hd__clkdlybuf4s25_1
X_4055_ _4339_/A _4051_/X _4054_/X _3594_/X VGND VGND VPWR VPWR _4064_/A sky130_fd_sc_hd__a22o_2
XTAP_TAPCELL_ROW_82_926 VGND VPWR sky130_fd_sc_hd__tapvpwrvgnd_1
XTAP_TAPCELL_ROW_82_915 VGND VPWR sky130_fd_sc_hd__tapvpwrvgnd_1
XFILLER_36_184 VGND VGND VPWR VPWR sky130_fd_sc_hd__decap_3
X_4957_ _4943_/S _6077_/B _4919_/B _4869_/Y _4956_/X VGND VGND VPWR VPWR _5429_/B
+ sky130_fd_sc_hd__o221a_2
X_4888_ _4846_/A _5224_/A _4956_/A VGND VGND VPWR VPWR _4888_/X sky130_fd_sc_hd__mux2_2
X_3908_ _3908_/A _6062_/D VGND VGND VPWR VPWR _3908_/Y sky130_fd_sc_hd__nor2_2
X_3839_ _3976_/A _3839_/B VGND VGND VPWR VPWR _3839_/Y sky130_fd_sc_hd__nand2_2
X_6489_ _6489_/A VGND VGND VPWR VPWR _6489_/X sky130_fd_sc_hd__buf_1
X_5509_ _5739_/A _5509_/B VGND VGND VPWR VPWR _5510_/B sky130_fd_sc_hd__nand2_2
XFILLER_59_243 VGND VGND VPWR VPWR sky130_fd_sc_hd__decap_3
XFILLER_59_276 VGND VGND VPWR VPWR sky130_fd_sc_hd__decap_3
XFILLER_47_449 VGND VGND VPWR VPWR sky130_fd_sc_hd__decap_3
XFILLER_15_324 VGND VGND VPWR VPWR sky130_fd_sc_hd__fill_2
XFILLER_15_335 VGND VGND VPWR VPWR sky130_fd_sc_hd__fill_1
XFILLER_27_184 VGND VGND VPWR VPWR sky130_fd_sc_hd__fill_2
XFILLER_35_41 VGND VGND VPWR VPWR sky130_fd_sc_hd__fill_2
XFILLER_30_338 VGND VGND VPWR VPWR sky130_fd_sc_hd__decap_3
Xmax_cap209 _5381_/S VGND VGND VPWR VPWR _5948_/S1 sky130_fd_sc_hd__buf_2
XFILLER_2_283 VGND VGND VPWR VPWR sky130_fd_sc_hd__fill_2
Xload_slew426 _3503_/S0 VGND VGND VPWR VPWR _3526_/S0 sky130_fd_sc_hd__buf_4
Xload_slew459 _4057_/B VGND VGND VPWR VPWR _4800_/A sky130_fd_sc_hd__buf_4
XFILLER_38_427 VGND VGND VPWR VPWR sky130_fd_sc_hd__fill_1
XFILLER_65_202 VGND VGND VPWR VPWR sky130_fd_sc_hd__decap_3
XFILLER_65_246 VGND VGND VPWR VPWR sky130_fd_sc_hd__decap_3
XFILLER_65_279 VGND VGND VPWR VPWR sky130_fd_sc_hd__fill_1
XFILLER_18_173 VGND VGND VPWR VPWR sky130_fd_sc_hd__decap_3
X_5860_ _5968_/A _6040_/A VGND VGND VPWR VPWR _5860_/Y sky130_fd_sc_hd__nor2_2
X_4811_ _5038_/A _4791_/A _4810_/X VGND VGND VPWR VPWR _4811_/Y sky130_fd_sc_hd__o21ai_2
XFILLER_33_187 VGND VGND VPWR VPWR sky130_fd_sc_hd__decap_3
X_5791_ _5752_/A _5752_/B _6033_/B _6050_/A _5753_/A VGND VGND VPWR VPWR _5818_/B
+ sky130_fd_sc_hd__o221a_2
XFILLER_14_390 VGND VGND VPWR VPWR sky130_fd_sc_hd__decap_3
X_4742_ _4967_/A _4967_/B _4967_/C VGND VGND VPWR VPWR _5536_/B sky130_fd_sc_hd__nor3_2
X_4673_ _3980_/X _3972_/X _4757_/S VGND VGND VPWR VPWR _4673_/X sky130_fd_sc_hd__mux2_2
X_6412_ _6423_/B _6412_/B VGND VGND VPWR VPWR _6412_/Y sky130_fd_sc_hd__nor2_2
X_3624_ _6440_/A2 _6431_/A0 input60/X _6431_/A1 _6437_/S _3780_/A VGND VGND VPWR VPWR
+ _3624_/X sky130_fd_sc_hd__mux4_2
X_6343_ _6343_/A _6343_/B VGND VGND VPWR VPWR _6343_/Y sky130_fd_sc_hd__nor2_2
X_3555_ _6098_/A _3554_/B _3408_/Y _3372_/A _3412_/Y VGND VGND VPWR VPWR _3558_/C
+ sky130_fd_sc_hd__a221oi_2
X_6274_ _6274_/A _6298_/C VGND VGND VPWR VPWR _6275_/C sky130_fd_sc_hd__nand2_2
X_3486_ _3486_/A _3486_/B _3486_/C _3486_/D VGND VGND VPWR VPWR _3486_/Y sky130_fd_sc_hd__nor4_2
X_5225_ _5224_/X wire263/X _5225_/S VGND VGND VPWR VPWR _5225_/X sky130_fd_sc_hd__mux2_2
XTAP_TAPCELL_ROW_59_709 VGND VPWR sky130_fd_sc_hd__tapvpwrvgnd_1
X_5156_ _5438_/A _5210_/B _5172_/B _5274_/B _5669_/B2 VGND VGND VPWR VPWR _5156_/X
+ sky130_fd_sc_hd__o311a_2
XFILLER_56_224 VGND VGND VPWR VPWR sky130_fd_sc_hd__decap_3
X_5087_ _5087_/A _5110_/B VGND VGND VPWR VPWR _5087_/Y sky130_fd_sc_hd__nor2_2
X_4107_ _6164_/A VGND VGND VPWR VPWR _6167_/B sky130_fd_sc_hd__inv_2
XFILLER_44_408 VGND VGND VPWR VPWR sky130_fd_sc_hd__decap_3
X_4038_ _4038_/A _4044_/C VGND VGND VPWR VPWR _4038_/Y sky130_fd_sc_hd__xnor2_2
XTAP_TAPCELL_ROW_67_786 VGND VPWR sky130_fd_sc_hd__tapvpwrvgnd_1
XFILLER_24_110 VGND VGND VPWR VPWR sky130_fd_sc_hd__fill_2
XFILLER_71_238 VGND VGND VPWR VPWR sky130_fd_sc_hd__decap_3
XFILLER_71_216 VGND VGND VPWR VPWR sky130_fd_sc_hd__decap_3
XFILLER_24_132 VGND VGND VPWR VPWR sky130_fd_sc_hd__decap_3
XFILLER_12_305 VGND VGND VPWR VPWR sky130_fd_sc_hd__decap_3
XFILLER_24_176 VGND VGND VPWR VPWR sky130_fd_sc_hd__fill_2
XFILLER_52_496 VGND VGND VPWR VPWR sky130_fd_sc_hd__decap_3
X_5989_ _3545_/Y _3605_/X _5989_/C _5989_/D VGND VGND VPWR VPWR _5989_/X sky130_fd_sc_hd__and4bb_2
XTAP_TAPCELL_ROW_50_631 VGND VPWR sky130_fd_sc_hd__tapvpwrvgnd_1
XFILLER_20_360 VGND VGND VPWR VPWR sky130_fd_sc_hd__fill_1
XTAP_TAPCELL_ROW_22_377 VGND VPWR sky130_fd_sc_hd__tapvpwrvgnd_1
XFILLER_21_54 VGND VGND VPWR VPWR sky130_fd_sc_hd__fill_2
Xoutput190 _6004_/A VGND VGND VPWR VPWR result[58] sky130_fd_sc_hd__clkdlybuf4s25_1
XFILLER_47_202 VGND VGND VPWR VPWR sky130_fd_sc_hd__decap_3
XFILLER_47_246 VGND VGND VPWR VPWR sky130_fd_sc_hd__decap_3
XFILLER_35_408 VGND VGND VPWR VPWR sky130_fd_sc_hd__decap_3
XFILLER_15_121 VGND VGND VPWR VPWR sky130_fd_sc_hd__decap_3
XFILLER_62_249 VGND VGND VPWR VPWR sky130_fd_sc_hd__decap_3
XTAP_TAPCELL_ROW_13_300 VGND VPWR sky130_fd_sc_hd__tapvpwrvgnd_1
XFILLER_70_271 VGND VGND VPWR VPWR sky130_fd_sc_hd__fill_1
XFILLER_30_168 VGND VGND VPWR VPWR sky130_fd_sc_hd__decap_3
XFILLER_11_382 VGND VGND VPWR VPWR sky130_fd_sc_hd__decap_3
XFILLER_11_393 VGND VGND VPWR VPWR sky130_fd_sc_hd__decap_3
Xwire240 _4118_/X VGND VGND VPWR VPWR _4312_/A sky130_fd_sc_hd__clkbuf_4
XFILLER_7_320 VGND VGND VPWR VPWR sky130_fd_sc_hd__decap_3
Xwire284 _4515_/X VGND VGND VPWR VPWR _4846_/A sky130_fd_sc_hd__clkbuf_4
X_3340_ _3344_/C _3339_/Y _3410_/B VGND VGND VPWR VPWR _3340_/X sky130_fd_sc_hd__a21o_2
X_5010_ _4330_/X _5009_/X _5010_/S VGND VGND VPWR VPWR _5010_/X sky130_fd_sc_hd__mux2_2
X_3271_ _3760_/A _3748_/A _4098_/A _6454_/A VGND VGND VPWR VPWR _3271_/X sky130_fd_sc_hd__or4_2
XFILLER_23_3 VGND VGND VPWR VPWR sky130_fd_sc_hd__fill_2
XFILLER_38_235 VGND VGND VPWR VPWR sky130_fd_sc_hd__decap_3
XFILLER_19_471 VGND VGND VPWR VPWR sky130_fd_sc_hd__fill_1
XFILLER_53_227 VGND VGND VPWR VPWR sky130_fd_sc_hd__decap_3
X_5912_ _5966_/A _5903_/X _5904_/X _5911_/X VGND VGND VPWR VPWR _5912_/X sky130_fd_sc_hd__a211o_2
XTAP_TAPCELL_ROW_64_756 VGND VPWR sky130_fd_sc_hd__tapvpwrvgnd_1
X_5843_ _5884_/A _6040_/A VGND VGND VPWR VPWR _5844_/B sky130_fd_sc_hd__nand2_2
XFILLER_21_179 VGND VGND VPWR VPWR sky130_fd_sc_hd__decap_3
X_5774_ _5772_/X _5773_/X _6486_/C VGND VGND VPWR VPWR _5774_/Y sky130_fd_sc_hd__o21ai_2
X_4725_ _4725_/A VGND VGND VPWR VPWR _4725_/Y sky130_fd_sc_hd__inv_2
X_4656_ _6252_/A _4679_/B _4538_/B _4621_/B _6243_/C VGND VGND VPWR VPWR _4665_/B
+ sky130_fd_sc_hd__o2111a_2
Xinput81 operand_b[1] VGND VGND VPWR VPWR input81/X sky130_fd_sc_hd__clkdlybuf4s25_1
Xinput70 operand_b[0] VGND VGND VPWR VPWR input70/X sky130_fd_sc_hd__clkdlybuf4s25_1
X_4587_ _4743_/A _5534_/B _4743_/C VGND VGND VPWR VPWR _4588_/B sky130_fd_sc_hd__nor3_2
X_3607_ _3681_/A _6014_/B VGND VGND VPWR VPWR _3668_/D sky130_fd_sc_hd__xor2_2
X_6326_ _6333_/A _6344_/A _6326_/C VGND VGND VPWR VPWR _6332_/B sky130_fd_sc_hd__and3_2
Xinput92 operand_b[2] VGND VGND VPWR VPWR input92/X sky130_fd_sc_hd__clkdlybuf4s25_1
X_3538_ _3556_/A _3538_/B VGND VGND VPWR VPWR _3539_/C sky130_fd_sc_hd__nand2_2
X_6257_ _6244_/Y _6255_/X _6248_/X VGND VGND VPWR VPWR _6257_/X sky130_fd_sc_hd__a21o_2
X_3469_ _3425_/X _3468_/X _3469_/S VGND VGND VPWR VPWR _3470_/B sky130_fd_sc_hd__mux2_2
X_6188_ _4539_/X _6221_/C VGND VGND VPWR VPWR _6188_/X sky130_fd_sc_hd__and2b_2
X_5208_ _5573_/A _5572_/D _5262_/B VGND VGND VPWR VPWR _5209_/B sky130_fd_sc_hd__and3_2
X_5139_ _5137_/Y _5138_/Y _4372_/B VGND VGND VPWR VPWR _5139_/X sky130_fd_sc_hd__a21o_2
XFILLER_29_268 VGND VGND VPWR VPWR sky130_fd_sc_hd__decap_3
XFILLER_44_238 VGND VGND VPWR VPWR sky130_fd_sc_hd__decap_3
XTAP_TAPCELL_ROW_27_425 VGND VPWR sky130_fd_sc_hd__tapvpwrvgnd_1
XFILLER_37_290 VGND VGND VPWR VPWR sky130_fd_sc_hd__fill_1
XFILLER_40_433 VGND VGND VPWR VPWR sky130_fd_sc_hd__decap_3
XTAP_TAPCELL_ROW_35_491 VGND VPWR sky130_fd_sc_hd__tapvpwrvgnd_1
XFILLER_12_168 VGND VGND VPWR VPWR sky130_fd_sc_hd__decap_3
XFILLER_32_97 VGND VGND VPWR VPWR sky130_fd_sc_hd__fill_1
XFILLER_48_500 VGND VGND VPWR VPWR sky130_fd_sc_hd__fill_1
XFILLER_75_341 VGND VGND VPWR VPWR sky130_fd_sc_hd__decap_3
XFILLER_57_83 VGND VGND VPWR VPWR sky130_fd_sc_hd__fill_2
XFILLER_35_216 VGND VGND VPWR VPWR sky130_fd_sc_hd__decap_3
XFILLER_35_249 VGND VGND VPWR VPWR sky130_fd_sc_hd__decap_3
XFILLER_16_485 VGND VGND VPWR VPWR sky130_fd_sc_hd__fill_1
XFILLER_50_208 VGND VGND VPWR VPWR sky130_fd_sc_hd__decap_3
XTAP_TAPCELL_ROW_61_726 VGND VPWR sky130_fd_sc_hd__tapvpwrvgnd_1
X_5490_ _6322_/B _5459_/B _5474_/X VGND VGND VPWR VPWR _5493_/A sky130_fd_sc_hd__o21a_2
X_4510_ _6427_/A _4502_/X _4509_/X VGND VGND VPWR VPWR _4510_/Y sky130_fd_sc_hd__a21boi_2
X_4441_ _4120_/A _4120_/B _4120_/D _4431_/Y VGND VGND VPWR VPWR _4441_/Y sky130_fd_sc_hd__o31ai_4
XPHY_EDGE_ROW_9_Right_9 VGND VGND VPWR VPWR sky130_fd_sc_hd__decap_3
XFILLER_7_194 VGND VGND VPWR VPWR sky130_fd_sc_hd__decap_3
X_6111_ _4757_/S _6108_/B _6114_/B _6107_/Y _6110_/X VGND VGND VPWR VPWR _6111_/X
+ sky130_fd_sc_hd__o311a_2
X_4372_ _5138_/A _4372_/B VGND VGND VPWR VPWR _5485_/B sky130_fd_sc_hd__nor2_2
Xfanout608 _6419_/A VGND VGND VPWR VPWR _6040_/A sky130_fd_sc_hd__clkdlybuf4s25_1
Xfanout619 wire621/A VGND VGND VPWR VPWR _6090_/A sky130_fd_sc_hd__clkdlybuf4s25_1
X_3323_ _4150_/A _3313_/X _3322_/X _4095_/A VGND VGND VPWR VPWR _3323_/X sky130_fd_sc_hd__a22o_2
X_6042_ _6042_/A _6401_/A VGND VGND VPWR VPWR _6042_/Y sky130_fd_sc_hd__xnor2_2
X_3254_ _3361_/C _3735_/A VGND VGND VPWR VPWR _3417_/A sky130_fd_sc_hd__or2_2
XTAP_TAPCELL_ROW_69_804 VGND VPWR sky130_fd_sc_hd__tapvpwrvgnd_1
XFILLER_66_330 VGND VGND VPWR VPWR sky130_fd_sc_hd__decap_3
XFILLER_66_352 VGND VGND VPWR VPWR sky130_fd_sc_hd__decap_3
XTAP_TAPCELL_ROW_77_870 VGND VPWR sky130_fd_sc_hd__tapvpwrvgnd_1
XFILLER_66_374 VGND VGND VPWR VPWR sky130_fd_sc_hd__decap_3
XFILLER_26_249 VGND VGND VPWR VPWR sky130_fd_sc_hd__decap_3
XFILLER_81_333 VGND VGND VPWR VPWR sky130_fd_sc_hd__decap_3
XFILLER_41_208 VGND VGND VPWR VPWR sky130_fd_sc_hd__decap_3
XFILLER_34_271 VGND VGND VPWR VPWR sky130_fd_sc_hd__fill_1
XFILLER_34_293 VGND VGND VPWR VPWR sky130_fd_sc_hd__decap_3
XPHY_EDGE_ROW_14_Left_97 VGND VGND VPWR VPWR sky130_fd_sc_hd__decap_3
XFILLER_22_466 VGND VGND VPWR VPWR sky130_fd_sc_hd__fill_2
X_5826_ _5824_/X _5853_/B _5628_/A VGND VGND VPWR VPWR _5826_/X sky130_fd_sc_hd__a21o_2
X_5757_ _6051_/A _5723_/B _5723_/C _5770_/S _5756_/Y VGND VGND VPWR VPWR _5760_/B
+ sky130_fd_sc_hd__a41o_2
X_4708_ _4708_/A _4708_/B _4048_/A VGND VGND VPWR VPWR _4708_/Y sky130_fd_sc_hd__nor3b_2
X_5688_ _5688_/A1 _5579_/A _5579_/B _5580_/B _5687_/X VGND VGND VPWR VPWR _5688_/X
+ sky130_fd_sc_hd__a41o_2
X_4639_ _5442_/S VGND VGND VPWR VPWR _4971_/S sky130_fd_sc_hd__clkbuf_1
XFILLER_78_27 VGND VGND VPWR VPWR sky130_fd_sc_hd__fill_1
XFILLER_1_337 VGND VGND VPWR VPWR sky130_fd_sc_hd__decap_3
X_6309_ _6391_/C _6393_/A _6309_/C VGND VGND VPWR VPWR _6309_/X sky130_fd_sc_hd__or3_2
XFILLER_49_319 VGND VGND VPWR VPWR sky130_fd_sc_hd__decap_3
XFILLER_57_352 VGND VGND VPWR VPWR sky130_fd_sc_hd__decap_3
XFILLER_57_330 VGND VGND VPWR VPWR sky130_fd_sc_hd__decap_3
XFILLER_17_205 VGND VGND VPWR VPWR sky130_fd_sc_hd__fill_2
XFILLER_27_42 VGND VGND VPWR VPWR sky130_fd_sc_hd__fill_1
XFILLER_27_97 VGND VGND VPWR VPWR sky130_fd_sc_hd__decap_3
XFILLER_40_230 VGND VGND VPWR VPWR sky130_fd_sc_hd__decap_3
XFILLER_40_296 VGND VGND VPWR VPWR sky130_fd_sc_hd__decap_3
XFILLER_68_93 VGND VGND VPWR VPWR sky130_fd_sc_hd__fill_1
XFILLER_68_82 VGND VGND VPWR VPWR sky130_fd_sc_hd__fill_2
XFILLER_48_330 VGND VGND VPWR VPWR sky130_fd_sc_hd__decap_3
XFILLER_63_300 VGND VGND VPWR VPWR sky130_fd_sc_hd__decap_3
XFILLER_63_333 VGND VGND VPWR VPWR sky130_fd_sc_hd__decap_3
XFILLER_23_219 VGND VGND VPWR VPWR sky130_fd_sc_hd__decap_3
X_4990_ _4990_/A1 _4974_/X _4982_/X _5696_/A _4989_/X VGND VGND VPWR VPWR _4990_/Y
+ sky130_fd_sc_hd__o221ai_2
XFILLER_63_377 VGND VGND VPWR VPWR sky130_fd_sc_hd__decap_3
X_3941_ _3363_/Y _3933_/X _3939_/X _4339_/A VGND VGND VPWR VPWR _3941_/X sky130_fd_sc_hd__a2bb2o_2
XTAP_TAPCELL_ROW_46_597 VGND VPWR sky130_fd_sc_hd__tapvpwrvgnd_1
XFILLER_31_252 VGND VGND VPWR VPWR sky130_fd_sc_hd__fill_2
X_3872_ _3872_/A _3960_/A _4006_/C _3928_/D VGND VGND VPWR VPWR _3872_/X sky130_fd_sc_hd__or4_2
XFILLER_31_263 VGND VGND VPWR VPWR sky130_fd_sc_hd__decap_3
X_5611_ _5906_/A1 _5599_/B _5610_/X VGND VGND VPWR VPWR _5611_/Y sky130_fd_sc_hd__a21oi_2
X_5542_ _6317_/S _5530_/A _6318_/S VGND VGND VPWR VPWR _5542_/Y sky130_fd_sc_hd__a21oi_2
X_5473_ _5501_/B _5473_/B VGND VGND VPWR VPWR _5473_/Y sky130_fd_sc_hd__xnor2_2
X_4424_ _4884_/B _4420_/X _4422_/Y _3708_/B _4423_/Y VGND VGND VPWR VPWR _4424_/X
+ sky130_fd_sc_hd__a221o_2
Xfanout405 fanout406/X VGND VGND VPWR VPWR _3451_/S sky130_fd_sc_hd__clkdlybuf4s25_1
X_4355_ _4355_/A _4355_/B _4355_/C VGND VGND VPWR VPWR _4355_/X sky130_fd_sc_hd__and3_2
Xfanout416 input73/X VGND VGND VPWR VPWR _6151_/B sky130_fd_sc_hd__clkdlybuf4s25_1
Xfanout427 _3706_/S VGND VGND VPWR VPWR _5764_/S0 sky130_fd_sc_hd__clkdlybuf4s25_1
Xfanout438 _4506_/S VGND VGND VPWR VPWR _6429_/A sky130_fd_sc_hd__clkdlybuf4s25_1
X_3306_ _3590_/B _5962_/A _3306_/C VGND VGND VPWR VPWR _3306_/X sky130_fd_sc_hd__and3b_2
Xfanout449 input68/X VGND VGND VPWR VPWR _3754_/A sky130_fd_sc_hd__clkdlybuf4s25_1
X_4286_ _4286_/A _4286_/B VGND VGND VPWR VPWR _4286_/Y sky130_fd_sc_hd__nor2_2
XFILLER_58_127 VGND VGND VPWR VPWR sky130_fd_sc_hd__decap_3
X_6025_ _6183_/A _6183_/B _6183_/C _6025_/D VGND VGND VPWR VPWR _6250_/B sky130_fd_sc_hd__and4_2
X_3237_ _3596_/S VGND VGND VPWR VPWR _3698_/S sky130_fd_sc_hd__clkbuf_1
XFILLER_39_374 VGND VGND VPWR VPWR sky130_fd_sc_hd__fill_2
XFILLER_39_396 VGND VGND VPWR VPWR sky130_fd_sc_hd__fill_1
XFILLER_54_355 VGND VGND VPWR VPWR sky130_fd_sc_hd__decap_3
XFILLER_81_130 VGND VGND VPWR VPWR sky130_fd_sc_hd__fill_1
XTAP_TAPCELL_ROW_1_189 VGND VPWR sky130_fd_sc_hd__tapvpwrvgnd_1
XFILLER_54_399 VGND VGND VPWR VPWR sky130_fd_sc_hd__decap_3
X_5809_ _5874_/A _5809_/B VGND VGND VPWR VPWR _5822_/A sky130_fd_sc_hd__nand2_2
XTAP_TAPCELL_ROW_80_898 VGND VPWR sky130_fd_sc_hd__tapvpwrvgnd_1
XTAP_TAPCELL_ROW_9_256 VGND VPWR sky130_fd_sc_hd__tapvpwrvgnd_1
XFILLER_49_116 VGND VGND VPWR VPWR sky130_fd_sc_hd__decap_3
XFILLER_77_425 VGND VGND VPWR VPWR sky130_fd_sc_hd__fill_2
XFILLER_38_63 VGND VGND VPWR VPWR sky130_fd_sc_hd__fill_1
XFILLER_49_149 VGND VGND VPWR VPWR sky130_fd_sc_hd__decap_3
XFILLER_38_85 VGND VGND VPWR VPWR sky130_fd_sc_hd__decap_3
XFILLER_45_311 VGND VGND VPWR VPWR sky130_fd_sc_hd__decap_3
XFILLER_45_366 VGND VGND VPWR VPWR sky130_fd_sc_hd__decap_3
XFILLER_45_399 VGND VGND VPWR VPWR sky130_fd_sc_hd__decap_3
XTAP_TAPCELL_ROW_71_821 VGND VPWR sky130_fd_sc_hd__tapvpwrvgnd_1
XTAP_TAPCELL_ROW_43_567 VGND VPWR sky130_fd_sc_hd__tapvpwrvgnd_1
XFILLER_5_473 VGND VGND VPWR VPWR sky130_fd_sc_hd__fill_1
X_4140_ _4140_/A VGND VGND VPWR VPWR _6108_/A sky130_fd_sc_hd__clkbuf_2
XFILLER_68_414 VGND VGND VPWR VPWR sky130_fd_sc_hd__fill_1
X_4071_ _4042_/A input75/X input76/X _4049_/S VGND VGND VPWR VPWR _4071_/X sky130_fd_sc_hd__a22o_2
XFILLER_55_108 VGND VGND VPWR VPWR sky130_fd_sc_hd__decap_3
XFILLER_55_119 VGND VGND VPWR VPWR sky130_fd_sc_hd__decap_3
XFILLER_36_388 VGND VGND VPWR VPWR sky130_fd_sc_hd__decap_3
XFILLER_51_325 VGND VGND VPWR VPWR sky130_fd_sc_hd__decap_3
X_4973_ _4973_/A _4973_/B VGND VGND VPWR VPWR _4973_/Y sky130_fd_sc_hd__nand2_2
XFILLER_63_196 VGND VGND VPWR VPWR sky130_fd_sc_hd__decap_3
XFILLER_51_358 VGND VGND VPWR VPWR sky130_fd_sc_hd__decap_3
X_3924_ _3637_/Y _3728_/A _3919_/B _3919_/C VGND VGND VPWR VPWR _3925_/C sky130_fd_sc_hd__a211o_2
X_3855_ _3855_/A _3855_/B VGND VGND VPWR VPWR _3855_/X sky130_fd_sc_hd__or2_2
X_3786_ _6126_/B _3812_/A VGND VGND VPWR VPWR _3786_/X sky130_fd_sc_hd__and2b_2
X_5525_ _5493_/A _5493_/B _5530_/A VGND VGND VPWR VPWR _5532_/A sky130_fd_sc_hd__a21o_2
X_5456_ _5459_/A _5459_/B VGND VGND VPWR VPWR _5457_/A sky130_fd_sc_hd__or2_2
X_4407_ _4449_/C _4407_/B VGND VGND VPWR VPWR _4407_/X sky130_fd_sc_hd__xor2_2
X_5387_ _5374_/A _5383_/Y _4813_/A VGND VGND VPWR VPWR _5387_/Y sky130_fd_sc_hd__o21ai_2
X_4338_ _6021_/D _5180_/B _3981_/X _4301_/A _4337_/X VGND VGND VPWR VPWR _4338_/X
+ sky130_fd_sc_hd__a221o_2
XTAP_TAPCELL_ROW_6_237 VGND VPWR sky130_fd_sc_hd__tapvpwrvgnd_1
X_4269_ _4239_/A _6171_/B _6213_/A _4186_/B _4230_/X VGND VGND VPWR VPWR _4269_/X
+ sky130_fd_sc_hd__o221a_2
X_6008_ _6359_/A _6008_/B VGND VGND VPWR VPWR _6283_/A sky130_fd_sc_hd__and2_2
XFILLER_42_303 VGND VGND VPWR VPWR sky130_fd_sc_hd__decap_3
XFILLER_54_141 VGND VGND VPWR VPWR sky130_fd_sc_hd__decap_3
XFILLER_27_399 VGND VGND VPWR VPWR sky130_fd_sc_hd__fill_2
XFILLER_42_336 VGND VGND VPWR VPWR sky130_fd_sc_hd__decap_3
XFILLER_50_380 VGND VGND VPWR VPWR sky130_fd_sc_hd__decap_3
Xwire614 wire614/A VGND VGND VPWR VPWR _5859_/A sky130_fd_sc_hd__clkbuf_4
XTAP_TAPCELL_ROW_40_537 VGND VPWR sky130_fd_sc_hd__tapvpwrvgnd_1
XFILLER_40_75 VGND VGND VPWR VPWR sky130_fd_sc_hd__decap_3
XFILLER_77_211 VGND VGND VPWR VPWR sky130_fd_sc_hd__decap_3
XFILLER_77_244 VGND VGND VPWR VPWR sky130_fd_sc_hd__decap_3
XTAP_TAPCELL_ROW_48_615 VGND VPWR sky130_fd_sc_hd__tapvpwrvgnd_1
XFILLER_18_333 VGND VGND VPWR VPWR sky130_fd_sc_hd__decap_3
XFILLER_18_377 VGND VGND VPWR VPWR sky130_fd_sc_hd__decap_3
XTAP_TAPCELL_ROW_56_681 VGND VPWR sky130_fd_sc_hd__tapvpwrvgnd_1
XFILLER_60_122 VGND VGND VPWR VPWR sky130_fd_sc_hd__decap_3
XFILLER_41_391 VGND VGND VPWR VPWR sky130_fd_sc_hd__fill_1
X_3640_ _3640_/A VGND VGND VPWR VPWR _3641_/B sky130_fd_sc_hd__clkbuf_1
X_3571_ _3798_/B _3332_/X _3571_/S VGND VGND VPWR VPWR _3571_/X sky130_fd_sc_hd__mux2_2
XFILLER_53_3 VGND VGND VPWR VPWR sky130_fd_sc_hd__decap_3
X_6290_ _6290_/A _6290_/B VGND VGND VPWR VPWR _6290_/X sky130_fd_sc_hd__or2_2
X_5310_ _5310_/A VGND VGND VPWR VPWR _5322_/A sky130_fd_sc_hd__clkbuf_1
XFILLER_5_281 VGND VGND VPWR VPWR sky130_fd_sc_hd__fill_2
X_5241_ _4222_/X _4593_/X _4934_/X _5238_/X _5948_/S0 _5948_/S1 VGND VGND VPWR VPWR
+ _5241_/X sky130_fd_sc_hd__mux4_2
X_5172_ _5210_/A _5172_/B _5274_/B _5172_/D VGND VGND VPWR VPWR _5172_/Y sky130_fd_sc_hd__nand4_2
XFILLER_68_211 VGND VGND VPWR VPWR sky130_fd_sc_hd__decap_3
XFILLER_68_200 VGND VGND VPWR VPWR sky130_fd_sc_hd__fill_1
X_4123_ _4251_/B _4122_/C _4183_/B VGND VGND VPWR VPWR _4123_/Y sky130_fd_sc_hd__o21ai_2
XTAP_TAPCELL_ROW_3_207 VGND VPWR sky130_fd_sc_hd__tapvpwrvgnd_1
XFILLER_56_417 VGND VGND VPWR VPWR sky130_fd_sc_hd__decap_3
Xinput2 cmd[0] VGND VGND VPWR VPWR input2/X sky130_fd_sc_hd__buf_1
X_4054_ _3470_/B _3712_/X _3878_/X _4053_/X _4461_/S _4140_/A VGND VGND VPWR VPWR
+ _4054_/X sky130_fd_sc_hd__mux4_2
XFILLER_36_141 VGND VGND VPWR VPWR sky130_fd_sc_hd__decap_3
XTAP_TAPCELL_ROW_82_927 VGND VPWR sky130_fd_sc_hd__tapvpwrvgnd_1
XTAP_TAPCELL_ROW_82_916 VGND VPWR sky130_fd_sc_hd__tapvpwrvgnd_1
XFILLER_24_303 VGND VGND VPWR VPWR sky130_fd_sc_hd__decap_3
XFILLER_51_111 VGND VGND VPWR VPWR sky130_fd_sc_hd__fill_1
XTAP_TAPCELL_ROW_19_350 VGND VPWR sky130_fd_sc_hd__tapvpwrvgnd_1
X_4956_ _4956_/A _6053_/A VGND VGND VPWR VPWR _4956_/X sky130_fd_sc_hd__or2_2
XFILLER_51_199 VGND VGND VPWR VPWR sky130_fd_sc_hd__decap_3
X_4887_ _4900_/A VGND VGND VPWR VPWR _4956_/A sky130_fd_sc_hd__inv_2
X_3907_ _4077_/C _3921_/A _3907_/C VGND VGND VPWR VPWR _3907_/X sky130_fd_sc_hd__or3_2
X_3838_ _3836_/X _3837_/X _4233_/A VGND VGND VPWR VPWR _3839_/B sky130_fd_sc_hd__mux2_2
X_5508_ _5508_/A1 _4878_/X _5440_/A VGND VGND VPWR VPWR _5508_/X sky130_fd_sc_hd__a21o_2
X_3769_ _3860_/A _3876_/S VGND VGND VPWR VPWR _3769_/Y sky130_fd_sc_hd__xnor2_2
X_6488_ _6488_/A _6488_/B _6487_/X VGND VGND VPWR VPWR _6489_/A sky130_fd_sc_hd__or3b_2
X_5439_ _5439_/A _5470_/A VGND VGND VPWR VPWR _5439_/Y sky130_fd_sc_hd__nand2_2
XFILLER_59_211 VGND VGND VPWR VPWR sky130_fd_sc_hd__decap_3
XFILLER_74_214 VGND VGND VPWR VPWR sky130_fd_sc_hd__decap_3
XFILLER_59_266 VGND VGND VPWR VPWR sky130_fd_sc_hd__decap_3
XFILLER_74_225 VGND VGND VPWR VPWR sky130_fd_sc_hd__decap_3
XFILLER_59_299 VGND VGND VPWR VPWR sky130_fd_sc_hd__fill_1
XFILLER_42_111 VGND VGND VPWR VPWR sky130_fd_sc_hd__decap_3
XFILLER_15_358 VGND VGND VPWR VPWR sky130_fd_sc_hd__decap_3
XFILLER_42_144 VGND VGND VPWR VPWR sky130_fd_sc_hd__decap_3
XFILLER_70_453 VGND VGND VPWR VPWR sky130_fd_sc_hd__fill_2
XFILLER_42_177 VGND VGND VPWR VPWR sky130_fd_sc_hd__decap_3
XFILLER_23_391 VGND VGND VPWR VPWR sky130_fd_sc_hd__fill_1
XPHY_EDGE_ROW_2_Left_85 VGND VGND VPWR VPWR sky130_fd_sc_hd__decap_3
XFILLER_18_6 VGND VGND VPWR VPWR sky130_fd_sc_hd__fill_1
XFILLER_65_225 VGND VGND VPWR VPWR sky130_fd_sc_hd__decap_3
XFILLER_18_141 VGND VGND VPWR VPWR sky130_fd_sc_hd__fill_1
XFILLER_33_100 VGND VGND VPWR VPWR sky130_fd_sc_hd__fill_1
XFILLER_33_122 VGND VGND VPWR VPWR sky130_fd_sc_hd__decap_3
X_4810_ _5732_/A _6472_/S _3240_/Y _4802_/X _4809_/Y VGND VGND VPWR VPWR _4810_/X
+ sky130_fd_sc_hd__o311a_2
XTAP_TAPCELL_ROW_16_320 VGND VPWR sky130_fd_sc_hd__tapvpwrvgnd_1
XFILLER_21_328 VGND VGND VPWR VPWR sky130_fd_sc_hd__decap_3
XFILLER_33_155 VGND VGND VPWR VPWR sky130_fd_sc_hd__decap_3
X_5790_ _5790_/A _5825_/A VGND VGND VPWR VPWR _5790_/X sky130_fd_sc_hd__or2_2
X_4741_ _4783_/B _4741_/B VGND VGND VPWR VPWR _4789_/B sky130_fd_sc_hd__xnor2_2
X_4672_ _4629_/B _4768_/B _4670_/Y _4671_/X _4630_/B VGND VGND VPWR VPWR _4672_/X
+ sky130_fd_sc_hd__o32a_2
X_6411_ _5918_/A _6481_/A _6408_/Y VGND VGND VPWR VPWR _6412_/B sky130_fd_sc_hd__a21oi_2
X_3623_ _3691_/A _3623_/B VGND VGND VPWR VPWR _3623_/Y sky130_fd_sc_hd__xnor2_2
X_6342_ _5467_/X _6339_/B _6341_/X _5457_/X VGND VGND VPWR VPWR _6343_/B sky130_fd_sc_hd__o22a_2
X_3554_ _3554_/A _3554_/B VGND VGND VPWR VPWR _3558_/B sky130_fd_sc_hd__nor2_2
X_6273_ _6264_/X _6272_/X _6275_/B VGND VGND VPWR VPWR _6273_/X sky130_fd_sc_hd__a21bo_2
X_3485_ _3748_/A _3578_/A _6472_/S _3484_/X VGND VGND VPWR VPWR _3485_/X sky130_fd_sc_hd__or4b_2
X_5224_ _5224_/A VGND VGND VPWR VPWR _5224_/X sky130_fd_sc_hd__clkbuf_1
XFILLER_56_203 VGND VGND VPWR VPWR sky130_fd_sc_hd__decap_3
X_5155_ _6391_/B _6306_/C VGND VGND VPWR VPWR _5274_/B sky130_fd_sc_hd__xnor2_4
XFILLER_56_236 VGND VGND VPWR VPWR sky130_fd_sc_hd__decap_3
X_5086_ _5128_/A _6275_/B VGND VGND VPWR VPWR _5110_/B sky130_fd_sc_hd__xor2_2
X_4106_ _4106_/A VGND VGND VPWR VPWR _4106_/X sky130_fd_sc_hd__clkbuf_2
X_4037_ _4035_/X _4037_/B VGND VGND VPWR VPWR _4044_/C sky130_fd_sc_hd__and2b_2
XFILLER_24_122 VGND VGND VPWR VPWR sky130_fd_sc_hd__fill_1
XFILLER_24_144 VGND VGND VPWR VPWR sky130_fd_sc_hd__decap_3
X_5988_ _3436_/X _3448_/X _5988_/C _5988_/D VGND VGND VPWR VPWR _5989_/D sky130_fd_sc_hd__and4bb_2
XFILLER_12_328 VGND VGND VPWR VPWR sky130_fd_sc_hd__decap_3
X_4939_ _6077_/B VGND VGND VPWR VPWR _4939_/Y sky130_fd_sc_hd__inv_2
XTAP_TAPCELL_ROW_50_632 VGND VPWR sky130_fd_sc_hd__tapvpwrvgnd_1
XFILLER_20_383 VGND VGND VPWR VPWR sky130_fd_sc_hd__decap_3
XFILLER_21_22 VGND VGND VPWR VPWR sky130_fd_sc_hd__fill_1
XTAP_TAPCELL_ROW_22_378 VGND VPWR sky130_fd_sc_hd__tapvpwrvgnd_1
Xoutput180 _5982_/A VGND VGND VPWR VPWR result[49] sky130_fd_sc_hd__clkdlybuf4s25_1
Xoutput191 _6004_/B VGND VGND VPWR VPWR result[59] sky130_fd_sc_hd__clkdlybuf4s25_1
XFILLER_47_214 VGND VGND VPWR VPWR sky130_fd_sc_hd__decap_3
XFILLER_47_225 VGND VGND VPWR VPWR sky130_fd_sc_hd__decap_3
XFILLER_47_258 VGND VGND VPWR VPWR sky130_fd_sc_hd__decap_3
XFILLER_46_85 VGND VGND VPWR VPWR sky130_fd_sc_hd__decap_3
XFILLER_62_217 VGND VGND VPWR VPWR sky130_fd_sc_hd__fill_2
XFILLER_15_155 VGND VGND VPWR VPWR sky130_fd_sc_hd__fill_2
XFILLER_30_147 VGND VGND VPWR VPWR sky130_fd_sc_hd__decap_3
XFILLER_11_372 VGND VGND VPWR VPWR sky130_fd_sc_hd__fill_1
Xwire230 _5228_/X VGND VGND VPWR VPWR wire230/X sky130_fd_sc_hd__clkbuf_4
XFILLER_7_13 VGND VGND VPWR VPWR sky130_fd_sc_hd__decap_3
Xwire263 _4846_/X VGND VGND VPWR VPWR wire263/X sky130_fd_sc_hd__buf_2
Xwire274 _3299_/X VGND VGND VPWR VPWR _3942_/A sky130_fd_sc_hd__buf_2
X_3270_ _5138_/A _6453_/B VGND VGND VPWR VPWR _6454_/A sky130_fd_sc_hd__or2_2
XFILLER_38_203 VGND VGND VPWR VPWR sky130_fd_sc_hd__decap_3
XFILLER_78_361 VGND VGND VPWR VPWR sky130_fd_sc_hd__decap_3
XFILLER_16_3 VGND VGND VPWR VPWR sky130_fd_sc_hd__fill_2
XFILLER_38_247 VGND VGND VPWR VPWR sky130_fd_sc_hd__decap_3
X_5911_ _6486_/C _5907_/X _5910_/X _5228_/X VGND VGND VPWR VPWR _5911_/X sky130_fd_sc_hd__a211o_2
XFILLER_34_442 VGND VGND VPWR VPWR sky130_fd_sc_hd__fill_2
XFILLER_46_280 VGND VGND VPWR VPWR sky130_fd_sc_hd__decap_3
XTAP_TAPCELL_ROW_64_757 VGND VPWR sky130_fd_sc_hd__tapvpwrvgnd_1
X_5842_ _5923_/A VGND VGND VPWR VPWR _5884_/A sky130_fd_sc_hd__inv_2
X_5773_ _5773_/A1 _5970_/B wire261/X _5750_/A VGND VGND VPWR VPWR _5773_/X sky130_fd_sc_hd__a22o_2
XFILLER_61_272 VGND VGND VPWR VPWR sky130_fd_sc_hd__decap_3
XFILLER_21_169 VGND VGND VPWR VPWR sky130_fd_sc_hd__fill_1
X_4724_ _4757_/S _4017_/X _4723_/X VGND VGND VPWR VPWR _4725_/A sky130_fd_sc_hd__o21ai_2
X_4655_ _6252_/A _6060_/D _4538_/B _4783_/A _6243_/C VGND VGND VPWR VPWR _4665_/A
+ sky130_fd_sc_hd__a2111oi_2
Xinput82 operand_b[20] VGND VGND VPWR VPWR input82/X sky130_fd_sc_hd__clkdlybuf4s25_1
Xinput71 operand_b[10] VGND VGND VPWR VPWR _6131_/A sky130_fd_sc_hd__clkdlybuf4s25_1
Xinput60 operand_a[59] VGND VGND VPWR VPWR input60/X sky130_fd_sc_hd__clkdlybuf4s25_1
X_4586_ _4586_/A _4586_/B _5534_/C _4707_/C VGND VGND VPWR VPWR _4743_/C sky130_fd_sc_hd__or4b_2
X_3606_ input4/X _4849_/C VGND VGND VPWR VPWR _6492_/A sky130_fd_sc_hd__or2_2
X_6325_ _5460_/A _5476_/S _6320_/Y _6321_/Y _6324_/X VGND VGND VPWR VPWR _6325_/Y
+ sky130_fd_sc_hd__a311oi_2
Xinput93 operand_b[30] VGND VGND VPWR VPWR input93/X sky130_fd_sc_hd__clkdlybuf4s25_1
X_3537_ _3556_/A _3538_/B _3633_/A VGND VGND VPWR VPWR _3539_/B sky130_fd_sc_hd__o21ai_2
X_6256_ _4734_/A _6255_/X _6244_/Y VGND VGND VPWR VPWR _6256_/X sky130_fd_sc_hd__a21o_2
X_3468_ _3556_/A _3357_/B _3520_/S VGND VGND VPWR VPWR _3468_/X sky130_fd_sc_hd__mux2_2
XFILLER_29_203 VGND VGND VPWR VPWR sky130_fd_sc_hd__fill_2
X_6187_ _4484_/A _6185_/Y _6186_/Y _4539_/B VGND VGND VPWR VPWR _6187_/X sky130_fd_sc_hd__o211a_2
X_5207_ _5274_/B _5204_/X _5205_/X _5206_/Y _5118_/X VGND VGND VPWR VPWR _5262_/B
+ sky130_fd_sc_hd__a32o_2
X_3399_ _3748_/A _3399_/B VGND VGND VPWR VPWR _4154_/B sky130_fd_sc_hd__nand2_2
XFILLER_76_309 VGND VGND VPWR VPWR sky130_fd_sc_hd__fill_1
X_5138_ _5138_/A _5138_/B VGND VGND VPWR VPWR _5138_/Y sky130_fd_sc_hd__nand2_2
XFILLER_44_206 VGND VGND VPWR VPWR sky130_fd_sc_hd__decap_3
X_5069_ _4997_/B _4997_/C _5034_/S _5108_/A _5057_/S VGND VGND VPWR VPWR _5072_/C
+ sky130_fd_sc_hd__a2111o_2
XTAP_TAPCELL_ROW_27_426 VGND VPWR sky130_fd_sc_hd__tapvpwrvgnd_1
XFILLER_40_401 VGND VGND VPWR VPWR sky130_fd_sc_hd__decap_3
XFILLER_52_250 VGND VGND VPWR VPWR sky130_fd_sc_hd__fill_2
XFILLER_12_114 VGND VGND VPWR VPWR sky130_fd_sc_hd__fill_2
XTAP_TAPCELL_ROW_35_492 VGND VPWR sky130_fd_sc_hd__tapvpwrvgnd_1
XFILLER_4_324 VGND VGND VPWR VPWR sky130_fd_sc_hd__fill_2
XFILLER_75_353 VGND VGND VPWR VPWR sky130_fd_sc_hd__decap_3
XFILLER_75_331 VGND VGND VPWR VPWR sky130_fd_sc_hd__decap_3
XFILLER_35_228 VGND VGND VPWR VPWR sky130_fd_sc_hd__decap_3
XFILLER_43_250 VGND VGND VPWR VPWR sky130_fd_sc_hd__decap_3
XTAP_TAPCELL_ROW_61_727 VGND VPWR sky130_fd_sc_hd__tapvpwrvgnd_1
XFILLER_43_294 VGND VGND VPWR VPWR sky130_fd_sc_hd__decap_3
X_4440_ _4485_/A VGND VGND VPWR VPWR _4440_/X sky130_fd_sc_hd__clkbuf_1
X_6110_ _6108_/X _6109_/X _6113_/A VGND VGND VPWR VPWR _6110_/X sky130_fd_sc_hd__a21o_2
X_4371_ _6059_/A _5180_/B _4365_/X _4367_/X _4370_/Y VGND VGND VPWR VPWR _4371_/X
+ sky130_fd_sc_hd__a221o_2
Xfanout609 _6474_/A VGND VGND VPWR VPWR _4990_/A1 sky130_fd_sc_hd__clkdlybuf4s25_1
X_3322_ _4842_/A _3317_/X _3321_/X VGND VGND VPWR VPWR _3322_/X sky130_fd_sc_hd__a21o_2
X_6041_ _5884_/A _5925_/A _6407_/A VGND VGND VPWR VPWR _6041_/X sky130_fd_sc_hd__a21o_2
X_3253_ _3410_/B VGND VGND VPWR VPWR _3486_/A sky130_fd_sc_hd__inv_2
XFILLER_58_309 VGND VGND VPWR VPWR sky130_fd_sc_hd__decap_3
XTAP_TAPCELL_ROW_77_871 VGND VPWR sky130_fd_sc_hd__tapvpwrvgnd_1
XFILLER_66_397 VGND VGND VPWR VPWR sky130_fd_sc_hd__decap_3
XFILLER_19_291 VGND VGND VPWR VPWR sky130_fd_sc_hd__decap_3
XFILLER_22_434 VGND VGND VPWR VPWR sky130_fd_sc_hd__fill_1
X_5825_ _5825_/A _6493_/A _6493_/B VGND VGND VPWR VPWR _5853_/B sky130_fd_sc_hd__nand3_2
X_5756_ _5734_/S _5752_/B _5723_/C _5770_/S VGND VGND VPWR VPWR _5756_/Y sky130_fd_sc_hd__a211oi_2
X_5687_ _5580_/A _5580_/B _5635_/B _5686_/X VGND VGND VPWR VPWR _5687_/X sky130_fd_sc_hd__a211o_2
X_4707_ _4586_/A _4586_/B _4707_/C _4707_/D VGND VGND VPWR VPWR _4968_/B sky130_fd_sc_hd__and4bb_2
X_4638_ _5859_/B _4637_/Y _4990_/A1 VGND VGND VPWR VPWR _4638_/X sky130_fd_sc_hd__a21o_2
X_4569_ _5696_/A _4549_/Y _4568_/X VGND VGND VPWR VPWR _4569_/Y sky130_fd_sc_hd__o21ai_2
X_6308_ _6391_/C _6308_/B VGND VGND VPWR VPWR _6308_/Y sky130_fd_sc_hd__nand2_2
X_6239_ _6239_/A _6239_/B _6238_/X VGND VGND VPWR VPWR _6239_/X sky130_fd_sc_hd__or3b_2
XFILLER_69_180 VGND VGND VPWR VPWR sky130_fd_sc_hd__decap_3
XFILLER_57_375 VGND VGND VPWR VPWR sky130_fd_sc_hd__decap_3
XFILLER_72_345 VGND VGND VPWR VPWR sky130_fd_sc_hd__decap_3
XFILLER_32_209 VGND VGND VPWR VPWR sky130_fd_sc_hd__decap_3
XFILLER_25_272 VGND VGND VPWR VPWR sky130_fd_sc_hd__decap_3
XFILLER_43_64 VGND VGND VPWR VPWR sky130_fd_sc_hd__decap_3
XFILLER_40_264 VGND VGND VPWR VPWR sky130_fd_sc_hd__fill_1
XFILLER_67_106 VGND VGND VPWR VPWR sky130_fd_sc_hd__fill_1
XFILLER_48_342 VGND VGND VPWR VPWR sky130_fd_sc_hd__fill_2
XFILLER_48_353 VGND VGND VPWR VPWR sky130_fd_sc_hd__decap_3
XFILLER_63_312 VGND VGND VPWR VPWR sky130_fd_sc_hd__decap_3
XTAP_TAPCELL_ROW_74_841 VGND VPWR sky130_fd_sc_hd__tapvpwrvgnd_1
X_3940_ _3940_/A VGND VGND VPWR VPWR _5012_/C sky130_fd_sc_hd__clkbuf_1
XFILLER_63_389 VGND VGND VPWR VPWR sky130_fd_sc_hd__decap_3
XFILLER_63_356 VGND VGND VPWR VPWR sky130_fd_sc_hd__decap_3
XFILLER_31_220 VGND VGND VPWR VPWR sky130_fd_sc_hd__decap_3
XFILLER_31_231 VGND VGND VPWR VPWR sky130_fd_sc_hd__decap_3
X_3871_ wire497/A _3960_/A _4006_/C _3928_/D VGND VGND VPWR VPWR _3871_/Y sky130_fd_sc_hd__o31ai_2
X_5610_ wire281/X wire282/X _5637_/A VGND VGND VPWR VPWR _5610_/X sky130_fd_sc_hd__mux2_2
X_5541_ _6317_/S _5530_/A _6318_/S VGND VGND VPWR VPWR _5541_/X sky130_fd_sc_hd__o21a_2
X_5472_ _5458_/A _5412_/B _5471_/X VGND VGND VPWR VPWR _5473_/B sky130_fd_sc_hd__o21a_2
X_4423_ _4422_/A _4374_/A _5010_/S VGND VGND VPWR VPWR _4423_/Y sky130_fd_sc_hd__a21oi_2
X_4354_ _4352_/Y _4353_/Y _4354_/S VGND VGND VPWR VPWR _4358_/A sky130_fd_sc_hd__mux2_2
Xfanout406 input81/X VGND VGND VPWR VPWR fanout406/X sky130_fd_sc_hd__clkdlybuf4s25_1
Xfanout417 _6151_/A VGND VGND VPWR VPWR _6062_/D sky130_fd_sc_hd__clkdlybuf4s25_1
Xfanout439 fanout444/X VGND VGND VPWR VPWR _6424_/A sky130_fd_sc_hd__clkdlybuf4s25_1
X_3305_ _4842_/A _4372_/B VGND VGND VPWR VPWR _3305_/Y sky130_fd_sc_hd__nor2_2
X_6024_ _6060_/D _6024_/B VGND VGND VPWR VPWR _6025_/D sky130_fd_sc_hd__and2_2
X_4285_ _4507_/S _3424_/B _5216_/A VGND VGND VPWR VPWR _4285_/X sky130_fd_sc_hd__a21o_2
XFILLER_39_331 VGND VGND VPWR VPWR sky130_fd_sc_hd__decap_3
X_3236_ _6447_/A0 _6447_/A1 _6450_/A0 _6450_/A1 _6447_/S0 _3575_/S1 VGND VGND VPWR
+ VPWR _3236_/X sky130_fd_sc_hd__mux4_2
XFILLER_27_515 VGND VGND VPWR VPWR sky130_fd_sc_hd__fill_1
XFILLER_54_312 VGND VGND VPWR VPWR sky130_fd_sc_hd__decap_3
XFILLER_66_150 VGND VGND VPWR VPWR sky130_fd_sc_hd__fill_2
XTAP_TAPCELL_ROW_37_510 VGND VPWR sky130_fd_sc_hd__tapvpwrvgnd_1
XFILLER_66_183 VGND VGND VPWR VPWR sky130_fd_sc_hd__decap_3
XFILLER_54_389 VGND VGND VPWR VPWR sky130_fd_sc_hd__fill_2
XFILLER_22_231 VGND VGND VPWR VPWR sky130_fd_sc_hd__decap_3
XFILLER_22_253 VGND VGND VPWR VPWR sky130_fd_sc_hd__decap_3
XFILLER_22_286 VGND VGND VPWR VPWR sky130_fd_sc_hd__decap_3
X_5808_ _5808_/A VGND VGND VPWR VPWR _6004_/A sky130_fd_sc_hd__buf_1
XTAP_TAPCELL_ROW_80_899 VGND VPWR sky130_fd_sc_hd__tapvpwrvgnd_1
X_5739_ _5739_/A _5739_/B VGND VGND VPWR VPWR _5739_/Y sky130_fd_sc_hd__nor2_2
XFILLER_1_113 VGND VGND VPWR VPWR sky130_fd_sc_hd__fill_1
XTAP_TAPCELL_ROW_9_257 VGND VPWR sky130_fd_sc_hd__tapvpwrvgnd_1
XFILLER_64_109 VGND VGND VPWR VPWR sky130_fd_sc_hd__fill_1
XFILLER_45_323 VGND VGND VPWR VPWR sky130_fd_sc_hd__decap_3
XFILLER_57_172 VGND VGND VPWR VPWR sky130_fd_sc_hd__decap_3
XFILLER_45_378 VGND VGND VPWR VPWR sky130_fd_sc_hd__decap_3
XTAP_TAPCELL_ROW_71_822 VGND VPWR sky130_fd_sc_hd__tapvpwrvgnd_1
XFILLER_72_186 VGND VGND VPWR VPWR sky130_fd_sc_hd__decap_3
XFILLER_60_315 VGND VGND VPWR VPWR sky130_fd_sc_hd__decap_3
XFILLER_54_85 VGND VGND VPWR VPWR sky130_fd_sc_hd__fill_1
XTAP_TAPCELL_ROW_43_568 VGND VPWR sky130_fd_sc_hd__tapvpwrvgnd_1
XFILLER_60_348 VGND VGND VPWR VPWR sky130_fd_sc_hd__decap_3
X_4070_ _3755_/S _3753_/Y _3907_/X _3910_/X VGND VGND VPWR VPWR _4070_/Y sky130_fd_sc_hd__o31ai_2
XFILLER_48_150 VGND VGND VPWR VPWR sky130_fd_sc_hd__decap_3
XFILLER_36_323 VGND VGND VPWR VPWR sky130_fd_sc_hd__decap_3
XFILLER_48_183 VGND VGND VPWR VPWR sky130_fd_sc_hd__decap_3
X_4972_ _3932_/A _4279_/B _4632_/X _4971_/X _5175_/S _4879_/S VGND VGND VPWR VPWR
+ _4973_/B sky130_fd_sc_hd__mux4_2
X_3923_ _3615_/A _3615_/B _3615_/C _3919_/B _3922_/Y VGND VGND VPWR VPWR _3925_/B
+ sky130_fd_sc_hd__a311o_2
X_3854_ _4132_/A _3928_/C _3823_/Y _4611_/A _3853_/X VGND VGND VPWR VPWR _5991_/C
+ sky130_fd_sc_hd__o221ai_2
X_3785_ _3779_/X _3782_/Y _3784_/X VGND VGND VPWR VPWR _3785_/Y sky130_fd_sc_hd__a21oi_2
X_5524_ _5556_/B _5675_/B VGND VGND VPWR VPWR _6318_/S sky130_fd_sc_hd__nor2_2
XFILLER_8_290 VGND VGND VPWR VPWR sky130_fd_sc_hd__fill_2
X_5455_ _5476_/S _6322_/A VGND VGND VPWR VPWR _5459_/B sky130_fd_sc_hd__and2b_2
X_4406_ _4315_/Y _4449_/B _4403_/X _4450_/B VGND VGND VPWR VPWR _4407_/B sky130_fd_sc_hd__a31o_2
X_5386_ _5383_/Y _5384_/X _5374_/A _6365_/A VGND VGND VPWR VPWR _5386_/X sky130_fd_sc_hd__o211a_2
X_4337_ _4469_/A _6021_/D _4336_/X VGND VGND VPWR VPWR _4337_/X sky130_fd_sc_hd__o21a_2
X_4268_ _4430_/A _4268_/B VGND VGND VPWR VPWR _4268_/Y sky130_fd_sc_hd__nor2_2
X_6007_ _6306_/A _6292_/A _6291_/C VGND VGND VPWR VPWR _6008_/B sky130_fd_sc_hd__and3_2
X_3219_ _6428_/A2 _5962_/A _3451_/S VGND VGND VPWR VPWR _3450_/B sky130_fd_sc_hd__mux2_2
XFILLER_39_183 VGND VGND VPWR VPWR sky130_fd_sc_hd__decap_3
X_4199_ _4199_/A VGND VGND VPWR VPWR _4199_/X sky130_fd_sc_hd__clkbuf_1
XFILLER_54_131 VGND VGND VPWR VPWR sky130_fd_sc_hd__decap_3
XFILLER_27_389 VGND VGND VPWR VPWR sky130_fd_sc_hd__decap_3
XFILLER_54_197 VGND VGND VPWR VPWR sky130_fd_sc_hd__fill_1
XFILLER_42_348 VGND VGND VPWR VPWR sky130_fd_sc_hd__decap_3
XFILLER_50_392 VGND VGND VPWR VPWR sky130_fd_sc_hd__decap_3
XTAP_TAPCELL_ROW_40_538 VGND VPWR sky130_fd_sc_hd__tapvpwrvgnd_1
XFILLER_10_289 VGND VGND VPWR VPWR sky130_fd_sc_hd__decap_3
XFILLER_77_223 VGND VGND VPWR VPWR sky130_fd_sc_hd__fill_1
XFILLER_49_96 VGND VGND VPWR VPWR sky130_fd_sc_hd__fill_1
XFILLER_77_234 VGND VGND VPWR VPWR sky130_fd_sc_hd__decap_3
XFILLER_45_142 VGND VGND VPWR VPWR sky130_fd_sc_hd__decap_3
XFILLER_18_389 VGND VGND VPWR VPWR sky130_fd_sc_hd__decap_3
XFILLER_33_326 VGND VGND VPWR VPWR sky130_fd_sc_hd__decap_3
XFILLER_33_337 VGND VGND VPWR VPWR sky130_fd_sc_hd__decap_3
XFILLER_45_175 VGND VGND VPWR VPWR sky130_fd_sc_hd__decap_3
XTAP_TAPCELL_ROW_56_682 VGND VPWR sky130_fd_sc_hd__tapvpwrvgnd_1
XFILLER_60_178 VGND VGND VPWR VPWR sky130_fd_sc_hd__decap_3
XFILLER_60_167 VGND VGND VPWR VPWR sky130_fd_sc_hd__decap_3
X_3570_ _3530_/X _3569_/X _3800_/A VGND VGND VPWR VPWR _3570_/X sky130_fd_sc_hd__mux2_2
X_5240_ _5739_/A VGND VGND VPWR VPWR _5381_/S sky130_fd_sc_hd__clkbuf_1
X_5171_ _5144_/B _4312_/A _4320_/A VGND VGND VPWR VPWR _5172_/D sky130_fd_sc_hd__a21o_2
XPHY_EDGE_ROW_18_Right_18 VGND VGND VPWR VPWR sky130_fd_sc_hd__decap_3
X_4122_ _4251_/B _4183_/B _4122_/C VGND VGND VPWR VPWR _4122_/X sky130_fd_sc_hd__or3_2
XTAP_TAPCELL_ROW_3_208 VGND VPWR sky130_fd_sc_hd__tapvpwrvgnd_1
XFILLER_68_256 VGND VGND VPWR VPWR sky130_fd_sc_hd__fill_2
XFILLER_68_234 VGND VGND VPWR VPWR sky130_fd_sc_hd__decap_3
XFILLER_56_429 VGND VGND VPWR VPWR sky130_fd_sc_hd__fill_2
X_4053_ _4014_/X _4052_/X _4221_/S VGND VGND VPWR VPWR _4053_/X sky130_fd_sc_hd__mux2_2
Xinput3 cmd[1] VGND VGND VPWR VPWR input3/X sky130_fd_sc_hd__clkdlybuf4s25_1
XTAP_TAPCELL_ROW_82_928 VGND VPWR sky130_fd_sc_hd__tapvpwrvgnd_1
XTAP_TAPCELL_ROW_82_917 VGND VPWR sky130_fd_sc_hd__tapvpwrvgnd_1
XFILLER_36_164 VGND VGND VPWR VPWR sky130_fd_sc_hd__fill_2
XTAP_TAPCELL_ROW_19_351 VGND VPWR sky130_fd_sc_hd__tapvpwrvgnd_1
XFILLER_36_197 VGND VGND VPWR VPWR sky130_fd_sc_hd__decap_3
X_4955_ _4485_/A _4485_/B _4784_/X _5110_/A VGND VGND VPWR VPWR _4997_/B sky130_fd_sc_hd__a211o_2
XPHY_EDGE_ROW_27_Right_27 VGND VGND VPWR VPWR sky130_fd_sc_hd__decap_3
XFILLER_51_167 VGND VGND VPWR VPWR sky130_fd_sc_hd__fill_1
X_3906_ _3965_/A _6151_/B VGND VGND VPWR VPWR _4076_/A sky130_fd_sc_hd__xor2_2
X_4886_ _4726_/S _3398_/X _4875_/X VGND VGND VPWR VPWR _4886_/X sky130_fd_sc_hd__a21o_2
X_3837_ _3314_/X _3377_/X _3388_/X _3376_/X _3633_/A _3800_/A VGND VGND VPWR VPWR
+ _3837_/X sky130_fd_sc_hd__mux4_2
X_3768_ _6126_/A _3745_/B _3767_/X VGND VGND VPWR VPWR _3876_/S sky130_fd_sc_hd__a21boi_2
X_5507_ _5045_/X _5219_/X _5338_/X _5506_/X _5616_/A _5548_/S VGND VGND VPWR VPWR
+ _5507_/X sky130_fd_sc_hd__mux4_2
X_6487_ _6485_/A _6492_/B _6484_/Y _6486_/X VGND VGND VPWR VPWR _6487_/X sky130_fd_sc_hd__a31o_2
X_3699_ _3443_/X _3698_/X _3798_/A VGND VGND VPWR VPWR _3699_/X sky130_fd_sc_hd__mux2_2
X_5438_ _5438_/A _5538_/A _5625_/A VGND VGND VPWR VPWR _5470_/A sky130_fd_sc_hd__or3_2
XPHY_EDGE_ROW_36_Right_36 VGND VGND VPWR VPWR sky130_fd_sc_hd__decap_3
X_5369_ _5369_/A VGND VGND VPWR VPWR _5422_/C sky130_fd_sc_hd__clkbuf_1
XFILLER_59_234 VGND VGND VPWR VPWR sky130_fd_sc_hd__decap_3
XFILLER_59_223 VGND VGND VPWR VPWR sky130_fd_sc_hd__fill_1
XFILLER_74_237 VGND VGND VPWR VPWR sky130_fd_sc_hd__fill_2
XFILLER_27_142 VGND VGND VPWR VPWR sky130_fd_sc_hd__fill_1
XFILLER_27_164 VGND VGND VPWR VPWR sky130_fd_sc_hd__decap_3
XFILLER_27_175 VGND VGND VPWR VPWR sky130_fd_sc_hd__decap_3
XPHY_EDGE_ROW_45_Right_45 VGND VGND VPWR VPWR sky130_fd_sc_hd__decap_3
XFILLER_82_281 VGND VGND VPWR VPWR sky130_fd_sc_hd__decap_3
XFILLER_70_421 VGND VGND VPWR VPWR sky130_fd_sc_hd__fill_2
XFILLER_15_337 VGND VGND VPWR VPWR sky130_fd_sc_hd__fill_2
XFILLER_27_197 VGND VGND VPWR VPWR sky130_fd_sc_hd__fill_1
XFILLER_42_156 VGND VGND VPWR VPWR sky130_fd_sc_hd__decap_3
XTAP_TAPCELL_ROW_53_652 VGND VPWR sky130_fd_sc_hd__tapvpwrvgnd_1
XFILLER_30_329 VGND VGND VPWR VPWR sky130_fd_sc_hd__decap_3
Xwire423 wire423/A VGND VGND VPWR VPWR wire423/X sky130_fd_sc_hd__clkbuf_4
XFILLER_51_86 VGND VGND VPWR VPWR sky130_fd_sc_hd__fill_2
XPHY_EDGE_ROW_54_Right_54 VGND VGND VPWR VPWR sky130_fd_sc_hd__decap_3
Xload_slew428 _5764_/S0 VGND VGND VPWR VPWR _5801_/S0 sky130_fd_sc_hd__buf_6
XFILLER_38_418 VGND VGND VPWR VPWR sky130_fd_sc_hd__fill_2
XFILLER_65_237 VGND VGND VPWR VPWR sky130_fd_sc_hd__decap_3
XFILLER_65_215 VGND VGND VPWR VPWR sky130_fd_sc_hd__decap_3
XPHY_EDGE_ROW_63_Right_63 VGND VGND VPWR VPWR sky130_fd_sc_hd__decap_3
XFILLER_18_164 VGND VGND VPWR VPWR sky130_fd_sc_hd__decap_3
XFILLER_46_484 VGND VGND VPWR VPWR sky130_fd_sc_hd__fill_1
XFILLER_61_410 VGND VGND VPWR VPWR sky130_fd_sc_hd__fill_2
XTAP_TAPCELL_ROW_16_321 VGND VPWR sky130_fd_sc_hd__tapvpwrvgnd_1
XFILLER_73_281 VGND VGND VPWR VPWR sky130_fd_sc_hd__decap_3
XFILLER_33_167 VGND VGND VPWR VPWR sky130_fd_sc_hd__fill_1
XFILLER_33_178 VGND VGND VPWR VPWR sky130_fd_sc_hd__decap_3
XFILLER_14_381 VGND VGND VPWR VPWR sky130_fd_sc_hd__decap_3
X_4740_ _4443_/A _4443_/B _4737_/X _4738_/X _4739_/X VGND VGND VPWR VPWR _4741_/B
+ sky130_fd_sc_hd__a32o_2
X_4671_ _4679_/A _4679_/B _6243_/C VGND VGND VPWR VPWR _4671_/X sky130_fd_sc_hd__a21o_2
X_6410_ _6410_/A _6479_/A VGND VGND VPWR VPWR _6481_/A sky130_fd_sc_hd__nand2_2
X_3622_ _3600_/B _3568_/B _3621_/X VGND VGND VPWR VPWR _3623_/B sky130_fd_sc_hd__a21o_2
X_6341_ _5460_/A _6338_/Y _6339_/X _6340_/X VGND VGND VPWR VPWR _6341_/X sky130_fd_sc_hd__a31o_2
XPHY_EDGE_ROW_72_Right_72 VGND VGND VPWR VPWR sky130_fd_sc_hd__decap_3
X_3553_ _3479_/A _3479_/C _3668_/A _3679_/A VGND VGND VPWR VPWR _3553_/X sky130_fd_sc_hd__a211o_2
X_6272_ _5078_/B _6264_/B _6266_/X _6271_/X VGND VGND VPWR VPWR _6272_/X sky130_fd_sc_hd__a31o_2
X_3484_ _3387_/X _3388_/X _3482_/X _3483_/X _3559_/D _4025_/S1 VGND VGND VPWR VPWR
+ _3484_/X sky130_fd_sc_hd__mux4_2
X_5223_ _5200_/B _6391_/C VGND VGND VPWR VPWR _5223_/X sky130_fd_sc_hd__and2b_2
X_5154_ _5188_/S _6383_/A VGND VGND VPWR VPWR _5210_/B sky130_fd_sc_hd__nand2_2
X_4105_ _6427_/A _4097_/X _5440_/B VGND VGND VPWR VPWR _4105_/X sky130_fd_sc_hd__a21bo_2
XFILLER_29_429 VGND VGND VPWR VPWR sky130_fd_sc_hd__decap_3
XFILLER_56_215 VGND VGND VPWR VPWR sky130_fd_sc_hd__decap_3
X_5085_ _5085_/A _5123_/C VGND VGND VPWR VPWR _5085_/Y sky130_fd_sc_hd__nor2_2
XPHY_EDGE_ROW_81_Right_81 VGND VGND VPWR VPWR sky130_fd_sc_hd__decap_3
XFILLER_37_440 VGND VGND VPWR VPWR sky130_fd_sc_hd__decap_3
XFILLER_56_248 VGND VGND VPWR VPWR sky130_fd_sc_hd__decap_3
XFILLER_56_259 VGND VGND VPWR VPWR sky130_fd_sc_hd__fill_1
X_4036_ _4049_/S _6162_/A VGND VGND VPWR VPWR _4037_/B sky130_fd_sc_hd__or2b_2
XFILLER_64_270 VGND VGND VPWR VPWR sky130_fd_sc_hd__decap_3
XFILLER_52_421 VGND VGND VPWR VPWR sky130_fd_sc_hd__fill_2
XFILLER_12_318 VGND VGND VPWR VPWR sky130_fd_sc_hd__fill_2
X_5987_ _6113_/A _3323_/X _3337_/Y _3297_/Y _3374_/X VGND VGND VPWR VPWR _5989_/C
+ sky130_fd_sc_hd__a2111oi_2
X_4938_ _4954_/D _4898_/B _4903_/X _4900_/A VGND VGND VPWR VPWR _4938_/X sky130_fd_sc_hd__o22a_2
XTAP_TAPCELL_ROW_50_633 VGND VPWR sky130_fd_sc_hd__tapvpwrvgnd_1
XANTENNA_30 _3806_/X VGND VGND VPWR VPWR sky130_fd_sc_hd__diode_2
X_4869_ _4818_/A _4922_/A _4823_/A _4867_/X VGND VGND VPWR VPWR _4869_/Y sky130_fd_sc_hd__a31oi_2
XTAP_TAPCELL_ROW_22_379 VGND VPWR sky130_fd_sc_hd__tapvpwrvgnd_1
Xoutput170 _3492_/Y VGND VGND VPWR VPWR result[3] sky130_fd_sc_hd__clkdlybuf4s25_1
Xoutput181 _3545_/Y VGND VGND VPWR VPWR result[4] sky130_fd_sc_hd__clkdlybuf4s25_1
Xoutput192 _3605_/X VGND VGND VPWR VPWR result[5] sky130_fd_sc_hd__clkdlybuf4s25_1
XTAP_TAPCELL_ROW_58_700 VGND VPWR sky130_fd_sc_hd__tapvpwrvgnd_1
XFILLER_47_237 VGND VGND VPWR VPWR sky130_fd_sc_hd__decap_3
XFILLER_15_101 VGND VGND VPWR VPWR sky130_fd_sc_hd__decap_3
XFILLER_15_145 VGND VGND VPWR VPWR sky130_fd_sc_hd__fill_1
XFILLER_15_167 VGND VGND VPWR VPWR sky130_fd_sc_hd__fill_1
XFILLER_70_262 VGND VGND VPWR VPWR sky130_fd_sc_hd__decap_3
XFILLER_70_251 VGND VGND VPWR VPWR sky130_fd_sc_hd__fill_1
XFILLER_30_159 VGND VGND VPWR VPWR sky130_fd_sc_hd__decap_3
XFILLER_62_85 VGND VGND VPWR VPWR sky130_fd_sc_hd__fill_1
XFILLER_11_362 VGND VGND VPWR VPWR sky130_fd_sc_hd__fill_2
XFILLER_38_226 VGND VGND VPWR VPWR sky130_fd_sc_hd__decap_3
XFILLER_38_259 VGND VGND VPWR VPWR sky130_fd_sc_hd__decap_3
X_5910_ _5908_/Y _5909_/X _5975_/A VGND VGND VPWR VPWR _5910_/X sky130_fd_sc_hd__o21a_2
XFILLER_34_421 VGND VGND VPWR VPWR sky130_fd_sc_hd__decap_3
XFILLER_46_292 VGND VGND VPWR VPWR sky130_fd_sc_hd__decap_3
XTAP_TAPCELL_ROW_64_758 VGND VPWR sky130_fd_sc_hd__tapvpwrvgnd_1
X_5841_ _5923_/A _5874_/B VGND VGND VPWR VPWR _5844_/A sky130_fd_sc_hd__nand2_2
XFILLER_61_240 VGND VGND VPWR VPWR sky130_fd_sc_hd__decap_3
XFILLER_21_104 VGND VGND VPWR VPWR sky130_fd_sc_hd__decap_3
X_5772_ _5968_/A _6033_/B _5771_/X VGND VGND VPWR VPWR _5772_/X sky130_fd_sc_hd__o21a_2
XFILLER_61_284 VGND VGND VPWR VPWR sky130_fd_sc_hd__fill_1
X_4723_ _4726_/S _4723_/B VGND VGND VPWR VPWR _4723_/X sky130_fd_sc_hd__or2_2
X_4654_ _4695_/A _6061_/B VGND VGND VPWR VPWR _4654_/Y sky130_fd_sc_hd__xnor2_2
Xinput72 operand_b[11] VGND VGND VPWR VPWR input72/X sky130_fd_sc_hd__clkdlybuf4s25_1
Xinput61 operand_a[5] VGND VGND VPWR VPWR input61/X sky130_fd_sc_hd__clkdlybuf4s25_1
Xinput50 operand_a[4] VGND VGND VPWR VPWR input50/X sky130_fd_sc_hd__clkdlybuf4s25_1
X_4585_ _4541_/S _4575_/Y _4576_/Y _4580_/X _4584_/X VGND VGND VPWR VPWR _4612_/C
+ sky130_fd_sc_hd__a2111o_2
X_3605_ _4094_/A _3561_/Y _3562_/Y _3604_/X VGND VGND VPWR VPWR _3605_/X sky130_fd_sc_hd__a211o_2
X_6324_ _6322_/Y _6323_/X _6324_/S VGND VGND VPWR VPWR _6324_/X sky130_fd_sc_hd__mux2_2
Xinput94 operand_b[31] VGND VGND VPWR VPWR _6247_/B sky130_fd_sc_hd__clkdlybuf4s25_1
Xinput83 operand_b[21] VGND VGND VPWR VPWR _6173_/B sky130_fd_sc_hd__clkdlybuf4s25_1
X_3536_ _4154_/B _3509_/X _3514_/X _3525_/X _3535_/Y VGND VGND VPWR VPWR _3536_/X
+ sky130_fd_sc_hd__o2111a_2
X_6255_ _6243_/A _6250_/Y _6252_/Y _4695_/A _6254_/Y VGND VGND VPWR VPWR _6255_/X
+ sky130_fd_sc_hd__o221a_2
X_5206_ _5210_/B _5274_/B VGND VGND VPWR VPWR _5206_/Y sky130_fd_sc_hd__nor2_2
X_3467_ _3489_/A _3467_/B VGND VGND VPWR VPWR _3467_/Y sky130_fd_sc_hd__xnor2_2
X_6186_ _6189_/A _6221_/C _4484_/A VGND VGND VPWR VPWR _6186_/Y sky130_fd_sc_hd__o21ai_2
X_3398_ _3398_/A _3398_/B VGND VGND VPWR VPWR _3398_/X sky130_fd_sc_hd__and2_2
XFILLER_69_340 VGND VGND VPWR VPWR sky130_fd_sc_hd__fill_2
X_5137_ _5137_/A _5137_/B VGND VGND VPWR VPWR _5137_/Y sky130_fd_sc_hd__nand2_2
XFILLER_57_513 VGND VGND VPWR VPWR sky130_fd_sc_hd__decap_3
XFILLER_29_237 VGND VGND VPWR VPWR sky130_fd_sc_hd__decap_3
X_5068_ _4997_/B _4997_/C _5034_/S _5108_/A _6298_/A VGND VGND VPWR VPWR _5072_/B
+ sky130_fd_sc_hd__a2111o_2
X_4019_ _4019_/A VGND VGND VPWR VPWR _4288_/A sky130_fd_sc_hd__clkbuf_1
XFILLER_37_281 VGND VGND VPWR VPWR sky130_fd_sc_hd__decap_3
XPHY_EDGE_ROW_0_Right_0 VGND VGND VPWR VPWR sky130_fd_sc_hd__decap_3
XFILLER_40_424 VGND VGND VPWR VPWR sky130_fd_sc_hd__decap_3
XFILLER_52_273 VGND VGND VPWR VPWR sky130_fd_sc_hd__decap_3
XFILLER_12_137 VGND VGND VPWR VPWR sky130_fd_sc_hd__decap_3
XFILLER_12_159 VGND VGND VPWR VPWR sky130_fd_sc_hd__decap_3
XFILLER_32_11 VGND VGND VPWR VPWR sky130_fd_sc_hd__fill_1
XTAP_TAPCELL_ROW_35_493 VGND VPWR sky130_fd_sc_hd__tapvpwrvgnd_1
XFILLER_32_88 VGND VGND VPWR VPWR sky130_fd_sc_hd__fill_2
XPHY_EDGE_ROW_26_Left_109 VGND VGND VPWR VPWR sky130_fd_sc_hd__decap_3
XFILLER_57_52 VGND VGND VPWR VPWR sky130_fd_sc_hd__decap_3
XFILLER_35_207 VGND VGND VPWR VPWR sky130_fd_sc_hd__decap_3
XFILLER_16_421 VGND VGND VPWR VPWR sky130_fd_sc_hd__fill_1
XFILLER_28_270 VGND VGND VPWR VPWR sky130_fd_sc_hd__decap_3
XPHY_EDGE_ROW_35_Left_118 VGND VGND VPWR VPWR sky130_fd_sc_hd__decap_3
XFILLER_31_402 VGND VGND VPWR VPWR sky130_fd_sc_hd__fill_2
XFILLER_43_262 VGND VGND VPWR VPWR sky130_fd_sc_hd__decap_3
XTAP_TAPCELL_ROW_61_728 VGND VPWR sky130_fd_sc_hd__tapvpwrvgnd_1
XPHY_EDGE_ROW_44_Left_127 VGND VGND VPWR VPWR sky130_fd_sc_hd__decap_3
X_4370_ _4370_/A _4370_/B VGND VGND VPWR VPWR _4370_/Y sky130_fd_sc_hd__nor2_2
X_3321_ _3748_/A _3633_/A _4150_/B VGND VGND VPWR VPWR _3321_/X sky130_fd_sc_hd__and3_2
X_6040_ _6040_/A _6040_/B VGND VGND VPWR VPWR _6407_/A sky130_fd_sc_hd__nand2_2
X_3252_ _3264_/A _4106_/A _4199_/A _3250_/Y _4200_/A VGND VGND VPWR VPWR _3252_/X
+ sky130_fd_sc_hd__o32a_2
XFILLER_39_513 VGND VGND VPWR VPWR sky130_fd_sc_hd__decap_3
XTAP_TAPCELL_ROW_77_872 VGND VPWR sky130_fd_sc_hd__tapvpwrvgnd_1
XPHY_EDGE_ROW_53_Left_136 VGND VGND VPWR VPWR sky130_fd_sc_hd__decap_3
XFILLER_66_365 VGND VGND VPWR VPWR sky130_fd_sc_hd__fill_2
XFILLER_34_240 VGND VGND VPWR VPWR sky130_fd_sc_hd__decap_3
XFILLER_22_413 VGND VGND VPWR VPWR sky130_fd_sc_hd__fill_2
XFILLER_34_262 VGND VGND VPWR VPWR sky130_fd_sc_hd__decap_3
X_5824_ _6493_/A _6493_/B _5825_/A VGND VGND VPWR VPWR _5824_/X sky130_fd_sc_hd__a21o_2
X_5755_ _5734_/S _5752_/B _5723_/B _5770_/S VGND VGND VPWR VPWR _5760_/A sky130_fd_sc_hd__a211oi_2
XTAP_TAPCELL_ROW_32_463 VGND VPWR sky130_fd_sc_hd__tapvpwrvgnd_1
X_5686_ _6346_/A _6344_/A _5635_/C VGND VGND VPWR VPWR _5686_/X sky130_fd_sc_hd__a21o_2
X_4706_ _4262_/X _4263_/Y _4537_/A _4537_/B _4178_/D VGND VGND VPWR VPWR _4707_/D
+ sky130_fd_sc_hd__a221oi_2
XPHY_EDGE_ROW_62_Left_145 VGND VGND VPWR VPWR sky130_fd_sc_hd__decap_3
X_4637_ _6473_/S _4637_/B VGND VGND VPWR VPWR _4637_/Y sky130_fd_sc_hd__nand2_2
X_4568_ _4568_/A1 _4556_/Y _4560_/Y _3704_/A _4567_/X VGND VGND VPWR VPWR _4568_/X
+ sky130_fd_sc_hd__o221a_2
X_6307_ _6393_/A _6309_/C VGND VGND VPWR VPWR _6308_/B sky130_fd_sc_hd__xor2_2
X_4499_ _4320_/A _4541_/S _4627_/B _4498_/X VGND VGND VPWR VPWR _4499_/X sky130_fd_sc_hd__a31o_2
X_3519_ _6114_/A _3640_/A _3600_/C _3612_/B _3518_/Y VGND VGND VPWR VPWR _3519_/Y
+ sky130_fd_sc_hd__a221oi_2
X_6238_ input89/X _6231_/X _6232_/X _6243_/D _6237_/X VGND VGND VPWR VPWR _6238_/X
+ sky130_fd_sc_hd__o221a_2
X_6169_ _4230_/A _6161_/Y _6157_/Y _4049_/S _6168_/Y VGND VGND VPWR VPWR _6198_/B
+ sky130_fd_sc_hd__o221a_2
XPHY_EDGE_ROW_71_Left_154 VGND VGND VPWR VPWR sky130_fd_sc_hd__decap_3
XFILLER_27_11 VGND VGND VPWR VPWR sky130_fd_sc_hd__decap_3
XFILLER_69_192 VGND VGND VPWR VPWR sky130_fd_sc_hd__decap_3
XFILLER_57_343 VGND VGND VPWR VPWR sky130_fd_sc_hd__decap_3
XFILLER_57_321 VGND VGND VPWR VPWR sky130_fd_sc_hd__decap_3
XFILLER_45_505 VGND VGND VPWR VPWR sky130_fd_sc_hd__decap_3
XFILLER_27_55 VGND VGND VPWR VPWR sky130_fd_sc_hd__fill_1
XFILLER_72_335 VGND VGND VPWR VPWR sky130_fd_sc_hd__fill_1
XFILLER_72_357 VGND VGND VPWR VPWR sky130_fd_sc_hd__decap_3
XFILLER_25_262 VGND VGND VPWR VPWR sky130_fd_sc_hd__decap_3
XFILLER_40_221 VGND VGND VPWR VPWR sky130_fd_sc_hd__decap_3
XFILLER_40_243 VGND VGND VPWR VPWR sky130_fd_sc_hd__decap_3
XFILLER_9_406 VGND VGND VPWR VPWR sky130_fd_sc_hd__decap_3
XPHY_EDGE_ROW_80_Left_163 VGND VGND VPWR VPWR sky130_fd_sc_hd__decap_3
XFILLER_4_59 VGND VGND VPWR VPWR sky130_fd_sc_hd__fill_2
XFILLER_48_321 VGND VGND VPWR VPWR sky130_fd_sc_hd__decap_3
XFILLER_48_365 VGND VGND VPWR VPWR sky130_fd_sc_hd__decap_3
XTAP_TAPCELL_ROW_74_842 VGND VPWR sky130_fd_sc_hd__tapvpwrvgnd_1
XFILLER_63_324 VGND VGND VPWR VPWR sky130_fd_sc_hd__decap_3
XFILLER_16_251 VGND VGND VPWR VPWR sky130_fd_sc_hd__fill_1
X_3870_ _3870_/A _3870_/B _3869_/X VGND VGND VPWR VPWR _3928_/D sky130_fd_sc_hd__or3b_2
X_5540_ _5470_/A _5538_/B _6494_/A VGND VGND VPWR VPWR _5540_/X sky130_fd_sc_hd__a21o_2
XFILLER_76_3 VGND VGND VPWR VPWR sky130_fd_sc_hd__fill_1
X_5471_ _5458_/A _5412_/B _5460_/A VGND VGND VPWR VPWR _5471_/X sky130_fd_sc_hd__a21o_2
X_4422_ _4422_/A _5732_/B VGND VGND VPWR VPWR _4422_/Y sky130_fd_sc_hd__nand2_2
X_4353_ _4355_/A _6173_/A _4353_/C VGND VGND VPWR VPWR _4353_/Y sky130_fd_sc_hd__nor3_2
Xfanout407 _4238_/B VGND VGND VPWR VPWR _6171_/B sky130_fd_sc_hd__clkdlybuf4s25_1
Xfanout418 input72/X VGND VGND VPWR VPWR _6151_/A sky130_fd_sc_hd__clkdlybuf4s25_1
Xfanout429 _3706_/S VGND VGND VPWR VPWR _5963_/S0 sky130_fd_sc_hd__clkdlybuf4s25_1
X_4284_ _4268_/B _4272_/X _4283_/Y VGND VGND VPWR VPWR _4284_/Y sky130_fd_sc_hd__a21oi_2
X_3304_ _6431_/A0 _6429_/B _5946_/A3 _6428_/A2 _3306_/C _3590_/B VGND VGND VPWR VPWR
+ _3780_/B sky130_fd_sc_hd__mux4_2
X_6023_ _6189_/A _6189_/B _6192_/A _6233_/B VGND VGND VPWR VPWR _6024_/B sky130_fd_sc_hd__and4_2
X_3235_ _6446_/A0 _5225_/S _5316_/A _6449_/A1 _6449_/S0 _3424_/B VGND VGND VPWR VPWR
+ _3235_/X sky130_fd_sc_hd__mux4_2
XFILLER_58_118 VGND VGND VPWR VPWR sky130_fd_sc_hd__decap_3
XFILLER_39_365 VGND VGND VPWR VPWR sky130_fd_sc_hd__decap_3
XFILLER_54_324 VGND VGND VPWR VPWR sky130_fd_sc_hd__fill_1
XFILLER_54_346 VGND VGND VPWR VPWR sky130_fd_sc_hd__decap_3
XTAP_TAPCELL_ROW_37_511 VGND VPWR sky130_fd_sc_hd__tapvpwrvgnd_1
XFILLER_66_195 VGND VGND VPWR VPWR sky130_fd_sc_hd__fill_1
XFILLER_54_368 VGND VGND VPWR VPWR sky130_fd_sc_hd__decap_3
XFILLER_81_143 VGND VGND VPWR VPWR sky130_fd_sc_hd__fill_1
XFILLER_81_187 VGND VGND VPWR VPWR sky130_fd_sc_hd__fill_1
X_5807_ _5627_/A _5790_/X _5806_/X VGND VGND VPWR VPWR _5808_/A sky130_fd_sc_hd__a21bo_2
X_3999_ _4001_/A _4076_/B VGND VGND VPWR VPWR _3999_/X sky130_fd_sc_hd__or2_2
X_5738_ _5281_/X _5441_/X _5584_/X _5737_/X _5947_/S _5239_/X VGND VGND VPWR VPWR
+ _5738_/X sky130_fd_sc_hd__mux4_2
X_5669_ _5396_/X _5640_/Y _5653_/X _5669_/B2 _5668_/Y VGND VGND VPWR VPWR _5982_/C
+ sky130_fd_sc_hd__a221o_2
XTAP_TAPCELL_ROW_9_258 VGND VPWR sky130_fd_sc_hd__tapvpwrvgnd_1
XFILLER_49_107 VGND VGND VPWR VPWR sky130_fd_sc_hd__decap_3
XFILLER_45_302 VGND VGND VPWR VPWR sky130_fd_sc_hd__decap_3
XFILLER_57_162 VGND VGND VPWR VPWR sky130_fd_sc_hd__decap_3
XFILLER_45_335 VGND VGND VPWR VPWR sky130_fd_sc_hd__fill_1
XFILLER_45_357 VGND VGND VPWR VPWR sky130_fd_sc_hd__decap_3
XTAP_TAPCELL_ROW_0_180 VGND VPWR sky130_fd_sc_hd__tapvpwrvgnd_1
XFILLER_60_327 VGND VGND VPWR VPWR sky130_fd_sc_hd__decap_3
XFILLER_60_305 VGND VGND VPWR VPWR sky130_fd_sc_hd__decap_3
XFILLER_13_210 VGND VGND VPWR VPWR sky130_fd_sc_hd__fill_1
XTAP_TAPCELL_ROW_43_569 VGND VPWR sky130_fd_sc_hd__tapvpwrvgnd_1
XFILLER_9_258 VGND VGND VPWR VPWR sky130_fd_sc_hd__fill_1
XFILLER_9_269 VGND VGND VPWR VPWR sky130_fd_sc_hd__decap_3
XFILLER_48_162 VGND VGND VPWR VPWR sky130_fd_sc_hd__decap_3
XFILLER_36_335 VGND VGND VPWR VPWR sky130_fd_sc_hd__decap_3
XFILLER_36_357 VGND VGND VPWR VPWR sky130_fd_sc_hd__decap_3
XFILLER_36_379 VGND VGND VPWR VPWR sky130_fd_sc_hd__decap_3
XFILLER_51_316 VGND VGND VPWR VPWR sky130_fd_sc_hd__decap_3
X_4971_ _4803_/X _4970_/X _4971_/S VGND VGND VPWR VPWR _4971_/X sky130_fd_sc_hd__mux2_2
XFILLER_63_187 VGND VGND VPWR VPWR sky130_fd_sc_hd__decap_3
XFILLER_63_165 VGND VGND VPWR VPWR sky130_fd_sc_hd__decap_3
X_3922_ _4086_/A _4086_/C VGND VGND VPWR VPWR _3922_/Y sky130_fd_sc_hd__nand2_2
X_3853_ _3620_/X _3828_/X _3852_/X VGND VGND VPWR VPWR _3853_/X sky130_fd_sc_hd__o21a_2
X_3784_ _3784_/A _3784_/B VGND VGND VPWR VPWR _3784_/X sky130_fd_sc_hd__and2_2
X_5523_ _5553_/S _6333_/A VGND VGND VPWR VPWR _5675_/B sky130_fd_sc_hd__and2_2
X_5454_ _6322_/A _5476_/S VGND VGND VPWR VPWR _5459_/A sky130_fd_sc_hd__and2b_2
X_5385_ _6363_/A _6319_/A VGND VGND VPWR VPWR _6365_/A sky130_fd_sc_hd__or2_2
X_4405_ _4385_/X _4386_/X _4403_/X _4404_/X VGND VGND VPWR VPWR _4450_/B sky130_fd_sc_hd__a31o_2
X_4336_ _4681_/A1 _4681_/A0 _6200_/B VGND VGND VPWR VPWR _4336_/X sky130_fd_sc_hd__mux2_2
X_4267_ _4267_/A _4267_/B VGND VGND VPWR VPWR _4268_/B sky130_fd_sc_hd__or2_2
XFILLER_39_140 VGND VGND VPWR VPWR sky130_fd_sc_hd__decap_3
X_6006_ _6383_/A _6306_/C _6393_/A _6392_/B VGND VGND VPWR VPWR _6291_/C sky130_fd_sc_hd__and4_2
X_4198_ _4469_/A _6171_/A VGND VGND VPWR VPWR _4198_/Y sky130_fd_sc_hd__nor2_2
X_3218_ _3578_/A VGND VGND VPWR VPWR _3784_/A sky130_fd_sc_hd__clkbuf_1
XFILLER_27_346 VGND VGND VPWR VPWR sky130_fd_sc_hd__decap_3
XFILLER_24_12 VGND VGND VPWR VPWR sky130_fd_sc_hd__fill_1
XFILLER_24_45 VGND VGND VPWR VPWR sky130_fd_sc_hd__fill_1
XFILLER_50_360 VGND VGND VPWR VPWR sky130_fd_sc_hd__decap_3
XFILLER_50_371 VGND VGND VPWR VPWR sky130_fd_sc_hd__decap_3
XTAP_TAPCELL_ROW_40_539 VGND VPWR sky130_fd_sc_hd__tapvpwrvgnd_1
XFILLER_49_42 VGND VGND VPWR VPWR sky130_fd_sc_hd__fill_1
XFILLER_49_64 VGND VGND VPWR VPWR sky130_fd_sc_hd__decap_3
XFILLER_18_346 VGND VGND VPWR VPWR sky130_fd_sc_hd__fill_2
XFILLER_18_368 VGND VGND VPWR VPWR sky130_fd_sc_hd__decap_3
XFILLER_45_154 VGND VGND VPWR VPWR sky130_fd_sc_hd__decap_3
XFILLER_45_187 VGND VGND VPWR VPWR sky130_fd_sc_hd__decap_3
XTAP_TAPCELL_ROW_56_683 VGND VPWR sky130_fd_sc_hd__tapvpwrvgnd_1
XFILLER_60_102 VGND VGND VPWR VPWR sky130_fd_sc_hd__fill_1
XFILLER_33_349 VGND VGND VPWR VPWR sky130_fd_sc_hd__fill_2
XFILLER_41_360 VGND VGND VPWR VPWR sky130_fd_sc_hd__decap_3
XFILLER_81_95 VGND VGND VPWR VPWR sky130_fd_sc_hd__fill_1
XTAP_TAPCELL_ROW_11_274 VGND VPWR sky130_fd_sc_hd__tapvpwrvgnd_1
X_5170_ _5117_/A _5117_/B _5117_/C _5191_/B VGND VGND VPWR VPWR _5170_/X sky130_fd_sc_hd__a31o_2
X_4121_ _6167_/A _6167_/B _4120_/X _4743_/A VGND VGND VPWR VPWR _4122_/C sky130_fd_sc_hd__o211a_2
XFILLER_56_408 VGND VGND VPWR VPWR sky130_fd_sc_hd__decap_3
X_4052_ _6467_/A2 _6467_/A3 _4099_/S VGND VGND VPWR VPWR _4052_/X sky130_fd_sc_hd__mux2_2
XTAP_TAPCELL_ROW_3_209 VGND VPWR sky130_fd_sc_hd__tapvpwrvgnd_1
Xinput4 cmd[2] VGND VGND VPWR VPWR input4/X sky130_fd_sc_hd__clkdlybuf4s25_1
XTAP_TAPCELL_ROW_82_918 VGND VPWR sky130_fd_sc_hd__tapvpwrvgnd_1
XFILLER_36_187 VGND VGND VPWR VPWR sky130_fd_sc_hd__decap_3
XTAP_TAPCELL_ROW_82_929 VGND VPWR sky130_fd_sc_hd__tapvpwrvgnd_1
XTAP_TAPCELL_ROW_19_352 VGND VPWR sky130_fd_sc_hd__tapvpwrvgnd_1
XFILLER_51_113 VGND VGND VPWR VPWR sky130_fd_sc_hd__decap_3
X_4954_ _4954_/A _4954_/B _4954_/C _4954_/D VGND VGND VPWR VPWR _5110_/A sky130_fd_sc_hd__or4_2
XFILLER_32_360 VGND VGND VPWR VPWR sky130_fd_sc_hd__decap_3
X_3905_ _5685_/A _3871_/Y _3872_/X _3904_/X VGND VGND VPWR VPWR _5992_/A sky130_fd_sc_hd__a31o_2
XFILLER_32_371 VGND VGND VPWR VPWR sky130_fd_sc_hd__fill_2
X_4885_ _4885_/A VGND VGND VPWR VPWR _4885_/X sky130_fd_sc_hd__clkbuf_1
X_3836_ _3316_/X _3325_/X _3387_/X _3384_/X _4025_/S0 _4025_/S1 VGND VGND VPWR VPWR
+ _3836_/X sky130_fd_sc_hd__mux4_2
X_3767_ _3753_/Y _3744_/A _3744_/B _3755_/S VGND VGND VPWR VPWR _3767_/X sky130_fd_sc_hd__a31o_2
X_5506_ _5615_/A3 _6439_/A3 _6439_/A0 _6449_/A2 _5801_/S0 _5801_/S1 VGND VGND VPWR
+ VPWR _5506_/X sky130_fd_sc_hd__mux4_2
X_6486_ _6486_/A _6486_/B _6486_/C _6486_/D VGND VGND VPWR VPWR _6486_/X sky130_fd_sc_hd__or4_2
X_3698_ _3280_/X _3651_/X _3698_/S VGND VGND VPWR VPWR _3698_/X sky130_fd_sc_hd__mux2_2
XFILLER_10_69 VGND VGND VPWR VPWR sky130_fd_sc_hd__fill_1
X_5437_ _5438_/A _5625_/A _5538_/A VGND VGND VPWR VPWR _5439_/A sky130_fd_sc_hd__o21ai_2
X_5368_ _5394_/A _5394_/B VGND VGND VPWR VPWR _5369_/A sky130_fd_sc_hd__or2_2
X_5299_ _5299_/A VGND VGND VPWR VPWR _5302_/D sky130_fd_sc_hd__inv_2
X_4319_ _5696_/A _4319_/B VGND VGND VPWR VPWR _4319_/Y sky130_fd_sc_hd__nor2_2
XFILLER_74_205 VGND VGND VPWR VPWR sky130_fd_sc_hd__decap_3
XFILLER_59_279 VGND VGND VPWR VPWR sky130_fd_sc_hd__fill_1
XFILLER_27_132 VGND VGND VPWR VPWR sky130_fd_sc_hd__fill_1
XFILLER_55_430 VGND VGND VPWR VPWR sky130_fd_sc_hd__decap_3
XFILLER_35_88 VGND VGND VPWR VPWR sky130_fd_sc_hd__decap_3
XTAP_TAPCELL_ROW_53_653 VGND VPWR sky130_fd_sc_hd__tapvpwrvgnd_1
XFILLER_23_382 VGND VGND VPWR VPWR sky130_fd_sc_hd__decap_3
XFILLER_70_499 VGND VGND VPWR VPWR sky130_fd_sc_hd__fill_1
XFILLER_2_253 VGND VGND VPWR VPWR sky130_fd_sc_hd__fill_1
XFILLER_65_205 VGND VGND VPWR VPWR sky130_fd_sc_hd__decap_3
Xfanout590 input19/X VGND VGND VPWR VPWR _6461_/A3 sky130_fd_sc_hd__clkdlybuf4s25_1
XFILLER_65_249 VGND VGND VPWR VPWR sky130_fd_sc_hd__decap_3
XFILLER_18_176 VGND VGND VPWR VPWR sky130_fd_sc_hd__decap_3
XTAP_TAPCELL_ROW_16_322 VGND VPWR sky130_fd_sc_hd__tapvpwrvgnd_1
XFILLER_73_293 VGND VGND VPWR VPWR sky130_fd_sc_hd__decap_3
XFILLER_21_319 VGND VGND VPWR VPWR sky130_fd_sc_hd__decap_3
XFILLER_14_360 VGND VGND VPWR VPWR sky130_fd_sc_hd__decap_3
XFILLER_14_393 VGND VGND VPWR VPWR sky130_fd_sc_hd__decap_3
X_4670_ _4679_/A _4679_/B VGND VGND VPWR VPWR _4670_/Y sky130_fd_sc_hd__nor2_2
X_3621_ _3600_/B _3568_/B _6090_/A VGND VGND VPWR VPWR _3621_/X sky130_fd_sc_hd__o21a_2
X_6340_ _6339_/A _6324_/S _5466_/A VGND VGND VPWR VPWR _6340_/X sky130_fd_sc_hd__o21a_2
X_3552_ _3552_/A VGND VGND VPWR VPWR _3856_/A sky130_fd_sc_hd__buf_1
X_6271_ _6265_/B _6269_/X _6270_/X VGND VGND VPWR VPWR _6271_/X sky130_fd_sc_hd__a21bo_2
X_3483_ _4355_/A _6199_/C _4429_/A _6457_/A1 _3695_/S0 _3424_/B VGND VGND VPWR VPWR
+ _3483_/X sky130_fd_sc_hd__mux4_2
X_5222_ _5508_/A1 _5218_/X _5221_/X VGND VGND VPWR VPWR _5222_/Y sky130_fd_sc_hd__a21oi_2
X_5153_ _5188_/S _5191_/B _5573_/A _5572_/D _5172_/B VGND VGND VPWR VPWR _5153_/X
+ sky130_fd_sc_hd__a221o_2
X_4104_ _4840_/B _4104_/B VGND VGND VPWR VPWR _5440_/B sky130_fd_sc_hd__or2_2
XFILLER_56_227 VGND VGND VPWR VPWR sky130_fd_sc_hd__decap_3
X_5084_ _4416_/B _5701_/B _5084_/S VGND VGND VPWR VPWR _5084_/X sky130_fd_sc_hd__mux2_2
XFILLER_49_290 VGND VGND VPWR VPWR sky130_fd_sc_hd__decap_3
X_4035_ _6162_/A _4049_/S VGND VGND VPWR VPWR _4035_/X sky130_fd_sc_hd__and2b_2
XFILLER_52_400 VGND VGND VPWR VPWR sky130_fd_sc_hd__decap_3
XTAP_TAPCELL_ROW_67_778 VGND VPWR sky130_fd_sc_hd__tapvpwrvgnd_1
XFILLER_71_219 VGND VGND VPWR VPWR sky130_fd_sc_hd__decap_3
XFILLER_24_135 VGND VGND VPWR VPWR sky130_fd_sc_hd__decap_3
XFILLER_52_477 VGND VGND VPWR VPWR sky130_fd_sc_hd__decap_3
X_5986_ _5986_/A _5986_/B _5986_/C _5986_/D VGND VGND VPWR VPWR _6001_/A sky130_fd_sc_hd__or4_2
X_4937_ _4937_/A _4937_/B _4937_/C VGND VGND VPWR VPWR _4937_/X sky130_fd_sc_hd__and3_2
XANTENNA_20 _5440_/B VGND VGND VPWR VPWR sky130_fd_sc_hd__diode_2
XANTENNA_31 input2/X VGND VGND VPWR VPWR sky130_fd_sc_hd__diode_2
XFILLER_20_330 VGND VGND VPWR VPWR sky130_fd_sc_hd__fill_1
X_4868_ _4910_/A _4867_/X _4823_/A VGND VGND VPWR VPWR _4868_/Y sky130_fd_sc_hd__o21ai_2
X_3819_ _3817_/C _4086_/B _3817_/X _3818_/X VGND VGND VPWR VPWR _3820_/B sky130_fd_sc_hd__o22a_2
X_4799_ _4796_/X _4798_/X _4926_/A VGND VGND VPWR VPWR _4799_/X sky130_fd_sc_hd__a21o_2
X_6469_ _6467_/X _6468_/X _6469_/S VGND VGND VPWR VPWR _6469_/X sky130_fd_sc_hd__mux2_2
Xoutput160 _5986_/B VGND VGND VPWR VPWR result[30] sky130_fd_sc_hd__clkdlybuf4s25_1
Xoutput171 _5998_/A VGND VGND VPWR VPWR result[40] sky130_fd_sc_hd__clkdlybuf4s25_1
Xoutput182 _5981_/D VGND VGND VPWR VPWR result[50] sky130_fd_sc_hd__clkdlybuf4s25_1
Xoutput193 _6004_/C VGND VGND VPWR VPWR result[60] sky130_fd_sc_hd__clkdlybuf4s25_1
XFILLER_47_205 VGND VGND VPWR VPWR sky130_fd_sc_hd__decap_3
XTAP_TAPCELL_ROW_58_701 VGND VPWR sky130_fd_sc_hd__tapvpwrvgnd_1
XFILLER_46_32 VGND VGND VPWR VPWR sky130_fd_sc_hd__fill_1
XFILLER_47_249 VGND VGND VPWR VPWR sky130_fd_sc_hd__decap_3
XFILLER_15_124 VGND VGND VPWR VPWR sky130_fd_sc_hd__decap_3
XFILLER_70_230 VGND VGND VPWR VPWR sky130_fd_sc_hd__decap_3
XFILLER_70_296 VGND VGND VPWR VPWR sky130_fd_sc_hd__decap_3
XFILLER_7_323 VGND VGND VPWR VPWR sky130_fd_sc_hd__decap_3
Xwire287 _4271_/Y VGND VGND VPWR VPWR _4283_/B sky130_fd_sc_hd__clkbuf_2
XFILLER_78_341 VGND VGND VPWR VPWR sky130_fd_sc_hd__fill_1
XFILLER_38_238 VGND VGND VPWR VPWR sky130_fd_sc_hd__decap_3
XFILLER_53_208 VGND VGND VPWR VPWR sky130_fd_sc_hd__fill_2
XTAP_TAPCELL_ROW_64_759 VGND VPWR sky130_fd_sc_hd__tapvpwrvgnd_1
X_5840_ _6040_/A VGND VGND VPWR VPWR _5874_/B sky130_fd_sc_hd__inv_2
XFILLER_61_252 VGND VGND VPWR VPWR sky130_fd_sc_hd__decap_3
X_5771_ _5938_/A1 wire263/X _6050_/A VGND VGND VPWR VPWR _5771_/X sky130_fd_sc_hd__mux2_2
X_4722_ _4378_/X _4721_/X _6108_/A VGND VGND VPWR VPWR _4723_/B sky130_fd_sc_hd__mux2_2
Xinput40 operand_a[40] VGND VGND VPWR VPWR input40/X sky130_fd_sc_hd__clkdlybuf4s25_1
X_4653_ _5628_/A _4623_/Y _4652_/X VGND VGND VPWR VPWR _4653_/Y sky130_fd_sc_hd__o21ai_2
Xinput73 operand_b[12] VGND VGND VPWR VPWR input73/X sky130_fd_sc_hd__clkdlybuf4s25_1
Xinput62 operand_a[60] VGND VGND VPWR VPWR input62/X sky130_fd_sc_hd__clkdlybuf4s25_1
Xinput51 operand_a[50] VGND VGND VPWR VPWR input51/X sky130_fd_sc_hd__clkdlybuf4s25_1
X_4584_ _4536_/B _4616_/B _4577_/X _4581_/Y _4583_/X VGND VGND VPWR VPWR _4584_/X
+ sky130_fd_sc_hd__a311o_2
X_3604_ _3563_/X _3568_/X _3579_/X _3603_/X VGND VGND VPWR VPWR _3604_/X sky130_fd_sc_hd__a211o_2
X_6323_ _5460_/A _5476_/S _6339_/A _6322_/A VGND VGND VPWR VPWR _6323_/X sky130_fd_sc_hd__o211a_2
Xinput95 operand_b[32] VGND VGND VPWR VPWR _4854_/A sky130_fd_sc_hd__clkdlybuf4s25_1
Xinput84 operand_b[22] VGND VGND VPWR VPWR _6176_/B sky130_fd_sc_hd__clkdlybuf4s25_1
X_3535_ _3535_/A _3535_/B VGND VGND VPWR VPWR _3535_/Y sky130_fd_sc_hd__nand2_2
X_6254_ _6254_/A VGND VGND VPWR VPWR _6254_/Y sky130_fd_sc_hd__inv_2
X_3466_ _3667_/A _3667_/C _3666_/A _3666_/B VGND VGND VPWR VPWR _3467_/B sky130_fd_sc_hd__o22a_2
X_5205_ _5167_/X _5170_/X _5188_/S VGND VGND VPWR VPWR _5205_/X sky130_fd_sc_hd__a21o_2
X_6185_ _6185_/A _6221_/C VGND VGND VPWR VPWR _6185_/Y sky130_fd_sc_hd__xnor2_2
X_3397_ _3631_/S1 _3451_/S _5590_/A1 _3396_/X VGND VGND VPWR VPWR _3398_/B sky130_fd_sc_hd__a31o_2
X_5136_ _5136_/A _5136_/B VGND VGND VPWR VPWR _5136_/Y sky130_fd_sc_hd__nand2_2
X_5067_ _5128_/A _6275_/B VGND VGND VPWR VPWR _5123_/C sky130_fd_sc_hd__xnor2_2
X_4018_ _4018_/A _6158_/A VGND VGND VPWR VPWR _4018_/X sky130_fd_sc_hd__or2_2
XFILLER_37_271 VGND VGND VPWR VPWR sky130_fd_sc_hd__decap_3
XFILLER_52_241 VGND VGND VPWR VPWR sky130_fd_sc_hd__decap_3
XFILLER_12_105 VGND VGND VPWR VPWR sky130_fd_sc_hd__decap_3
XFILLER_40_436 VGND VGND VPWR VPWR sky130_fd_sc_hd__fill_2
X_5969_ wire281/X wire282/X _6476_/A VGND VGND VPWR VPWR _5969_/X sky130_fd_sc_hd__mux2_2
XTAP_TAPCELL_ROW_35_494 VGND VPWR sky130_fd_sc_hd__tapvpwrvgnd_1
XFILLER_8_109 VGND VGND VPWR VPWR sky130_fd_sc_hd__fill_1
XFILLER_20_182 VGND VGND VPWR VPWR sky130_fd_sc_hd__decap_3
XFILLER_48_514 VGND VGND VPWR VPWR sky130_fd_sc_hd__fill_2
XFILLER_75_344 VGND VGND VPWR VPWR sky130_fd_sc_hd__decap_3
XFILLER_35_219 VGND VGND VPWR VPWR sky130_fd_sc_hd__decap_3
XFILLER_43_241 VGND VGND VPWR VPWR sky130_fd_sc_hd__decap_3
XFILLER_43_285 VGND VGND VPWR VPWR sky130_fd_sc_hd__decap_3
XTAP_TAPCELL_ROW_61_729 VGND VPWR sky130_fd_sc_hd__tapvpwrvgnd_1
X_3320_ _3225_/X _3319_/X _6429_/A VGND VGND VPWR VPWR _4150_/B sky130_fd_sc_hd__mux2_2
X_3251_ _3361_/C _3515_/B VGND VGND VPWR VPWR _4200_/A sky130_fd_sc_hd__nand2b_2
XFILLER_21_3 VGND VGND VPWR VPWR sky130_fd_sc_hd__decap_3
XFILLER_66_333 VGND VGND VPWR VPWR sky130_fd_sc_hd__decap_3
XTAP_TAPCELL_ROW_77_873 VGND VPWR sky130_fd_sc_hd__tapvpwrvgnd_1
XFILLER_66_377 VGND VGND VPWR VPWR sky130_fd_sc_hd__fill_2
XFILLER_66_355 VGND VGND VPWR VPWR sky130_fd_sc_hd__decap_3
X_5823_ _6400_/B _5822_/B _5822_/Y VGND VGND VPWR VPWR _6493_/A sky130_fd_sc_hd__a21oi_2
XFILLER_34_296 VGND VGND VPWR VPWR sky130_fd_sc_hd__fill_2
X_5754_ _5753_/A _5770_/S _5751_/X _5753_/Y VGND VGND VPWR VPWR _5754_/X sky130_fd_sc_hd__a31o_2
XTAP_TAPCELL_ROW_32_464 VGND VPWR sky130_fd_sc_hd__tapvpwrvgnd_1
X_5685_ _5685_/A _5685_/B _5685_/C VGND VGND VPWR VPWR _5707_/A sky130_fd_sc_hd__and3_4
X_4705_ _4778_/A _4705_/B VGND VGND VPWR VPWR _4967_/C sky130_fd_sc_hd__xnor2_2
X_4636_ _3948_/X _3944_/B _4636_/S VGND VGND VPWR VPWR _4637_/B sky130_fd_sc_hd__mux2_2
X_6306_ _6306_/A _6383_/A _6306_/C _6337_/B VGND VGND VPWR VPWR _6309_/C sky130_fd_sc_hd__and4_2
X_4567_ _5216_/B _4598_/B _4566_/Y _4567_/B2 VGND VGND VPWR VPWR _4567_/X sky130_fd_sc_hd__o22a_2
X_4498_ _4513_/A _4498_/B _4538_/B _4539_/B VGND VGND VPWR VPWR _4498_/X sky130_fd_sc_hd__and4_2
X_3518_ _3432_/A _3578_/A _3517_/X VGND VGND VPWR VPWR _3518_/Y sky130_fd_sc_hd__a21oi_2
X_6237_ _6235_/X _6236_/X _6232_/B VGND VGND VPWR VPWR _6237_/X sky130_fd_sc_hd__a21o_2
X_3449_ _3469_/S VGND VGND VPWR VPWR _3842_/S sky130_fd_sc_hd__clkbuf_2
X_6168_ _6168_/A _6168_/B VGND VGND VPWR VPWR _6168_/Y sky130_fd_sc_hd__nand2_2
X_5119_ _5131_/A _5172_/B VGND VGND VPWR VPWR _5122_/B sky130_fd_sc_hd__xnor2_2
XFILLER_57_333 VGND VGND VPWR VPWR sky130_fd_sc_hd__decap_3
X_6099_ _6098_/B _6096_/Y _6097_/Y _6098_/Y _3667_/A VGND VGND VPWR VPWR _6099_/X
+ sky130_fd_sc_hd__o32a_2
XFILLER_57_366 VGND VGND VPWR VPWR sky130_fd_sc_hd__decap_3
XFILLER_57_355 VGND VGND VPWR VPWR sky130_fd_sc_hd__decap_3
XFILLER_40_200 VGND VGND VPWR VPWR sky130_fd_sc_hd__decap_3
XFILLER_43_99 VGND VGND VPWR VPWR sky130_fd_sc_hd__fill_2
XFILLER_40_299 VGND VGND VPWR VPWR sky130_fd_sc_hd__decap_3
XFILLER_0_351 VGND VGND VPWR VPWR sky130_fd_sc_hd__fill_1
XFILLER_48_333 VGND VGND VPWR VPWR sky130_fd_sc_hd__decap_3
XFILLER_63_303 VGND VGND VPWR VPWR sky130_fd_sc_hd__decap_3
XTAP_TAPCELL_ROW_74_843 VGND VPWR sky130_fd_sc_hd__tapvpwrvgnd_1
XTAP_TAPCELL_ROW_46_589 VGND VPWR sky130_fd_sc_hd__tapvpwrvgnd_1
XFILLER_31_211 VGND VGND VPWR VPWR sky130_fd_sc_hd__decap_3
XFILLER_31_266 VGND VGND VPWR VPWR sky130_fd_sc_hd__decap_3
X_5470_ _5470_/A _5499_/D VGND VGND VPWR VPWR _5470_/Y sky130_fd_sc_hd__xnor2_2
X_4421_ _5704_/A _6442_/A VGND VGND VPWR VPWR _5732_/B sky130_fd_sc_hd__or2_2
X_4352_ _4352_/A _4355_/C VGND VGND VPWR VPWR _4352_/Y sky130_fd_sc_hd__nor2_2
Xfanout408 input80/X VGND VGND VPWR VPWR _4238_/B sky130_fd_sc_hd__clkdlybuf4s25_1
Xfanout419 _6131_/A VGND VGND VPWR VPWR _6062_/C sky130_fd_sc_hd__clkdlybuf4s25_1
X_4283_ _4430_/A _4283_/B VGND VGND VPWR VPWR _4283_/Y sky130_fd_sc_hd__nor2_2
X_3303_ _4842_/A _6472_/S VGND VGND VPWR VPWR _3303_/Y sky130_fd_sc_hd__nor2_2
X_6022_ _6170_/A _6059_/A _6022_/C _6059_/C VGND VGND VPWR VPWR _6183_/C sky130_fd_sc_hd__and4_2
X_3234_ _6447_/A3 _4942_/A _6450_/A3 _5128_/A _6447_/S0 _3575_/S1 VGND VGND VPWR VPWR
+ _3234_/X sky130_fd_sc_hd__mux4_2
XTAP_TAPCELL_ROW_37_512 VGND VPWR sky130_fd_sc_hd__tapvpwrvgnd_1
XFILLER_54_358 VGND VGND VPWR VPWR sky130_fd_sc_hd__decap_3
XFILLER_22_200 VGND VGND VPWR VPWR sky130_fd_sc_hd__decap_3
XFILLER_22_277 VGND VGND VPWR VPWR sky130_fd_sc_hd__decap_3
X_5806_ _5215_/X _5795_/Y _6495_/D _6497_/A _5805_/Y VGND VGND VPWR VPWR _5806_/X
+ sky130_fd_sc_hd__o221a_2
X_3998_ _6154_/B _3998_/B VGND VGND VPWR VPWR _3998_/X sky130_fd_sc_hd__xor2_2
X_5737_ _5752_/A _6349_/A _6440_/A1 _6440_/A3 _5963_/S0 _5963_/S1 VGND VGND VPWR VPWR
+ _5737_/X sky130_fd_sc_hd__mux4_2
X_5668_ _6497_/A _6494_/B _5667_/X VGND VGND VPWR VPWR _5668_/Y sky130_fd_sc_hd__o21bai_2
X_5599_ _5637_/A _5599_/B VGND VGND VPWR VPWR _5647_/B sky130_fd_sc_hd__and2_2
X_4619_ _4700_/A VGND VGND VPWR VPWR _4768_/A sky130_fd_sc_hd__inv_2
XTAP_TAPCELL_ROW_9_259 VGND VPWR sky130_fd_sc_hd__tapvpwrvgnd_1
XFILLER_38_11 VGND VGND VPWR VPWR sky130_fd_sc_hd__fill_1
XFILLER_49_119 VGND VGND VPWR VPWR sky130_fd_sc_hd__decap_3
XFILLER_38_88 VGND VGND VPWR VPWR sky130_fd_sc_hd__decap_3
XFILLER_45_314 VGND VGND VPWR VPWR sky130_fd_sc_hd__decap_3
XFILLER_72_122 VGND VGND VPWR VPWR sky130_fd_sc_hd__fill_1
XFILLER_45_369 VGND VGND VPWR VPWR sky130_fd_sc_hd__decap_3
XTAP_TAPCELL_ROW_0_181 VGND VPWR sky130_fd_sc_hd__tapvpwrvgnd_1
XTAP_TAPCELL_ROW_0_170 VGND VPWR sky130_fd_sc_hd__tapvpwrvgnd_1
XFILLER_53_380 VGND VGND VPWR VPWR sky130_fd_sc_hd__decap_3
XFILLER_13_266 VGND VGND VPWR VPWR sky130_fd_sc_hd__decap_3
XFILLER_13_277 VGND VGND VPWR VPWR sky130_fd_sc_hd__decap_3
XFILLER_48_130 VGND VGND VPWR VPWR sky130_fd_sc_hd__decap_3
XFILLER_48_141 VGND VGND VPWR VPWR sky130_fd_sc_hd__decap_3
XFILLER_51_328 VGND VGND VPWR VPWR sky130_fd_sc_hd__decap_3
X_4970_ _6450_/A0 _4942_/A _6447_/A1 _4849_/A _5008_/S0 wire372/X VGND VGND VPWR VPWR
+ _4970_/X sky130_fd_sc_hd__mux4_2
X_3921_ _3921_/A _3921_/B VGND VGND VPWR VPWR _4086_/C sky130_fd_sc_hd__and2_2
XFILLER_63_199 VGND VGND VPWR VPWR sky130_fd_sc_hd__decap_3
X_3852_ _3947_/A _3830_/Y _3835_/X _3839_/Y _3851_/X VGND VGND VPWR VPWR _3852_/X
+ sky130_fd_sc_hd__o311a_2
X_5522_ _5553_/S _6333_/A VGND VGND VPWR VPWR _5556_/B sky130_fd_sc_hd__nor2_2
X_3783_ _3225_/X _3233_/X _3319_/X _3324_/X _3495_/A _6429_/A VGND VGND VPWR VPWR
+ _3784_/B sky130_fd_sc_hd__mux4_2
X_5453_ _4813_/A _5412_/X _5439_/Y _4526_/A _5452_/X VGND VGND VPWR VPWR _5981_/C
+ sky130_fd_sc_hd__a221o_2
X_5384_ _6358_/A _6359_/A VGND VGND VPWR VPWR _5384_/X sky130_fd_sc_hd__or2_2
X_4404_ _6176_/A _6059_/A VGND VGND VPWR VPWR _4404_/X sky130_fd_sc_hd__and2_2
X_4335_ _4382_/S _3592_/X _4235_/A _4207_/A VGND VGND VPWR VPWR _4335_/X sky130_fd_sc_hd__o211a_2
XTAP_TAPCELL_ROW_6_229 VGND VPWR sky130_fd_sc_hd__tapvpwrvgnd_1
X_4266_ _4266_/A _4266_/B VGND VGND VPWR VPWR _4266_/Y sky130_fd_sc_hd__xnor2_2
XFILLER_59_439 VGND VGND VPWR VPWR sky130_fd_sc_hd__decap_3
X_6005_ _6005_/A _6005_/B _6501_/A _6005_/D VGND VGND VPWR VPWR _6005_/Y sky130_fd_sc_hd__nor4_4
X_4197_ _6171_/A _4230_/A VGND VGND VPWR VPWR _4258_/A sky130_fd_sc_hd__or2b_2
X_3217_ _6113_/A VGND VGND VPWR VPWR _3578_/A sky130_fd_sc_hd__inv_2
XFILLER_27_314 VGND VGND VPWR VPWR sky130_fd_sc_hd__decap_3
XFILLER_39_163 VGND VGND VPWR VPWR sky130_fd_sc_hd__decap_3
XFILLER_54_122 VGND VGND VPWR VPWR sky130_fd_sc_hd__decap_3
XFILLER_54_144 VGND VGND VPWR VPWR sky130_fd_sc_hd__decap_3
XFILLER_42_306 VGND VGND VPWR VPWR sky130_fd_sc_hd__fill_2
XFILLER_42_339 VGND VGND VPWR VPWR sky130_fd_sc_hd__decap_3
XFILLER_50_383 VGND VGND VPWR VPWR sky130_fd_sc_hd__decap_3
XFILLER_10_258 VGND VGND VPWR VPWR sky130_fd_sc_hd__decap_3
XFILLER_77_214 VGND VGND VPWR VPWR sky130_fd_sc_hd__decap_3
XFILLER_77_247 VGND VGND VPWR VPWR sky130_fd_sc_hd__decap_3
XFILLER_77_225 VGND VGND VPWR VPWR sky130_fd_sc_hd__decap_3
XTAP_TAPCELL_ROW_48_607 VGND VPWR sky130_fd_sc_hd__tapvpwrvgnd_1
XFILLER_45_111 VGND VGND VPWR VPWR sky130_fd_sc_hd__fill_1
XFILLER_18_336 VGND VGND VPWR VPWR sky130_fd_sc_hd__fill_1
XFILLER_45_122 VGND VGND VPWR VPWR sky130_fd_sc_hd__decap_3
XTAP_TAPCELL_ROW_56_684 VGND VPWR sky130_fd_sc_hd__tapvpwrvgnd_1
XFILLER_60_125 VGND VGND VPWR VPWR sky130_fd_sc_hd__decap_3
XFILLER_41_372 VGND VGND VPWR VPWR sky130_fd_sc_hd__fill_1
XTAP_TAPCELL_ROW_11_275 VGND VPWR sky130_fd_sc_hd__tapvpwrvgnd_1
XFILLER_53_6 VGND VGND VPWR VPWR sky130_fd_sc_hd__fill_1
X_4120_ _4120_/A _4120_/B _4120_/C _4120_/D VGND VGND VPWR VPWR _4120_/X sky130_fd_sc_hd__or4_2
XFILLER_68_214 VGND VGND VPWR VPWR sky130_fd_sc_hd__fill_1
XFILLER_1_490 VGND VGND VPWR VPWR sky130_fd_sc_hd__fill_1
X_4051_ _6162_/A _4111_/A _3981_/X _4035_/X _4050_/X VGND VGND VPWR VPWR _4051_/X
+ sky130_fd_sc_hd__a221o_2
Xinput5 cmd[3] VGND VGND VPWR VPWR input5/X sky130_fd_sc_hd__clkdlybuf4s25_1
XFILLER_36_122 VGND VGND VPWR VPWR sky130_fd_sc_hd__decap_3
XFILLER_36_144 VGND VGND VPWR VPWR sky130_fd_sc_hd__fill_2
XTAP_TAPCELL_ROW_82_919 VGND VPWR sky130_fd_sc_hd__tapvpwrvgnd_1
XFILLER_76_291 VGND VGND VPWR VPWR sky130_fd_sc_hd__decap_3
XFILLER_24_306 VGND VGND VPWR VPWR sky130_fd_sc_hd__fill_2
XTAP_TAPCELL_ROW_19_353 VGND VPWR sky130_fd_sc_hd__tapvpwrvgnd_1
X_4953_ _4953_/A _4791_/B VGND VGND VPWR VPWR _4953_/X sky130_fd_sc_hd__or2b_2
X_3904_ _3993_/A _3876_/X _3894_/X _3903_/X VGND VGND VPWR VPWR _3904_/X sky130_fd_sc_hd__a211o_2
X_4884_ _4884_/A _4884_/B VGND VGND VPWR VPWR _4885_/A sky130_fd_sc_hd__nor2_2
X_3835_ _3704_/A _4558_/A _5216_/B _5216_/A VGND VGND VPWR VPWR _3835_/X sky130_fd_sc_hd__o211a_2
X_3766_ _3812_/A _6126_/B VGND VGND VPWR VPWR _3860_/A sky130_fd_sc_hd__xor2_2
X_6485_ _6485_/A _6485_/B VGND VGND VPWR VPWR _6486_/D sky130_fd_sc_hd__nor2_2
X_5505_ _5505_/A _5543_/S VGND VGND VPWR VPWR _5505_/Y sky130_fd_sc_hd__xnor2_2
X_5436_ _5501_/A _5436_/B VGND VGND VPWR VPWR _5538_/A sky130_fd_sc_hd__xnor2_2
X_3697_ _3278_/X _3654_/X _3842_/S VGND VGND VPWR VPWR _3697_/X sky130_fd_sc_hd__mux2_2
X_5367_ _5388_/S _6319_/B VGND VGND VPWR VPWR _5394_/B sky130_fd_sc_hd__and2b_2
X_5298_ _5624_/A _5624_/B _5624_/C VGND VGND VPWR VPWR _5298_/Y sky130_fd_sc_hd__nor3_2
X_4318_ _4355_/C _4318_/B VGND VGND VPWR VPWR _4319_/B sky130_fd_sc_hd__xnor2_2
XFILLER_59_225 VGND VGND VPWR VPWR sky130_fd_sc_hd__fill_1
XFILLER_59_214 VGND VGND VPWR VPWR sky130_fd_sc_hd__decap_3
X_4249_ _4249_/A _4259_/B VGND VGND VPWR VPWR _4431_/A sky130_fd_sc_hd__or2_2
XFILLER_59_269 VGND VGND VPWR VPWR sky130_fd_sc_hd__decap_3
XFILLER_27_100 VGND VGND VPWR VPWR sky130_fd_sc_hd__decap_3
XFILLER_74_228 VGND VGND VPWR VPWR sky130_fd_sc_hd__decap_3
XFILLER_74_217 VGND VGND VPWR VPWR sky130_fd_sc_hd__fill_2
XFILLER_55_442 VGND VGND VPWR VPWR sky130_fd_sc_hd__fill_1
XFILLER_70_412 VGND VGND VPWR VPWR sky130_fd_sc_hd__fill_2
XFILLER_42_114 VGND VGND VPWR VPWR sky130_fd_sc_hd__decap_3
XFILLER_42_136 VGND VGND VPWR VPWR sky130_fd_sc_hd__decap_3
XFILLER_30_309 VGND VGND VPWR VPWR sky130_fd_sc_hd__decap_3
XFILLER_42_147 VGND VGND VPWR VPWR sky130_fd_sc_hd__decap_3
XTAP_TAPCELL_ROW_53_654 VGND VPWR sky130_fd_sc_hd__tapvpwrvgnd_1
Xfanout580 fanout580/A VGND VGND VPWR VPWR _4365_/A sky130_fd_sc_hd__clkdlybuf4s25_1
Xfanout591 _4355_/A VGND VGND VPWR VPWR _6199_/A sky130_fd_sc_hd__clkdlybuf4s25_1
XFILLER_65_228 VGND VGND VPWR VPWR sky130_fd_sc_hd__decap_3
XFILLER_18_133 VGND VGND VPWR VPWR sky130_fd_sc_hd__fill_2
XFILLER_58_280 VGND VGND VPWR VPWR sky130_fd_sc_hd__fill_2
XFILLER_73_261 VGND VGND VPWR VPWR sky130_fd_sc_hd__fill_1
XFILLER_33_125 VGND VGND VPWR VPWR sky130_fd_sc_hd__decap_3
XTAP_TAPCELL_ROW_16_323 VGND VPWR sky130_fd_sc_hd__tapvpwrvgnd_1
XFILLER_33_158 VGND VGND VPWR VPWR sky130_fd_sc_hd__decap_3
XFILLER_33_169 VGND VGND VPWR VPWR sky130_fd_sc_hd__decap_3
X_3620_ _3620_/A VGND VGND VPWR VPWR _3620_/X sky130_fd_sc_hd__clkbuf_1
X_3551_ _3551_/A _3551_/B _3551_/C VGND VGND VPWR VPWR _3552_/A sky130_fd_sc_hd__or3_2
XFILLER_51_3 VGND VGND VPWR VPWR sky130_fd_sc_hd__fill_2
X_6270_ _6270_/A _6270_/B _6270_/C VGND VGND VPWR VPWR _6270_/X sky130_fd_sc_hd__or3_2
X_3482_ _6460_/A0 _6460_/A1 _6447_/A0 _6447_/A1 _3575_/S0 _3575_/S1 VGND VGND VPWR
+ VPWR _3482_/X sky130_fd_sc_hd__mux4_2
X_5221_ _5618_/A _5220_/X _5217_/X _3830_/B VGND VGND VPWR VPWR _5221_/X sky130_fd_sc_hd__a22o_2
X_5152_ _5168_/A _5122_/B _5122_/Y _4526_/A _5151_/Y VGND VGND VPWR VPWR _5998_/A
+ sky130_fd_sc_hd__a221o_2
X_4103_ _3760_/A _4102_/A _6443_/A _4102_/Y VGND VGND VPWR VPWR _4104_/B sky130_fd_sc_hd__o31a_2
XFILLER_56_206 VGND VGND VPWR VPWR sky130_fd_sc_hd__decap_3
X_5083_ _4592_/X _4758_/X _4933_/X _5082_/X _5442_/S _6108_/A VGND VGND VPWR VPWR
+ _5701_/B sky130_fd_sc_hd__mux4_2
XFILLER_2_93 VGND VGND VPWR VPWR sky130_fd_sc_hd__fill_1
XFILLER_56_239 VGND VGND VPWR VPWR sky130_fd_sc_hd__decap_3
X_4034_ _4042_/A _6158_/A _4032_/X _4033_/X VGND VGND VPWR VPWR _4038_/A sky130_fd_sc_hd__a211o_2
XTAP_TAPCELL_ROW_67_779 VGND VPWR sky130_fd_sc_hd__tapvpwrvgnd_1
XFILLER_12_309 VGND VGND VPWR VPWR sky130_fd_sc_hd__fill_1
XFILLER_24_147 VGND VGND VPWR VPWR sky130_fd_sc_hd__fill_2
X_5985_ _5985_/A _5985_/B VGND VGND VPWR VPWR _5986_/D sky130_fd_sc_hd__or2_2
X_4936_ _6473_/S _3440_/X _4935_/X _4973_/A _5014_/A VGND VGND VPWR VPWR _4937_/C
+ sky130_fd_sc_hd__a221o_2
XANTENNA_10 _3933_/X VGND VGND VPWR VPWR sky130_fd_sc_hd__diode_2
XANTENNA_21 _4424_/X VGND VGND VPWR VPWR sky130_fd_sc_hd__diode_2
XANTENNA_32 _4849_/C VGND VGND VPWR VPWR sky130_fd_sc_hd__diode_2
XFILLER_32_180 VGND VGND VPWR VPWR sky130_fd_sc_hd__decap_3
X_4867_ _4821_/A _4923_/B VGND VGND VPWR VPWR _4867_/X sky130_fd_sc_hd__and2b_2
X_3818_ _3818_/A _3818_/B _3818_/C VGND VGND VPWR VPWR _3818_/X sky130_fd_sc_hd__or3_2
XFILLER_20_386 VGND VGND VPWR VPWR sky130_fd_sc_hd__decap_3
X_4798_ _4854_/A _5058_/B _4797_/X _4863_/A VGND VGND VPWR VPWR _4798_/X sky130_fd_sc_hd__o2bb2a_2
X_3749_ _3749_/A VGND VGND VPWR VPWR _5228_/A sky130_fd_sc_hd__clkbuf_2
X_6468_ _3548_/B _3681_/A input67/X _3600_/B _3520_/S _6468_/S1 VGND VGND VPWR VPWR
+ _6468_/X sky130_fd_sc_hd__mux4_2
X_6399_ _5752_/A _6051_/Y _6398_/X _6050_/X VGND VGND VPWR VPWR _6399_/X sky130_fd_sc_hd__a211o_2
Xoutput150 _5999_/A VGND VGND VPWR VPWR result[21] sky130_fd_sc_hd__clkdlybuf4s25_1
Xoutput161 _5986_/C VGND VGND VPWR VPWR result[31] sky130_fd_sc_hd__clkdlybuf4s25_1
X_5419_ _5414_/Y _5417_/X _5418_/X _5262_/B _5262_/A VGND VGND VPWR VPWR _5573_/C
+ sky130_fd_sc_hd__o311a_2
Xoutput172 _5984_/A VGND VGND VPWR VPWR result[41] sky130_fd_sc_hd__clkdlybuf4s25_1
Xoutput183 _5982_/B VGND VGND VPWR VPWR result[51] sky130_fd_sc_hd__clkdlybuf4s25_1
Xoutput194 _6005_/A VGND VGND VPWR VPWR result[61] sky130_fd_sc_hd__clkdlybuf4s25_1
XFILLER_47_217 VGND VGND VPWR VPWR sky130_fd_sc_hd__decap_3
XFILLER_47_228 VGND VGND VPWR VPWR sky130_fd_sc_hd__decap_3
XTAP_TAPCELL_ROW_58_702 VGND VPWR sky130_fd_sc_hd__tapvpwrvgnd_1
XFILLER_28_442 VGND VGND VPWR VPWR sky130_fd_sc_hd__fill_1
XPHY_EDGE_ROW_6_Left_89 VGND VGND VPWR VPWR sky130_fd_sc_hd__decap_3
XFILLER_46_88 VGND VGND VPWR VPWR sky130_fd_sc_hd__fill_1
XFILLER_15_169 VGND VGND VPWR VPWR sky130_fd_sc_hd__decap_3
XFILLER_70_253 VGND VGND VPWR VPWR sky130_fd_sc_hd__decap_3
XFILLER_11_331 VGND VGND VPWR VPWR sky130_fd_sc_hd__decap_3
XFILLER_7_16 VGND VGND VPWR VPWR sky130_fd_sc_hd__fill_1
Xwire266 _4339_/X VGND VGND VPWR VPWR _4848_/A sky130_fd_sc_hd__buf_2
XTAP_TAPCELL_ROW_21_370 VGND VPWR sky130_fd_sc_hd__tapvpwrvgnd_1
XFILLER_38_206 VGND VGND VPWR VPWR sky130_fd_sc_hd__decap_3
XFILLER_34_412 VGND VGND VPWR VPWR sky130_fd_sc_hd__fill_2
XFILLER_46_283 VGND VGND VPWR VPWR sky130_fd_sc_hd__decap_3
X_5770_ _5751_/X _5752_/Y _5770_/S VGND VGND VPWR VPWR _5770_/X sky130_fd_sc_hd__mux2_2
XFILLER_61_275 VGND VGND VPWR VPWR sky130_fd_sc_hd__decap_3
X_4721_ _4551_/X _4720_/X _4721_/S VGND VGND VPWR VPWR _4721_/X sky130_fd_sc_hd__mux2_2
X_4652_ _4497_/A _4630_/Y _4623_/B _5038_/A _4651_/X VGND VGND VPWR VPWR _4652_/X
+ sky130_fd_sc_hd__o221a_2
Xinput30 operand_a[31] VGND VGND VPWR VPWR input30/X sky130_fd_sc_hd__clkdlybuf4s25_1
X_3603_ _3580_/Y _5013_/B _3593_/X _3703_/A _3602_/X VGND VGND VPWR VPWR _3603_/X
+ sky130_fd_sc_hd__a221o_2
Xinput63 operand_a[61] VGND VGND VPWR VPWR input63/X sky130_fd_sc_hd__clkdlybuf4s25_1
Xinput52 operand_a[51] VGND VGND VPWR VPWR input52/X sky130_fd_sc_hd__clkdlybuf4s25_1
Xinput41 operand_a[41] VGND VGND VPWR VPWR input41/X sky130_fd_sc_hd__clkdlybuf4s25_1
X_4583_ _4536_/B _4616_/B _4579_/Y _4582_/X VGND VGND VPWR VPWR _4583_/X sky130_fd_sc_hd__a31o_2
X_6322_ _6322_/A _6322_/B VGND VGND VPWR VPWR _6322_/Y sky130_fd_sc_hd__nor2_2
Xinput96 operand_b[33] VGND VGND VPWR VPWR _4821_/A sky130_fd_sc_hd__clkdlybuf4s25_1
Xinput85 operand_b[23] VGND VGND VPWR VPWR _6022_/C sky130_fd_sc_hd__buf_1
Xinput74 operand_b[13] VGND VGND VPWR VPWR _6133_/A sky130_fd_sc_hd__clkdlybuf4s25_1
X_3534_ _3527_/X _3529_/X _3531_/X _3533_/X _3572_/S _3803_/S VGND VGND VPWR VPWR
+ _3535_/B sky130_fd_sc_hd__mux4_2
X_6253_ _6243_/B _6243_/D _6252_/B _4698_/A VGND VGND VPWR VPWR _6254_/A sky130_fd_sc_hd__o2bb2a_2
Xmax_cap588 input2/X VGND VGND VPWR VPWR fanout580/A sky130_fd_sc_hd__buf_2
X_3465_ _3711_/S _3412_/A _3667_/A _3554_/A VGND VGND VPWR VPWR _3666_/B sky130_fd_sc_hd__a31o_2
X_5204_ _5421_/A _5421_/B _5203_/X _5210_/B VGND VGND VPWR VPWR _5204_/X sky130_fd_sc_hd__o31a_2
X_6184_ _6184_/A VGND VGND VPWR VPWR _6221_/C sky130_fd_sc_hd__buf_1
X_3396_ _4010_/C _3394_/X _3395_/X _3571_/S _3559_/D VGND VGND VPWR VPWR _3396_/X
+ sky130_fd_sc_hd__a221o_2
X_5135_ _4463_/B _5134_/X _5137_/A VGND VGND VPWR VPWR _5136_/B sky130_fd_sc_hd__mux2_2
X_5066_ _5535_/A _5535_/B _5535_/C _5536_/D VGND VGND VPWR VPWR _5624_/C sky130_fd_sc_hd__or4b_2
XFILLER_44_209 VGND VGND VPWR VPWR sky130_fd_sc_hd__decap_3
X_4017_ _3647_/B _4016_/X _4140_/A VGND VGND VPWR VPWR _4017_/X sky130_fd_sc_hd__mux2_2
XTAP_TAPCELL_ROW_27_418 VGND VPWR sky130_fd_sc_hd__tapvpwrvgnd_1
XFILLER_52_253 VGND VGND VPWR VPWR sky130_fd_sc_hd__fill_2
XFILLER_25_489 VGND VGND VPWR VPWR sky130_fd_sc_hd__fill_1
XFILLER_40_404 VGND VGND VPWR VPWR sky130_fd_sc_hd__fill_2
XFILLER_40_415 VGND VGND VPWR VPWR sky130_fd_sc_hd__decap_3
XFILLER_52_264 VGND VGND VPWR VPWR sky130_fd_sc_hd__decap_3
X_5968_ _5968_/A _6423_/B VGND VGND VPWR VPWR _5968_/Y sky130_fd_sc_hd__nor2_2
X_4919_ _4919_/A _4919_/B VGND VGND VPWR VPWR _4975_/C sky130_fd_sc_hd__nor2_2
XTAP_TAPCELL_ROW_35_495 VGND VPWR sky130_fd_sc_hd__tapvpwrvgnd_1
X_5899_ _5909_/A _5935_/B VGND VGND VPWR VPWR _5899_/Y sky130_fd_sc_hd__nor2_2
XFILLER_75_334 VGND VGND VPWR VPWR sky130_fd_sc_hd__fill_2
XFILLER_43_220 VGND VGND VPWR VPWR sky130_fd_sc_hd__decap_3
XFILLER_43_253 VGND VGND VPWR VPWR sky130_fd_sc_hd__decap_3
XFILLER_43_297 VGND VGND VPWR VPWR sky130_fd_sc_hd__decap_3
XFILLER_7_110 VGND VGND VPWR VPWR sky130_fd_sc_hd__fill_2
XFILLER_3_393 VGND VGND VPWR VPWR sky130_fd_sc_hd__fill_1
X_3250_ _3264_/A _3349_/A _3249_/X VGND VGND VPWR VPWR _3250_/Y sky130_fd_sc_hd__a21oi_2
XFILLER_66_312 VGND VGND VPWR VPWR sky130_fd_sc_hd__decap_3
XFILLER_78_194 VGND VGND VPWR VPWR sky130_fd_sc_hd__fill_2
XTAP_TAPCELL_ROW_77_874 VGND VPWR sky130_fd_sc_hd__tapvpwrvgnd_1
XFILLER_19_294 VGND VGND VPWR VPWR sky130_fd_sc_hd__decap_3
XFILLER_34_231 VGND VGND VPWR VPWR sky130_fd_sc_hd__decap_3
XFILLER_34_253 VGND VGND VPWR VPWR sky130_fd_sc_hd__decap_3
X_5822_ _5822_/A _5822_/B VGND VGND VPWR VPWR _5822_/Y sky130_fd_sc_hd__nor2_2
X_5753_ _5753_/A _5770_/S _5752_/Y VGND VGND VPWR VPWR _5753_/Y sky130_fd_sc_hd__nor3b_2
X_4704_ _4486_/X _4701_/X _4703_/X VGND VGND VPWR VPWR _4705_/B sky130_fd_sc_hd__o21ai_2
XTAP_TAPCELL_ROW_32_465 VGND VPWR sky130_fd_sc_hd__tapvpwrvgnd_1
X_5684_ _5609_/A _5762_/B _5682_/A VGND VGND VPWR VPWR _5685_/C sky130_fd_sc_hd__a21o_2
X_4635_ _4726_/S _3933_/X _4634_/Y _5739_/B VGND VGND VPWR VPWR _5859_/B sky130_fd_sc_hd__a211o_2
X_4566_ _4561_/X _4563_/X _4565_/X VGND VGND VPWR VPWR _4566_/Y sky130_fd_sc_hd__a21oi_2
X_6305_ _6383_/A _6306_/C _6383_/B VGND VGND VPWR VPWR _6393_/C sky130_fd_sc_hd__and3_2
Xmax_cap330 _3608_/C VGND VGND VPWR VPWR _3679_/D sky130_fd_sc_hd__buf_2
X_3517_ _4199_/A _4200_/A _3548_/B VGND VGND VPWR VPWR _3517_/X sky130_fd_sc_hd__mux2_2
X_4497_ _4497_/A _4497_/B VGND VGND VPWR VPWR _4497_/Y sky130_fd_sc_hd__nor2_2
X_6236_ _6233_/B _6228_/X _6233_/A VGND VGND VPWR VPWR _6236_/X sky130_fd_sc_hd__a21o_2
X_3448_ _4233_/A _3448_/B VGND VGND VPWR VPWR _3448_/X sky130_fd_sc_hd__and2_2
X_6167_ _6167_/A _6167_/B _6167_/C _6167_/D VGND VGND VPWR VPWR _6168_/B sky130_fd_sc_hd__or4_2
X_3379_ _4086_/A _3664_/A _3754_/A _3812_/A _3652_/S _3791_/S VGND VGND VPWR VPWR
+ _3379_/X sky130_fd_sc_hd__mux4_2
X_5118_ _5118_/A VGND VGND VPWR VPWR _5118_/X sky130_fd_sc_hd__clkbuf_1
XFILLER_69_183 VGND VGND VPWR VPWR sky130_fd_sc_hd__decap_3
XFILLER_57_312 VGND VGND VPWR VPWR sky130_fd_sc_hd__decap_3
X_6098_ _6098_/A _6098_/B VGND VGND VPWR VPWR _6098_/Y sky130_fd_sc_hd__xnor2_2
XFILLER_57_378 VGND VGND VPWR VPWR sky130_fd_sc_hd__decap_3
X_5049_ _3629_/X _3634_/X _5049_/S VGND VGND VPWR VPWR _5050_/B sky130_fd_sc_hd__mux2_2
XFILLER_72_326 VGND VGND VPWR VPWR sky130_fd_sc_hd__decap_3
XFILLER_25_231 VGND VGND VPWR VPWR sky130_fd_sc_hd__decap_3
XFILLER_72_348 VGND VGND VPWR VPWR sky130_fd_sc_hd__decap_3
XFILLER_25_253 VGND VGND VPWR VPWR sky130_fd_sc_hd__decap_3
XFILLER_25_275 VGND VGND VPWR VPWR sky130_fd_sc_hd__decap_3
XFILLER_40_212 VGND VGND VPWR VPWR sky130_fd_sc_hd__decap_3
XFILLER_43_67 VGND VGND VPWR VPWR sky130_fd_sc_hd__decap_3
XFILLER_48_312 VGND VGND VPWR VPWR sky130_fd_sc_hd__decap_3
XFILLER_48_356 VGND VGND VPWR VPWR sky130_fd_sc_hd__decap_3
XFILLER_63_337 VGND VGND VPWR VPWR sky130_fd_sc_hd__decap_3
XFILLER_63_315 VGND VGND VPWR VPWR sky130_fd_sc_hd__decap_3
XTAP_TAPCELL_ROW_74_844 VGND VPWR sky130_fd_sc_hd__tapvpwrvgnd_1
XFILLER_63_359 VGND VGND VPWR VPWR sky130_fd_sc_hd__decap_3
XFILLER_16_253 VGND VGND VPWR VPWR sky130_fd_sc_hd__fill_1
XPHY_EDGE_ROW_9_Left_92 VGND VGND VPWR VPWR sky130_fd_sc_hd__decap_3
XFILLER_71_370 VGND VGND VPWR VPWR sky130_fd_sc_hd__decap_3
XFILLER_16_286 VGND VGND VPWR VPWR sky130_fd_sc_hd__decap_3
XFILLER_31_223 VGND VGND VPWR VPWR sky130_fd_sc_hd__fill_1
XFILLER_31_234 VGND VGND VPWR VPWR sky130_fd_sc_hd__fill_2
XFILLER_8_463 VGND VGND VPWR VPWR sky130_fd_sc_hd__decap_3
X_4420_ _6442_/B _3708_/B _4372_/B VGND VGND VPWR VPWR _4420_/X sky130_fd_sc_hd__a21o_2
X_4351_ _4449_/A _4351_/B VGND VGND VPWR VPWR _4709_/B sky130_fd_sc_hd__xnor2_2
Xfanout409 input8/X VGND VGND VPWR VPWR _3908_/A sky130_fd_sc_hd__clkdlybuf4s25_1
X_4282_ _6473_/S _4276_/X _4281_/X VGND VGND VPWR VPWR _4282_/Y sky130_fd_sc_hd__a21boi_2
X_3302_ _3302_/A VGND VGND VPWR VPWR _6472_/S sky130_fd_sc_hd__clkbuf_2
X_6021_ _6171_/A _6171_/B _6173_/A _6021_/D VGND VGND VPWR VPWR _6059_/C sky130_fd_sc_hd__and4_2
X_3233_ _5281_/A3 _5338_/A3 _6449_/A3 _6449_/A2 _6449_/S0 _3424_/B VGND VGND VPWR
+ VPWR _3233_/X sky130_fd_sc_hd__mux4_2
XFILLER_39_334 VGND VGND VPWR VPWR sky130_fd_sc_hd__fill_2
XFILLER_39_356 VGND VGND VPWR VPWR sky130_fd_sc_hd__decap_3
XFILLER_39_389 VGND VGND VPWR VPWR sky130_fd_sc_hd__decap_3
XFILLER_54_315 VGND VGND VPWR VPWR sky130_fd_sc_hd__decap_3
XTAP_TAPCELL_ROW_37_513 VGND VPWR sky130_fd_sc_hd__tapvpwrvgnd_1
XFILLER_66_186 VGND VGND VPWR VPWR sky130_fd_sc_hd__decap_3
XFILLER_66_197 VGND VGND VPWR VPWR sky130_fd_sc_hd__fill_1
XFILLER_22_234 VGND VGND VPWR VPWR sky130_fd_sc_hd__fill_1
XFILLER_22_256 VGND VGND VPWR VPWR sky130_fd_sc_hd__fill_1
X_5805_ _5805_/A _5805_/B VGND VGND VPWR VPWR _5805_/Y sky130_fd_sc_hd__nor2_2
X_3997_ _4076_/A _3912_/B _4076_/B _3996_/X VGND VGND VPWR VPWR _3998_/B sky130_fd_sc_hd__a31o_2
XFILLER_22_289 VGND VGND VPWR VPWR sky130_fd_sc_hd__fill_1
X_5736_ _5752_/B _5970_/B wire261/X _5721_/A _5735_/X VGND VGND VPWR VPWR _5736_/X
+ sky130_fd_sc_hd__a221o_2
X_5667_ _5609_/A _5659_/X _5660_/X _5967_/B1 _5666_/Y VGND VGND VPWR VPWR _5667_/X
+ sky130_fd_sc_hd__a221o_2
X_4618_ _6243_/A _6060_/D VGND VGND VPWR VPWR _4700_/A sky130_fd_sc_hd__xnor2_2
X_5598_ _5637_/A _5599_/B VGND VGND VPWR VPWR _5648_/A sky130_fd_sc_hd__nor2_2
X_4549_ _4627_/C _4549_/B VGND VGND VPWR VPWR _4549_/Y sky130_fd_sc_hd__xnor2_2
X_6219_ _4230_/A _6216_/Y _6217_/X _4239_/A _6218_/X VGND VGND VPWR VPWR _6219_/X
+ sky130_fd_sc_hd__a221o_2
XFILLER_45_326 VGND VGND VPWR VPWR sky130_fd_sc_hd__decap_3
XFILLER_57_175 VGND VGND VPWR VPWR sky130_fd_sc_hd__decap_3
XFILLER_45_337 VGND VGND VPWR VPWR sky130_fd_sc_hd__decap_3
XTAP_TAPCELL_ROW_71_814 VGND VPWR sky130_fd_sc_hd__tapvpwrvgnd_1
XTAP_TAPCELL_ROW_0_171 VGND VPWR sky130_fd_sc_hd__tapvpwrvgnd_1
XFILLER_72_189 VGND VGND VPWR VPWR sky130_fd_sc_hd__decap_3
XFILLER_60_318 VGND VGND VPWR VPWR sky130_fd_sc_hd__decap_3
XFILLER_13_234 VGND VGND VPWR VPWR sky130_fd_sc_hd__fill_2
XFILLER_54_99 VGND VGND VPWR VPWR sky130_fd_sc_hd__fill_1
XTAP_TAPCELL_ROW_0_182 VGND VPWR sky130_fd_sc_hd__tapvpwrvgnd_1
XFILLER_13_245 VGND VGND VPWR VPWR sky130_fd_sc_hd__decap_3
XFILLER_70_65 VGND VGND VPWR VPWR sky130_fd_sc_hd__fill_2
XFILLER_5_488 VGND VGND VPWR VPWR sky130_fd_sc_hd__decap_3
XFILLER_48_153 VGND VGND VPWR VPWR sky130_fd_sc_hd__decap_3
XFILLER_36_304 VGND VGND VPWR VPWR sky130_fd_sc_hd__decap_3
XFILLER_36_326 VGND VGND VPWR VPWR sky130_fd_sc_hd__decap_3
XFILLER_48_186 VGND VGND VPWR VPWR sky130_fd_sc_hd__fill_1
XFILLER_48_197 VGND VGND VPWR VPWR sky130_fd_sc_hd__decap_3
XFILLER_51_307 VGND VGND VPWR VPWR sky130_fd_sc_hd__decap_3
X_3920_ _3615_/A _3615_/B _3615_/C _3919_/X VGND VGND VPWR VPWR _3925_/A sky130_fd_sc_hd__a31o_2
X_3851_ _3620_/A _3840_/X _3844_/Y _3363_/Y _3850_/X VGND VGND VPWR VPWR _3851_/X
+ sky130_fd_sc_hd__o221a_2
X_3782_ _4462_/S _3782_/B VGND VGND VPWR VPWR _3782_/Y sky130_fd_sc_hd__nand2_2
XTAP_TAPCELL_ROW_42_560 VGND VPWR sky130_fd_sc_hd__tapvpwrvgnd_1
X_5521_ _5712_/A VGND VGND VPWR VPWR _5553_/S sky130_fd_sc_hd__inv_2
X_5452_ _5440_/Y _5445_/X _5538_/A _5168_/A _5451_/X VGND VGND VPWR VPWR _5452_/X
+ sky130_fd_sc_hd__a221o_2
X_5383_ _5418_/C _5416_/A VGND VGND VPWR VPWR _5383_/Y sky130_fd_sc_hd__nor2_2
X_4403_ _6176_/A _6059_/A VGND VGND VPWR VPWR _4403_/X sky130_fd_sc_hd__or2_2
X_4334_ _6427_/A _4327_/X _4333_/Y VGND VGND VPWR VPWR _4334_/X sky130_fd_sc_hd__a21bo_2
X_6004_ _6004_/A _6004_/B _6004_/C _6004_/D VGND VGND VPWR VPWR _6005_/D sky130_fd_sc_hd__or4_4
X_4265_ _4265_/A _4708_/A _4360_/D _4361_/A VGND VGND VPWR VPWR _4266_/B sky130_fd_sc_hd__or4_2
X_4196_ _5084_/S _4196_/B VGND VGND VPWR VPWR _4598_/B sky130_fd_sc_hd__nand2_2
XFILLER_39_186 VGND VGND VPWR VPWR sky130_fd_sc_hd__decap_3
XFILLER_67_473 VGND VGND VPWR VPWR sky130_fd_sc_hd__fill_2
XFILLER_27_337 VGND VGND VPWR VPWR sky130_fd_sc_hd__decap_3
XFILLER_54_134 VGND VGND VPWR VPWR sky130_fd_sc_hd__decap_3
XPHY_EDGE_ROW_59_Left_142 VGND VGND VPWR VPWR sky130_fd_sc_hd__decap_3
XFILLER_50_351 VGND VGND VPWR VPWR sky130_fd_sc_hd__decap_3
XFILLER_50_395 VGND VGND VPWR VPWR sky130_fd_sc_hd__decap_3
X_5719_ _5734_/S _5752_/B VGND VGND VPWR VPWR _5721_/A sky130_fd_sc_hd__nor2_2
XPHY_EDGE_ROW_68_Left_151 VGND VGND VPWR VPWR sky130_fd_sc_hd__decap_3
XFILLER_77_237 VGND VGND VPWR VPWR sky130_fd_sc_hd__fill_2
XTAP_TAPCELL_ROW_48_608 VGND VPWR sky130_fd_sc_hd__tapvpwrvgnd_1
XFILLER_45_145 VGND VGND VPWR VPWR sky130_fd_sc_hd__decap_3
XFILLER_33_307 VGND VGND VPWR VPWR sky130_fd_sc_hd__fill_1
XFILLER_45_167 VGND VGND VPWR VPWR sky130_fd_sc_hd__fill_1
XFILLER_45_178 VGND VGND VPWR VPWR sky130_fd_sc_hd__decap_3
XPHY_EDGE_ROW_77_Left_160 VGND VGND VPWR VPWR sky130_fd_sc_hd__decap_3
XFILLER_33_329 VGND VGND VPWR VPWR sky130_fd_sc_hd__decap_3
XTAP_TAPCELL_ROW_56_685 VGND VPWR sky130_fd_sc_hd__tapvpwrvgnd_1
XFILLER_41_340 VGND VGND VPWR VPWR sky130_fd_sc_hd__decap_3
XFILLER_41_351 VGND VGND VPWR VPWR sky130_fd_sc_hd__decap_3
XTAP_TAPCELL_ROW_11_276 VGND VPWR sky130_fd_sc_hd__tapvpwrvgnd_1
XFILLER_68_237 VGND VGND VPWR VPWR sky130_fd_sc_hd__fill_2
X_4050_ _4018_/A _6162_/A _4049_/X VGND VGND VPWR VPWR _4050_/X sky130_fd_sc_hd__o21a_2
XFILLER_68_248 VGND VGND VPWR VPWR sky130_fd_sc_hd__decap_3
Xinput6 operand_a[0] VGND VGND VPWR VPWR input6/X sky130_fd_sc_hd__clkdlybuf4s25_1
XFILLER_64_421 VGND VGND VPWR VPWR sky130_fd_sc_hd__fill_2
XFILLER_36_178 VGND VGND VPWR VPWR sky130_fd_sc_hd__decap_3
XTAP_TAPCELL_ROW_19_354 VGND VPWR sky130_fd_sc_hd__tapvpwrvgnd_1
X_4952_ _4813_/X _4902_/Y _4928_/X _5685_/A _4951_/X VGND VGND VPWR VPWR _6000_/B
+ sky130_fd_sc_hd__a221o_2
XFILLER_32_340 VGND VGND VPWR VPWR sky130_fd_sc_hd__fill_2
X_4883_ _5168_/A VGND VGND VPWR VPWR _4883_/X sky130_fd_sc_hd__clkbuf_1
X_3903_ _3704_/A _3899_/X _3902_/Y _4196_/B VGND VGND VPWR VPWR _3903_/X sky130_fd_sc_hd__a2bb2o_2
X_3834_ _3949_/S _3834_/B VGND VGND VPWR VPWR _5216_/B sky130_fd_sc_hd__nand2_2
X_3765_ _5685_/A _3732_/X _3735_/X _3764_/X VGND VGND VPWR VPWR _5991_/A sky130_fd_sc_hd__a31o_2
X_6484_ _6491_/B _6498_/A VGND VGND VPWR VPWR _6484_/Y sky130_fd_sc_hd__nand2_2
X_5504_ _5412_/B _5580_/B _5503_/X VGND VGND VPWR VPWR _5543_/S sky130_fd_sc_hd__a21oi_2
X_3696_ _3236_/X _3648_/X _3695_/X _3649_/X _3842_/S _3750_/A VGND VGND VPWR VPWR
+ _3696_/X sky130_fd_sc_hd__mux4_2
X_5435_ _5421_/Y _5530_/B _5434_/X VGND VGND VPWR VPWR _5436_/B sky130_fd_sc_hd__o21ai_2
X_5366_ _6319_/B _5388_/S VGND VGND VPWR VPWR _5394_/A sky130_fd_sc_hd__and2b_2
X_5297_ _5297_/A _5120_/B VGND VGND VPWR VPWR _5624_/B sky130_fd_sc_hd__or2b_2
X_4317_ _6173_/A _4315_/Y _4316_/X VGND VGND VPWR VPWR _4318_/B sky130_fd_sc_hd__a21oi_2
X_4248_ _4267_/A _4267_/B VGND VGND VPWR VPWR _4259_/B sky130_fd_sc_hd__nand2_2
XTAP_TAPCELL_ROW_2_200 VGND VPWR sky130_fd_sc_hd__tapvpwrvgnd_1
X_4179_ _4211_/B _4217_/A VGND VGND VPWR VPWR _4179_/Y sky130_fd_sc_hd__xnor2_2
XFILLER_27_167 VGND VGND VPWR VPWR sky130_fd_sc_hd__fill_1
XFILLER_82_251 VGND VGND VPWR VPWR sky130_fd_sc_hd__fill_1
XFILLER_27_178 VGND VGND VPWR VPWR sky130_fd_sc_hd__decap_3
XFILLER_82_284 VGND VGND VPWR VPWR sky130_fd_sc_hd__decap_3
XFILLER_35_68 VGND VGND VPWR VPWR sky130_fd_sc_hd__fill_1
XFILLER_42_159 VGND VGND VPWR VPWR sky130_fd_sc_hd__decap_3
XTAP_TAPCELL_ROW_53_655 VGND VPWR sky130_fd_sc_hd__tapvpwrvgnd_1
XFILLER_11_513 VGND VGND VPWR VPWR sky130_fd_sc_hd__decap_3
XFILLER_23_373 VGND VGND VPWR VPWR sky130_fd_sc_hd__decap_3
XPHY_EDGE_ROW_14_Right_14 VGND VGND VPWR VPWR sky130_fd_sc_hd__decap_3
XPHY_EDGE_ROW_23_Right_23 VGND VGND VPWR VPWR sky130_fd_sc_hd__decap_3
Xfanout570 input21/X VGND VGND VPWR VPWR _6208_/A sky130_fd_sc_hd__clkdlybuf4s25_1
Xfanout581 _6485_/A VGND VGND VPWR VPWR _3241_/A sky130_fd_sc_hd__clkdlybuf4s25_1
Xfanout592 input18/X VGND VGND VPWR VPWR _4355_/A sky130_fd_sc_hd__clkdlybuf4s25_1
XFILLER_76_75 VGND VGND VPWR VPWR sky130_fd_sc_hd__fill_1
XFILLER_65_218 VGND VGND VPWR VPWR sky130_fd_sc_hd__decap_3
XFILLER_46_421 VGND VGND VPWR VPWR sky130_fd_sc_hd__decap_3
XFILLER_18_167 VGND VGND VPWR VPWR sky130_fd_sc_hd__decap_3
XFILLER_73_251 VGND VGND VPWR VPWR sky130_fd_sc_hd__fill_2
XTAP_TAPCELL_ROW_16_324 VGND VPWR sky130_fd_sc_hd__tapvpwrvgnd_1
XPHY_EDGE_ROW_32_Right_32 VGND VGND VPWR VPWR sky130_fd_sc_hd__decap_3
XFILLER_14_384 VGND VGND VPWR VPWR sky130_fd_sc_hd__decap_3
X_3550_ _3612_/B _3548_/Y _3679_/D VGND VGND VPWR VPWR _3551_/C sky130_fd_sc_hd__mux2_2
X_5220_ _4720_/X _4877_/X _5045_/X _5219_/X _5616_/A _5548_/S VGND VGND VPWR VPWR
+ _5220_/X sky130_fd_sc_hd__mux4_2
X_3481_ _3363_/Y _3470_/Y _3476_/X _3480_/X VGND VGND VPWR VPWR _3481_/X sky130_fd_sc_hd__o211a_2
XPHY_EDGE_ROW_41_Right_41 VGND VGND VPWR VPWR sky130_fd_sc_hd__decap_3
X_5151_ _5696_/A _5131_/Y _5140_/X _5142_/X _5150_/X VGND VGND VPWR VPWR _5151_/Y
+ sky130_fd_sc_hd__o2111ai_2
X_5082_ _5128_/A _5054_/A _6265_/B _6265_/A _5173_/S0 wire372/X VGND VGND VPWR VPWR
+ _5082_/X sky130_fd_sc_hd__mux4_2
X_4102_ _4102_/A _4102_/B VGND VGND VPWR VPWR _4102_/Y sky130_fd_sc_hd__nand2_2
XFILLER_56_218 VGND VGND VPWR VPWR sky130_fd_sc_hd__decap_3
X_4033_ _3982_/S _6152_/A _6158_/A _4042_/A _3995_/X VGND VGND VPWR VPWR _4033_/X
+ sky130_fd_sc_hd__o221a_2
XFILLER_49_281 VGND VGND VPWR VPWR sky130_fd_sc_hd__decap_3
XFILLER_64_240 VGND VGND VPWR VPWR sky130_fd_sc_hd__decap_3
XPHY_EDGE_ROW_50_Right_50 VGND VGND VPWR VPWR sky130_fd_sc_hd__decap_3
XFILLER_64_273 VGND VGND VPWR VPWR sky130_fd_sc_hd__fill_2
X_5984_ _5984_/A _5984_/B _5984_/C _5984_/D VGND VGND VPWR VPWR _6002_/B sky130_fd_sc_hd__or4_2
X_4935_ _4593_/X _4934_/X _5175_/S VGND VGND VPWR VPWR _4935_/X sky130_fd_sc_hd__mux2_2
XTAP_TAPCELL_ROW_50_625 VGND VPWR sky130_fd_sc_hd__tapvpwrvgnd_1
XANTENNA_11 _3980_/X VGND VGND VPWR VPWR sky130_fd_sc_hd__diode_2
XANTENNA_22 _4527_/X VGND VGND VPWR VPWR sky130_fd_sc_hd__diode_2
X_4866_ _4954_/C _4901_/A VGND VGND VPWR VPWR _4866_/Y sky130_fd_sc_hd__xnor2_2
XANTENNA_33 _6100_/B VGND VGND VPWR VPWR sky130_fd_sc_hd__diode_2
X_4797_ _4797_/A VGND VGND VPWR VPWR _4797_/X sky130_fd_sc_hd__clkbuf_1
X_3817_ _4086_/A _4077_/A _3817_/C VGND VGND VPWR VPWR _3817_/X sky130_fd_sc_hd__or3_2
X_3748_ _3748_/A _3748_/B _4374_/A VGND VGND VPWR VPWR _3749_/A sky130_fd_sc_hd__and3_2
X_6467_ input9/X _6467_/A1 _6467_/A2 _6467_/A3 _4014_/S _6468_/S1 VGND VGND VPWR VPWR
+ _6467_/X sky130_fd_sc_hd__mux4_2
X_3679_ _3679_/A _3679_/B _3679_/C _3679_/D VGND VGND VPWR VPWR _3679_/X sky130_fd_sc_hd__or4_2
X_6398_ _6282_/X _6355_/X _6397_/X VGND VGND VPWR VPWR _6398_/X sky130_fd_sc_hd__a21o_2
Xoutput151 _5995_/A VGND VGND VPWR VPWR result[22] sky130_fd_sc_hd__clkdlybuf4s25_1
Xoutput140 _5992_/B VGND VGND VPWR VPWR result[12] sky130_fd_sc_hd__clkdlybuf4s25_1
X_5418_ _5373_/A _5418_/B _5418_/C VGND VGND VPWR VPWR _5418_/X sky130_fd_sc_hd__and3b_2
Xoutput162 _5999_/B VGND VGND VPWR VPWR result[32] sky130_fd_sc_hd__clkdlybuf4s25_1
Xoutput173 _5984_/B VGND VGND VPWR VPWR result[42] sky130_fd_sc_hd__clkdlybuf4s25_1
Xoutput184 _6000_/D VGND VGND VPWR VPWR result[52] sky130_fd_sc_hd__clkdlybuf4s25_1
Xoutput195 _6005_/B VGND VGND VPWR VPWR result[62] sky130_fd_sc_hd__clkdlybuf4s25_1
X_5349_ _5352_/A VGND VGND VPWR VPWR _5418_/C sky130_fd_sc_hd__inv_2
XTAP_TAPCELL_ROW_58_703 VGND VPWR sky130_fd_sc_hd__tapvpwrvgnd_1
XFILLER_15_104 VGND VGND VPWR VPWR sky130_fd_sc_hd__decap_3
XFILLER_43_402 VGND VGND VPWR VPWR sky130_fd_sc_hd__fill_2
XFILLER_43_413 VGND VGND VPWR VPWR sky130_fd_sc_hd__decap_3
XFILLER_70_221 VGND VGND VPWR VPWR sky130_fd_sc_hd__decap_3
XFILLER_70_265 VGND VGND VPWR VPWR sky130_fd_sc_hd__decap_3
XTAP_TAPCELL_ROW_21_371 VGND VPWR sky130_fd_sc_hd__tapvpwrvgnd_1
Xwire289 _5012_/C VGND VGND VPWR VPWR _4339_/A sky130_fd_sc_hd__buf_2
XFILLER_38_229 VGND VGND VPWR VPWR sky130_fd_sc_hd__decap_3
XFILLER_34_424 VGND VGND VPWR VPWR sky130_fd_sc_hd__fill_1
XFILLER_46_262 VGND VGND VPWR VPWR sky130_fd_sc_hd__decap_3
XFILLER_46_295 VGND VGND VPWR VPWR sky130_fd_sc_hd__decap_3
XFILLER_61_243 VGND VGND VPWR VPWR sky130_fd_sc_hd__decap_3
XFILLER_42_490 VGND VGND VPWR VPWR sky130_fd_sc_hd__decap_3
X_4720_ _4734_/A _4695_/A _4679_/A _4599_/A _5008_/S0 wire372/X VGND VGND VPWR VPWR
+ _4720_/X sky130_fd_sc_hd__mux4_2
X_4651_ _3945_/Y _4598_/B _4638_/X _4642_/Y _4650_/X VGND VGND VPWR VPWR _4651_/X
+ sky130_fd_sc_hd__o2111a_2
Xinput31 operand_a[32] VGND VGND VPWR VPWR input31/X sky130_fd_sc_hd__clkdlybuf4s25_1
Xinput20 operand_a[22] VGND VGND VPWR VPWR input20/X sky130_fd_sc_hd__clkdlybuf4s25_1
X_3602_ _3572_/S _3594_/X _3597_/X _3601_/X _3940_/A VGND VGND VPWR VPWR _3602_/X
+ sky130_fd_sc_hd__a32o_2
Xinput64 operand_a[62] VGND VGND VPWR VPWR input64/X sky130_fd_sc_hd__clkdlybuf4s25_1
Xinput53 operand_a[52] VGND VGND VPWR VPWR input53/X sky130_fd_sc_hd__clkdlybuf4s25_1
Xinput42 operand_a[42] VGND VGND VPWR VPWR input42/X sky130_fd_sc_hd__clkdlybuf4s25_1
X_4582_ _4614_/A _4533_/B _4582_/S VGND VGND VPWR VPWR _4582_/X sky130_fd_sc_hd__mux2_2
X_6321_ _6339_/A _6324_/S _5474_/X VGND VGND VPWR VPWR _6321_/Y sky130_fd_sc_hd__a21oi_2
Xinput97 operand_b[34] VGND VGND VPWR VPWR _6053_/A sky130_fd_sc_hd__clkdlybuf4s25_1
Xinput86 operand_b[24] VGND VGND VPWR VPWR input86/X sky130_fd_sc_hd__clkdlybuf4s25_1
Xinput75 operand_b[14] VGND VGND VPWR VPWR input75/X sky130_fd_sc_hd__clkdlybuf4s25_1
X_3533_ _3285_/X _3532_/X _3653_/S VGND VGND VPWR VPWR _3533_/X sky130_fd_sc_hd__mux2_2
X_6252_ _6252_/A _6252_/B VGND VGND VPWR VPWR _6252_/Y sky130_fd_sc_hd__nor2_2
X_3464_ _3464_/A _3464_/B _3464_/C VGND VGND VPWR VPWR _3666_/A sky130_fd_sc_hd__and3_2
X_6183_ _6183_/A _6183_/B _6183_/C VGND VGND VPWR VPWR _6184_/A sky130_fd_sc_hd__and3_2
X_5203_ _5116_/A _5116_/B _6391_/A VGND VGND VPWR VPWR _5203_/X sky130_fd_sc_hd__a21o_2
X_5134_ _4804_/X _5133_/X _6106_/A VGND VGND VPWR VPWR _5134_/X sky130_fd_sc_hd__mux2_2
X_3395_ _6429_/B _5946_/A3 _6428_/A2 _6431_/A1 _3625_/A _6439_/S0 VGND VGND VPWR VPWR
+ _3395_/X sky130_fd_sc_hd__mux4_2
XFILLER_69_332 VGND VGND VPWR VPWR sky130_fd_sc_hd__decap_3
X_5065_ _5120_/C _5120_/D VGND VGND VPWR VPWR _5536_/D sky130_fd_sc_hd__and2_2
X_4016_ _3842_/X _4015_/X _4461_/S VGND VGND VPWR VPWR _4016_/X sky130_fd_sc_hd__mux2_2
XFILLER_25_402 VGND VGND VPWR VPWR sky130_fd_sc_hd__decap_3
XFILLER_37_284 VGND VGND VPWR VPWR sky130_fd_sc_hd__decap_3
XTAP_TAPCELL_ROW_27_419 VGND VPWR sky130_fd_sc_hd__tapvpwrvgnd_1
XFILLER_52_221 VGND VGND VPWR VPWR sky130_fd_sc_hd__fill_2
XFILLER_52_232 VGND VGND VPWR VPWR sky130_fd_sc_hd__decap_3
XFILLER_40_427 VGND VGND VPWR VPWR sky130_fd_sc_hd__decap_3
XFILLER_52_276 VGND VGND VPWR VPWR sky130_fd_sc_hd__decap_3
X_5967_ _6474_/B _5242_/Y _5967_/B1 VGND VGND VPWR VPWR _5967_/X sky130_fd_sc_hd__a21o_2
XTAP_TAPCELL_ROW_63_750 VGND VPWR sky130_fd_sc_hd__tapvpwrvgnd_1
X_4918_ _4825_/Y _4910_/X _4911_/X _4912_/X _4917_/X VGND VGND VPWR VPWR _4918_/X
+ sky130_fd_sc_hd__o2111a_2
XTAP_TAPCELL_ROW_35_496 VGND VPWR sky130_fd_sc_hd__tapvpwrvgnd_1
X_5898_ _5923_/A _6419_/A VGND VGND VPWR VPWR _5935_/B sky130_fd_sc_hd__nor2_2
XFILLER_20_173 VGND VGND VPWR VPWR sky130_fd_sc_hd__decap_3
X_4849_ _4849_/A _4849_/B _4849_/C VGND VGND VPWR VPWR _4849_/X sky130_fd_sc_hd__or3_2
XFILLER_4_306 VGND VGND VPWR VPWR sky130_fd_sc_hd__fill_2
XFILLER_0_501 VGND VGND VPWR VPWR sky130_fd_sc_hd__decap_3
XFILLER_0_512 VGND VGND VPWR VPWR sky130_fd_sc_hd__decap_3
XFILLER_57_11 VGND VGND VPWR VPWR sky130_fd_sc_hd__fill_1
XFILLER_57_55 VGND VGND VPWR VPWR sky130_fd_sc_hd__fill_1
XFILLER_28_240 VGND VGND VPWR VPWR sky130_fd_sc_hd__decap_3
XFILLER_28_273 VGND VGND VPWR VPWR sky130_fd_sc_hd__fill_1
XFILLER_43_232 VGND VGND VPWR VPWR sky130_fd_sc_hd__decap_3
XFILLER_31_449 VGND VGND VPWR VPWR sky130_fd_sc_hd__fill_1
XFILLER_66_324 VGND VGND VPWR VPWR sky130_fd_sc_hd__decap_3
XFILLER_19_240 VGND VGND VPWR VPWR sky130_fd_sc_hd__fill_2
XTAP_TAPCELL_ROW_77_875 VGND VPWR sky130_fd_sc_hd__tapvpwrvgnd_1
XFILLER_34_243 VGND VGND VPWR VPWR sky130_fd_sc_hd__decap_3
XFILLER_34_265 VGND VGND VPWR VPWR sky130_fd_sc_hd__decap_3
X_5821_ _5822_/B _5821_/B VGND VGND VPWR VPWR _5821_/Y sky130_fd_sc_hd__xnor2_2
XPHY_EDGE_ROW_22_Left_105 VGND VGND VPWR VPWR sky130_fd_sc_hd__decap_3
X_5752_ _5752_/A _5752_/B VGND VGND VPWR VPWR _5752_/Y sky130_fd_sc_hd__nand2_2
XTAP_TAPCELL_ROW_60_720 VGND VPWR sky130_fd_sc_hd__tapvpwrvgnd_1
X_4703_ _4621_/B _4778_/B _4702_/Y VGND VGND VPWR VPWR _4703_/X sky130_fd_sc_hd__o21a_2
XTAP_TAPCELL_ROW_32_466 VGND VPWR sky130_fd_sc_hd__tapvpwrvgnd_1
X_5683_ _5853_/A _5725_/B _5762_/B VGND VGND VPWR VPWR _5685_/B sky130_fd_sc_hd__or3b_4
X_4634_ _4726_/S _4634_/B VGND VGND VPWR VPWR _4634_/Y sky130_fd_sc_hd__nor2_2
XFILLER_8_93 VGND VGND VPWR VPWR sky130_fd_sc_hd__fill_2
Xmax_cap320 _4540_/C VGND VGND VPWR VPWR _4627_/B sky130_fd_sc_hd__buf_2
X_4565_ _6233_/A _5058_/B _5352_/C _4614_/A VGND VGND VPWR VPWR _4565_/X sky130_fd_sc_hd__a22o_2
X_6304_ _6391_/C _6393_/A VGND VGND VPWR VPWR _6304_/X sky130_fd_sc_hd__and2b_2
Xmax_cap331 _3600_/C VGND VGND VPWR VPWR _4241_/B sky130_fd_sc_hd__buf_2
X_3516_ _6114_/A _6108_/B VGND VGND VPWR VPWR _3612_/B sky130_fd_sc_hd__nor2b_2
XPHY_EDGE_ROW_31_Left_114 VGND VGND VPWR VPWR sky130_fd_sc_hd__decap_3
X_4496_ _4627_/B _4496_/B VGND VGND VPWR VPWR _4497_/B sky130_fd_sc_hd__xnor2_2
XPHY_EDGE_ROW_4_Right_4 VGND VGND VPWR VPWR sky130_fd_sc_hd__decap_3
X_6235_ _6233_/B _6229_/X _6234_/X VGND VGND VPWR VPWR _6235_/X sky130_fd_sc_hd__o21a_2
X_3447_ _3710_/A _3440_/X _3446_/X _3535_/A VGND VGND VPWR VPWR _3448_/B sky130_fd_sc_hd__a22o_2
X_6166_ _6167_/C _6166_/B VGND VGND VPWR VPWR _6168_/A sky130_fd_sc_hd__nand2_2
X_3378_ _3376_/X _3377_/X _3596_/S VGND VGND VPWR VPWR _3378_/X sky130_fd_sc_hd__mux2_2
X_6097_ _3354_/S _3411_/X _6100_/C VGND VGND VPWR VPWR _6097_/Y sky130_fd_sc_hd__a21oi_2
X_5117_ _5117_/A _5117_/B _5117_/C VGND VGND VPWR VPWR _5118_/A sky130_fd_sc_hd__and3_2
XFILLER_69_195 VGND VGND VPWR VPWR sky130_fd_sc_hd__decap_3
XFILLER_57_324 VGND VGND VPWR VPWR sky130_fd_sc_hd__decap_3
X_5048_ _5509_/B _5044_/X _5047_/X _5664_/B1 VGND VGND VPWR VPWR _5048_/Y sky130_fd_sc_hd__a22oi_2
XFILLER_57_346 VGND VGND VPWR VPWR sky130_fd_sc_hd__decap_3
XFILLER_25_210 VGND VGND VPWR VPWR sky130_fd_sc_hd__decap_3
XPHY_EDGE_ROW_40_Left_123 VGND VGND VPWR VPWR sky130_fd_sc_hd__decap_3
XFILLER_25_265 VGND VGND VPWR VPWR sky130_fd_sc_hd__fill_1
XFILLER_40_224 VGND VGND VPWR VPWR sky130_fd_sc_hd__decap_3
XFILLER_43_35 VGND VGND VPWR VPWR sky130_fd_sc_hd__fill_1
XFILLER_40_246 VGND VGND VPWR VPWR sky130_fd_sc_hd__decap_3
XFILLER_4_29 VGND VGND VPWR VPWR sky130_fd_sc_hd__fill_1
XFILLER_48_324 VGND VGND VPWR VPWR sky130_fd_sc_hd__decap_3
XFILLER_48_368 VGND VGND VPWR VPWR sky130_fd_sc_hd__decap_3
XFILLER_75_165 VGND VGND VPWR VPWR sky130_fd_sc_hd__decap_3
XFILLER_63_327 VGND VGND VPWR VPWR sky130_fd_sc_hd__decap_3
XFILLER_16_232 VGND VGND VPWR VPWR sky130_fd_sc_hd__decap_3
XTAP_TAPCELL_ROW_74_845 VGND VPWR sky130_fd_sc_hd__tapvpwrvgnd_1
XFILLER_17_80 VGND VGND VPWR VPWR sky130_fd_sc_hd__decap_3
XFILLER_31_202 VGND VGND VPWR VPWR sky130_fd_sc_hd__decap_3
X_4350_ _4354_/S _4394_/A _4393_/B VGND VGND VPWR VPWR _4351_/B sky130_fd_sc_hd__a21o_2
X_3301_ _3301_/A VGND VGND VPWR VPWR _4842_/A sky130_fd_sc_hd__clkbuf_2
X_4281_ _4382_/S _3524_/X _4280_/X _4840_/B VGND VGND VPWR VPWR _4281_/X sky130_fd_sc_hd__a211o_2
X_6020_ _6158_/A _6162_/A _6164_/A VGND VGND VPWR VPWR _6183_/B sky130_fd_sc_hd__and3_2
X_3232_ _3750_/B _3228_/X _3572_/S VGND VGND VPWR VPWR _3232_/X sky130_fd_sc_hd__mux2_2
XFILLER_79_493 VGND VGND VPWR VPWR sky130_fd_sc_hd__fill_1
XFILLER_39_368 VGND VGND VPWR VPWR sky130_fd_sc_hd__decap_3
XTAP_TAPCELL_ROW_37_514 VGND VPWR sky130_fd_sc_hd__tapvpwrvgnd_1
XFILLER_47_390 VGND VGND VPWR VPWR sky130_fd_sc_hd__fill_2
XFILLER_54_349 VGND VGND VPWR VPWR sky130_fd_sc_hd__decap_3
X_5804_ _5859_/A _4555_/X _5800_/Y _5803_/X VGND VGND VPWR VPWR _5805_/B sky130_fd_sc_hd__o2bb2a_2
XTAP_TAPCELL_ROW_45_580 VGND VPWR sky130_fd_sc_hd__tapvpwrvgnd_1
XFILLER_62_393 VGND VGND VPWR VPWR sky130_fd_sc_hd__decap_3
XFILLER_62_371 VGND VGND VPWR VPWR sky130_fd_sc_hd__decap_3
X_3996_ _3982_/S _6133_/A _3995_/X VGND VGND VPWR VPWR _3996_/X sky130_fd_sc_hd__o21a_2
X_5735_ _5968_/A _5752_/B _5734_/X VGND VGND VPWR VPWR _5735_/X sky130_fd_sc_hd__o21a_2
X_5666_ _5859_/A _4384_/B _5665_/Y VGND VGND VPWR VPWR _5666_/Y sky130_fd_sc_hd__a21oi_2
X_4617_ _4443_/A _4443_/B _4783_/A VGND VGND VPWR VPWR _4621_/C sky130_fd_sc_hd__a21o_2
X_5597_ _6332_/A VGND VGND VPWR VPWR _5599_/B sky130_fd_sc_hd__inv_2
X_4548_ _4627_/A _4455_/B _4627_/B _4546_/X _4547_/X VGND VGND VPWR VPWR _4549_/B
+ sky130_fd_sc_hd__a32o_2
X_4479_ _4479_/A _4479_/B _4478_/X VGND VGND VPWR VPWR _4480_/A sky130_fd_sc_hd__or3b_2
X_6218_ _6458_/A1 _6216_/Y _6161_/Y VGND VGND VPWR VPWR _6218_/X sky130_fd_sc_hd__o21a_2
X_6149_ _6148_/A _6148_/B _3965_/A VGND VGND VPWR VPWR _6155_/B sky130_fd_sc_hd__a21o_2
XFILLER_57_143 VGND VGND VPWR VPWR sky130_fd_sc_hd__fill_1
XFILLER_45_305 VGND VGND VPWR VPWR sky130_fd_sc_hd__decap_3
XPHY_EDGE_ROW_79_Right_79 VGND VGND VPWR VPWR sky130_fd_sc_hd__decap_3
XFILLER_57_165 VGND VGND VPWR VPWR sky130_fd_sc_hd__decap_3
XTAP_TAPCELL_ROW_71_815 VGND VPWR sky130_fd_sc_hd__tapvpwrvgnd_1
XTAP_TAPCELL_ROW_0_172 VGND VPWR sky130_fd_sc_hd__tapvpwrvgnd_1
XFILLER_53_371 VGND VGND VPWR VPWR sky130_fd_sc_hd__decap_3
XFILLER_53_393 VGND VGND VPWR VPWR sky130_fd_sc_hd__decap_3
XTAP_TAPCELL_ROW_0_183 VGND VPWR sky130_fd_sc_hd__tapvpwrvgnd_1
XTAP_TAPCELL_ROW_8_250 VGND VPWR sky130_fd_sc_hd__tapvpwrvgnd_1
XFILLER_48_165 VGND VGND VPWR VPWR sky130_fd_sc_hd__decap_3
XFILLER_36_338 VGND VGND VPWR VPWR sky130_fd_sc_hd__fill_1
XFILLER_51_319 VGND VGND VPWR VPWR sky130_fd_sc_hd__decap_3
XFILLER_44_360 VGND VGND VPWR VPWR sky130_fd_sc_hd__decap_3
XFILLER_44_371 VGND VGND VPWR VPWR sky130_fd_sc_hd__decap_3
X_3850_ _3847_/X _3849_/X wire497/A VGND VGND VPWR VPWR _3850_/X sky130_fd_sc_hd__a21o_2
X_3781_ _3299_/X _3309_/X _3780_/Y VGND VGND VPWR VPWR _3782_/B sky130_fd_sc_hd__o21bai_2
XTAP_TAPCELL_ROW_42_561 VGND VPWR sky130_fd_sc_hd__tapvpwrvgnd_1
X_5520_ _5669_/B2 _5500_/Y _5505_/Y _5396_/A _5519_/X VGND VGND VPWR VPWR _5981_/D
+ sky130_fd_sc_hd__a221o_2
XFILLER_74_3 VGND VGND VPWR VPWR sky130_fd_sc_hd__decap_3
X_5451_ _5609_/A _5449_/X _5450_/X _5967_/B1 VGND VGND VPWR VPWR _5451_/X sky130_fd_sc_hd__a22o_2
X_5382_ _5509_/B _5378_/X _5381_/X _5966_/A _5859_/A VGND VGND VPWR VPWR _5382_/X
+ sky130_fd_sc_hd__a221o_2
X_4402_ _4743_/A _5534_/B _4482_/B VGND VGND VPWR VPWR _4402_/Y sky130_fd_sc_hd__o21bai_2
X_4333_ _5014_/A _4330_/X _4331_/X _4973_/A VGND VGND VPWR VPWR _4333_/Y sky130_fd_sc_hd__o211ai_2
X_4264_ _4262_/X _4263_/Y _4178_/D VGND VGND VPWR VPWR _4361_/A sky130_fd_sc_hd__a21o_2
X_6003_ _6003_/A _6003_/B _6003_/C _6003_/D VGND VGND VPWR VPWR _6004_/D sky130_fd_sc_hd__or4_4
XFILLER_39_121 VGND VGND VPWR VPWR sky130_fd_sc_hd__decap_3
XFILLER_39_143 VGND VGND VPWR VPWR sky130_fd_sc_hd__fill_2
X_4195_ _6427_/A _4188_/X _4194_/X _5739_/B VGND VGND VPWR VPWR _4195_/X sky130_fd_sc_hd__o2bb2a_2
XFILLER_82_411 VGND VGND VPWR VPWR sky130_fd_sc_hd__fill_1
XFILLER_27_349 VGND VGND VPWR VPWR sky130_fd_sc_hd__decap_3
XFILLER_54_113 VGND VGND VPWR VPWR sky130_fd_sc_hd__decap_3
XFILLER_54_157 VGND VGND VPWR VPWR sky130_fd_sc_hd__decap_3
XFILLER_35_393 VGND VGND VPWR VPWR sky130_fd_sc_hd__decap_3
XFILLER_50_330 VGND VGND VPWR VPWR sky130_fd_sc_hd__decap_3
XFILLER_50_363 VGND VGND VPWR VPWR sky130_fd_sc_hd__fill_1
XFILLER_50_374 VGND VGND VPWR VPWR sky130_fd_sc_hd__decap_3
X_5718_ _5752_/A VGND VGND VPWR VPWR _5734_/S sky130_fd_sc_hd__inv_2
X_3979_ _3597_/X _3978_/X _4140_/A VGND VGND VPWR VPWR _3979_/X sky130_fd_sc_hd__mux2_2
X_5649_ _5674_/B _5649_/B VGND VGND VPWR VPWR _5650_/B sky130_fd_sc_hd__nand2_2
XTAP_TAPCELL_ROW_5_220 VGND VPWR sky130_fd_sc_hd__tapvpwrvgnd_1
XTAP_TAPCELL_ROW_48_609 VGND VPWR sky130_fd_sc_hd__tapvpwrvgnd_1
XFILLER_45_113 VGND VGND VPWR VPWR sky130_fd_sc_hd__decap_3
XFILLER_45_157 VGND VGND VPWR VPWR sky130_fd_sc_hd__fill_1
XFILLER_26_371 VGND VGND VPWR VPWR sky130_fd_sc_hd__fill_2
XTAP_TAPCELL_ROW_56_686 VGND VPWR sky130_fd_sc_hd__tapvpwrvgnd_1
XFILLER_60_116 VGND VGND VPWR VPWR sky130_fd_sc_hd__decap_3
XFILLER_41_363 VGND VGND VPWR VPWR sky130_fd_sc_hd__decap_3
XTAP_TAPCELL_ROW_11_277 VGND VPWR sky130_fd_sc_hd__tapvpwrvgnd_1
Xinput7 operand_a[10] VGND VGND VPWR VPWR input7/X sky130_fd_sc_hd__clkdlybuf4s25_1
XFILLER_76_282 VGND VGND VPWR VPWR sky130_fd_sc_hd__decap_3
XFILLER_64_411 VGND VGND VPWR VPWR sky130_fd_sc_hd__fill_1
XFILLER_51_116 VGND VGND VPWR VPWR sky130_fd_sc_hd__decap_3
X_4951_ _3896_/A _3470_/B _4929_/X _4937_/X _4950_/Y VGND VGND VPWR VPWR _4951_/X
+ sky130_fd_sc_hd__a311o_2
XFILLER_17_393 VGND VGND VPWR VPWR sky130_fd_sc_hd__decap_3
X_4882_ _3896_/A _3427_/B _5618_/A _4937_/A VGND VGND VPWR VPWR _4882_/X sky130_fd_sc_hd__a31o_2
X_3902_ _4636_/S _4598_/A _3898_/Y VGND VGND VPWR VPWR _3902_/Y sky130_fd_sc_hd__a21oi_2
XFILLER_32_363 VGND VGND VPWR VPWR sky130_fd_sc_hd__fill_1
X_3833_ _4010_/C _3394_/X _3395_/X _3299_/X VGND VGND VPWR VPWR _3834_/B sky130_fd_sc_hd__a22o_2
X_3764_ _3335_/X _3737_/X _3745_/Y _3563_/X _3763_/X VGND VGND VPWR VPWR _3764_/X
+ sky130_fd_sc_hd__a221o_2
X_6483_ _5975_/A _6490_/S _6423_/X _6478_/X _6482_/Y VGND VGND VPWR VPWR _6488_/B
+ sky130_fd_sc_hd__a311o_2
X_5503_ _5476_/S _5503_/A2 _5502_/X VGND VGND VPWR VPWR _5503_/X sky130_fd_sc_hd__o21a_2
X_3695_ _4429_/A _6457_/A1 _6460_/A0 _6460_/A1 _3695_/S0 _3948_/S1 VGND VGND VPWR
+ VPWR _3695_/X sky130_fd_sc_hd__mux4_2
X_5434_ _5434_/A _5434_/B _5434_/C VGND VGND VPWR VPWR _5434_/X sky130_fd_sc_hd__and3_2
X_5365_ _5418_/C _5425_/A _5364_/X VGND VGND VPWR VPWR _5370_/A sky130_fd_sc_hd__o21ai_2
X_5296_ _5273_/Y _5904_/A3 _5299_/A _4883_/X _5295_/X VGND VGND VPWR VPWR _5296_/X
+ sky130_fd_sc_hd__a221o_2
X_4316_ _6173_/A _4315_/Y _6199_/A VGND VGND VPWR VPWR _4316_/X sky130_fd_sc_hd__o21a_2
XFILLER_59_205 VGND VGND VPWR VPWR sky130_fd_sc_hd__decap_3
X_4247_ _6199_/A _4355_/B VGND VGND VPWR VPWR _4430_/A sky130_fd_sc_hd__xor2_2
X_4178_ _4265_/A _4708_/A _4360_/D _4178_/D VGND VGND VPWR VPWR _4217_/A sky130_fd_sc_hd__or4_4
XTAP_TAPCELL_ROW_2_201 VGND VPWR sky130_fd_sc_hd__tapvpwrvgnd_1
XFILLER_74_208 VGND VGND VPWR VPWR sky130_fd_sc_hd__decap_3
XFILLER_27_113 VGND VGND VPWR VPWR sky130_fd_sc_hd__fill_2
XFILLER_55_411 VGND VGND VPWR VPWR sky130_fd_sc_hd__decap_3
XFILLER_55_433 VGND VGND VPWR VPWR sky130_fd_sc_hd__decap_3
XFILLER_67_271 VGND VGND VPWR VPWR sky130_fd_sc_hd__decap_3
XFILLER_55_477 VGND VGND VPWR VPWR sky130_fd_sc_hd__decap_3
XTAP_TAPCELL_ROW_81_910 VGND VPWR sky130_fd_sc_hd__tapvpwrvgnd_1
XTAP_TAPCELL_ROW_53_656 VGND VPWR sky130_fd_sc_hd__tapvpwrvgnd_1
XFILLER_23_385 VGND VGND VPWR VPWR sky130_fd_sc_hd__decap_3
XFILLER_4_3 VGND VGND VPWR VPWR sky130_fd_sc_hd__decap_3
Xfanout560 _6460_/A0 VGND VGND VPWR VPWR _4679_/A sky130_fd_sc_hd__clkdlybuf4s25_1
XFILLER_46_400 VGND VGND VPWR VPWR sky130_fd_sc_hd__fill_2
Xfanout571 input21/X VGND VGND VPWR VPWR _6461_/A2 sky130_fd_sc_hd__clkdlybuf4s25_1
Xfanout593 _3412_/A VGND VGND VPWR VPWR _3357_/B sky130_fd_sc_hd__clkdlybuf4s25_1
XFILLER_46_411 VGND VGND VPWR VPWR sky130_fd_sc_hd__decap_3
XFILLER_58_271 VGND VGND VPWR VPWR sky130_fd_sc_hd__decap_3
XFILLER_18_179 VGND VGND VPWR VPWR sky130_fd_sc_hd__decap_3
XFILLER_73_296 VGND VGND VPWR VPWR sky130_fd_sc_hd__decap_3
XFILLER_33_149 VGND VGND VPWR VPWR sky130_fd_sc_hd__decap_3
XTAP_TAPCELL_ROW_16_325 VGND VPWR sky130_fd_sc_hd__tapvpwrvgnd_1
XFILLER_14_363 VGND VGND VPWR VPWR sky130_fd_sc_hd__fill_1
XFILLER_14_396 VGND VGND VPWR VPWR sky130_fd_sc_hd__decap_3
XTAP_TAPCELL_ROW_24_391 VGND VPWR sky130_fd_sc_hd__tapvpwrvgnd_1
X_3480_ _3480_/A _3480_/B _3480_/C VGND VGND VPWR VPWR _3480_/X sky130_fd_sc_hd__or3_2
X_5150_ _4457_/Y _4841_/Y _5149_/X _5263_/A _5061_/A VGND VGND VPWR VPWR _5150_/X
+ sky130_fd_sc_hd__o221a_2
X_5081_ _5078_/X _5079_/Y _5081_/S VGND VGND VPWR VPWR _5081_/X sky130_fd_sc_hd__mux2_2
X_4101_ _3759_/X _4100_/X _4462_/S VGND VGND VPWR VPWR _4102_/B sky130_fd_sc_hd__mux2_2
X_4032_ _4042_/A _6158_/A _4076_/A _3912_/B _4076_/B VGND VGND VPWR VPWR _4032_/X
+ sky130_fd_sc_hd__o2111a_2
XFILLER_64_230 VGND VGND VPWR VPWR sky130_fd_sc_hd__fill_1
XFILLER_52_403 VGND VGND VPWR VPWR sky130_fd_sc_hd__decap_3
X_5983_ _5983_/A _5983_/B _5983_/C _5982_/Y VGND VGND VPWR VPWR _6003_/C sky130_fd_sc_hd__or4b_4
XFILLER_24_138 VGND VGND VPWR VPWR sky130_fd_sc_hd__fill_2
X_4934_ _4758_/X _4933_/X _5662_/S VGND VGND VPWR VPWR _4934_/X sky130_fd_sc_hd__mux2_2
XANTENNA_12 _4009_/X VGND VGND VPWR VPWR sky130_fd_sc_hd__diode_2
XANTENNA_23 _4874_/B VGND VGND VPWR VPWR sky130_fd_sc_hd__diode_2
XFILLER_32_160 VGND VGND VPWR VPWR sky130_fd_sc_hd__decap_3
X_4865_ _4817_/A _4864_/X _4916_/B VGND VGND VPWR VPWR _4901_/A sky130_fd_sc_hd__a21bo_2
XTAP_TAPCELL_ROW_50_626 VGND VPWR sky130_fd_sc_hd__tapvpwrvgnd_1
XANTENNA_34 _3524_/X VGND VGND VPWR VPWR sky130_fd_sc_hd__diode_2
X_4796_ _5906_/A1 _4922_/A _4795_/X VGND VGND VPWR VPWR _4796_/X sky130_fd_sc_hd__a21o_2
X_3816_ _3816_/A _4077_/B _4077_/C VGND VGND VPWR VPWR _4086_/B sky130_fd_sc_hd__and3_2
X_3747_ _6453_/A _5137_/B VGND VGND VPWR VPWR _3747_/X sky130_fd_sc_hd__or2_2
XFILLER_21_38 VGND VGND VPWR VPWR sky130_fd_sc_hd__fill_2
X_6466_ _6464_/X _6465_/X _6469_/S VGND VGND VPWR VPWR _6466_/X sky130_fd_sc_hd__mux2_2
X_3678_ _3685_/A _3685_/B _3679_/B VGND VGND VPWR VPWR _3818_/B sky130_fd_sc_hd__a21oi_2
X_6397_ _6368_/X _6378_/X _6396_/Y _6355_/D VGND VGND VPWR VPWR _6397_/X sky130_fd_sc_hd__o31a_2
Xoutput141 _5993_/A VGND VGND VPWR VPWR result[13] sky130_fd_sc_hd__clkdlybuf4s25_1
Xoutput152 _5994_/C VGND VGND VPWR VPWR result[23] sky130_fd_sc_hd__clkdlybuf4s25_1
X_5417_ _5415_/Y _5416_/X _6363_/A _5418_/B VGND VGND VPWR VPWR _5417_/X sky130_fd_sc_hd__o211a_2
Xoutput163 _5999_/C VGND VGND VPWR VPWR result[33] sky130_fd_sc_hd__clkdlybuf4s25_1
Xoutput174 _5984_/C VGND VGND VPWR VPWR result[43] sky130_fd_sc_hd__clkdlybuf4s25_1
Xoutput185 _6003_/A VGND VGND VPWR VPWR result[53] sky130_fd_sc_hd__clkdlybuf4s25_1
X_5348_ _5348_/A _5425_/A VGND VGND VPWR VPWR _5348_/X sky130_fd_sc_hd__or2_2
Xoutput196 _6501_/X VGND VGND VPWR VPWR result[63] sky130_fd_sc_hd__clkdlybuf4s25_1
XFILLER_47_208 VGND VGND VPWR VPWR sky130_fd_sc_hd__decap_3
X_5279_ _5118_/X _5423_/A _5278_/Y VGND VGND VPWR VPWR _5280_/B sky130_fd_sc_hd__o21a_2
XTAP_TAPCELL_ROW_58_704 VGND VPWR sky130_fd_sc_hd__tapvpwrvgnd_1
XTAP_TAPCELL_ROW_66_770 VGND VPWR sky130_fd_sc_hd__tapvpwrvgnd_1
XFILLER_70_200 VGND VGND VPWR VPWR sky130_fd_sc_hd__decap_3
XFILLER_15_127 VGND VGND VPWR VPWR sky130_fd_sc_hd__fill_2
XFILLER_43_447 VGND VGND VPWR VPWR sky130_fd_sc_hd__fill_1
XFILLER_70_233 VGND VGND VPWR VPWR sky130_fd_sc_hd__decap_3
XFILLER_70_277 VGND VGND VPWR VPWR sky130_fd_sc_hd__fill_1
XFILLER_62_45 VGND VGND VPWR VPWR sky130_fd_sc_hd__fill_1
XFILLER_11_322 VGND VGND VPWR VPWR sky130_fd_sc_hd__decap_3
XFILLER_23_160 VGND VGND VPWR VPWR sky130_fd_sc_hd__decap_3
Xwire257 _3418_/X VGND VGND VPWR VPWR _4611_/A sky130_fd_sc_hd__buf_2
XTAP_TAPCELL_ROW_21_372 VGND VPWR sky130_fd_sc_hd__tapvpwrvgnd_1
XFILLER_7_337 VGND VGND VPWR VPWR sky130_fd_sc_hd__decap_3
XFILLER_7_326 VGND VGND VPWR VPWR sky130_fd_sc_hd__decap_3
XFILLER_11_82 VGND VGND VPWR VPWR sky130_fd_sc_hd__fill_1
XFILLER_11_93 VGND VGND VPWR VPWR sky130_fd_sc_hd__decap_3
Xfanout390 _4189_/S VGND VGND VPWR VPWR _4504_/S sky130_fd_sc_hd__clkdlybuf4s25_1
XFILLER_46_241 VGND VGND VPWR VPWR sky130_fd_sc_hd__decap_3
XFILLER_61_222 VGND VGND VPWR VPWR sky130_fd_sc_hd__fill_2
XFILLER_14_193 VGND VGND VPWR VPWR sky130_fd_sc_hd__decap_3
X_4650_ _4646_/X _4649_/Y _4926_/A VGND VGND VPWR VPWR _4650_/X sky130_fd_sc_hd__a21o_2
Xinput10 operand_a[13] VGND VGND VPWR VPWR input10/X sky130_fd_sc_hd__clkdlybuf4s25_1
Xinput21 operand_a[23] VGND VGND VPWR VPWR input21/X sky130_fd_sc_hd__clkdlybuf4s25_1
X_3601_ _6090_/A _3640_/A _3598_/X _3599_/X _3600_/X VGND VGND VPWR VPWR _3601_/X
+ sky130_fd_sc_hd__a221o_2
X_6320_ _6339_/A _6324_/S _6322_/A VGND VGND VPWR VPWR _6320_/Y sky130_fd_sc_hd__o21ai_2
Xinput54 operand_a[53] VGND VGND VPWR VPWR input54/X sky130_fd_sc_hd__clkdlybuf4s25_1
Xinput43 operand_a[43] VGND VGND VPWR VPWR input43/X sky130_fd_sc_hd__clkdlybuf4s25_1
Xinput32 operand_a[33] VGND VGND VPWR VPWR input32/X sky130_fd_sc_hd__clkdlybuf4s25_1
X_4581_ _6232_/A _6192_/A _4536_/B _4582_/S VGND VGND VPWR VPWR _4581_/Y sky130_fd_sc_hd__a211oi_2
Xinput98 operand_b[35] VGND VGND VPWR VPWR _6077_/B sky130_fd_sc_hd__clkdlybuf4s25_1
Xinput87 operand_b[25] VGND VGND VPWR VPWR _6221_/A sky130_fd_sc_hd__clkdlybuf4s25_1
Xinput76 operand_b[15] VGND VGND VPWR VPWR input76/X sky130_fd_sc_hd__clkdlybuf4s25_1
Xinput65 operand_a[63] VGND VGND VPWR VPWR input65/X sky130_fd_sc_hd__clkdlybuf4s25_1
X_3532_ _3281_/X _3283_/X _3652_/S VGND VGND VPWR VPWR _3532_/X sky130_fd_sc_hd__mux2_2
X_6251_ _6250_/B _6251_/B VGND VGND VPWR VPWR _6252_/B sky130_fd_sc_hd__and2b_2
X_3463_ _3761_/S _6109_/B VGND VGND VPWR VPWR _3489_/A sky130_fd_sc_hd__xor2_2
X_6182_ _4394_/A _6180_/Y _6181_/X VGND VGND VPWR VPWR _6182_/X sky130_fd_sc_hd__a21o_2
X_5202_ _5214_/A _5202_/B VGND VGND VPWR VPWR _5262_/A sky130_fd_sc_hd__xor2_2
X_5133_ _4970_/X _5132_/X _5442_/S VGND VGND VPWR VPWR _5133_/X sky130_fd_sc_hd__mux2_2
X_3394_ _3451_/S _3394_/B VGND VGND VPWR VPWR _3394_/X sky130_fd_sc_hd__and2b_2
X_5064_ _5628_/A _5037_/Y _5063_/X VGND VGND VPWR VPWR _5999_/D sky130_fd_sc_hd__o21ai_2
X_4015_ _3977_/X _4014_/X _4460_/S VGND VGND VPWR VPWR _4015_/X sky130_fd_sc_hd__mux2_2
XFILLER_37_274 VGND VGND VPWR VPWR sky130_fd_sc_hd__decap_3
XFILLER_52_200 VGND VGND VPWR VPWR sky130_fd_sc_hd__decap_3
XFILLER_52_244 VGND VGND VPWR VPWR sky130_fd_sc_hd__decap_3
XFILLER_12_108 VGND VGND VPWR VPWR sky130_fd_sc_hd__decap_3
X_5966_ _5966_/A _5966_/B VGND VGND VPWR VPWR _5966_/Y sky130_fd_sc_hd__nand2_2
X_5897_ _5923_/A _6419_/A VGND VGND VPWR VPWR _5908_/B sky130_fd_sc_hd__nand2_2
X_4917_ _4913_/Y _4914_/X _4915_/X _4916_/X VGND VGND VPWR VPWR _4917_/X sky130_fd_sc_hd__o211a_2
XTAP_TAPCELL_ROW_35_497 VGND VPWR sky130_fd_sc_hd__tapvpwrvgnd_1
X_4848_ _4848_/A _4848_/B VGND VGND VPWR VPWR _4848_/Y sky130_fd_sc_hd__nand2_2
XFILLER_20_185 VGND VGND VPWR VPWR sky130_fd_sc_hd__fill_2
X_4779_ _4694_/A _4702_/Y _4694_/B VGND VGND VPWR VPWR _4779_/Y sky130_fd_sc_hd__a21boi_2
X_6449_ _6449_/A0 _6449_/A1 _6449_/A2 _6449_/A3 _6449_/S0 _6468_/S1 VGND VGND VPWR
+ VPWR _6449_/X sky130_fd_sc_hd__mux4_2
XFILLER_75_347 VGND VGND VPWR VPWR sky130_fd_sc_hd__fill_2
XFILLER_43_211 VGND VGND VPWR VPWR sky130_fd_sc_hd__decap_3
XFILLER_43_244 VGND VGND VPWR VPWR sky130_fd_sc_hd__decap_3
XFILLER_43_288 VGND VGND VPWR VPWR sky130_fd_sc_hd__decap_3
XFILLER_7_123 VGND VGND VPWR VPWR sky130_fd_sc_hd__fill_1
XFILLER_3_373 VGND VGND VPWR VPWR sky130_fd_sc_hd__fill_2
XFILLER_21_6 VGND VGND VPWR VPWR sky130_fd_sc_hd__fill_1
XFILLER_66_336 VGND VGND VPWR VPWR sky130_fd_sc_hd__fill_2
XFILLER_66_358 VGND VGND VPWR VPWR sky130_fd_sc_hd__decap_3
XFILLER_34_200 VGND VGND VPWR VPWR sky130_fd_sc_hd__decap_3
XTAP_TAPCELL_ROW_77_876 VGND VPWR sky130_fd_sc_hd__tapvpwrvgnd_1
XFILLER_19_285 VGND VGND VPWR VPWR sky130_fd_sc_hd__fill_1
X_5820_ _5886_/A _5818_/Y _5819_/Y VGND VGND VPWR VPWR _5821_/B sky130_fd_sc_hd__o21a_2
X_5751_ _5752_/A _5752_/B VGND VGND VPWR VPWR _5751_/X sky130_fd_sc_hd__or2_2
XTAP_TAPCELL_ROW_60_721 VGND VPWR sky130_fd_sc_hd__tapvpwrvgnd_1
X_4702_ _4648_/X _4659_/B _4657_/X VGND VGND VPWR VPWR _4702_/Y sky130_fd_sc_hd__a21oi_2
X_5682_ _5682_/A VGND VGND VPWR VPWR _5725_/B sky130_fd_sc_hd__inv_2
XTAP_TAPCELL_ROW_32_467 VGND VPWR sky130_fd_sc_hd__tapvpwrvgnd_1
X_4633_ _4279_/B _4632_/X _6108_/A VGND VGND VPWR VPWR _4634_/B sky130_fd_sc_hd__mux2_2
XFILLER_8_83 VGND VGND VPWR VPWR sky130_fd_sc_hd__fill_1
Xmax_cap310 _6426_/A VGND VGND VPWR VPWR _6442_/B sky130_fd_sc_hd__buf_2
X_4564_ _5180_/B VGND VGND VPWR VPWR _5058_/B sky130_fd_sc_hd__clkbuf_1
X_6303_ _5206_/Y _6383_/B _6302_/X VGND VGND VPWR VPWR _6355_/B sky130_fd_sc_hd__a21bo_2
Xmax_cap332 _3896_/A VGND VGND VPWR VPWR _3985_/A sky130_fd_sc_hd__clkbuf_2
Xmax_cap321 _6178_/B VGND VGND VPWR VPWR _4449_/C sky130_fd_sc_hd__buf_2
X_3515_ _3515_/A _3515_/B _3420_/A VGND VGND VPWR VPWR _3600_/C sky130_fd_sc_hd__nor3b_4
X_6234_ _6233_/B _6191_/X _6232_/C _6232_/A VGND VGND VPWR VPWR _6234_/X sky130_fd_sc_hd__a31o_2
X_4495_ _4513_/A _4455_/B _4494_/X VGND VGND VPWR VPWR _4496_/B sky130_fd_sc_hd__o21a_2
X_3446_ _3442_/X _3445_/X _3633_/A VGND VGND VPWR VPWR _3446_/X sky130_fd_sc_hd__mux2_2
X_6165_ _6163_/X _6164_/Y _6167_/A VGND VGND VPWR VPWR _6166_/B sky130_fd_sc_hd__mux2_2
X_3377_ _3327_/X _3329_/X _3653_/S VGND VGND VPWR VPWR _3377_/X sky130_fd_sc_hd__mux2_2
X_6096_ _3760_/A _6095_/X _3354_/S VGND VGND VPWR VPWR _6096_/Y sky130_fd_sc_hd__a21oi_2
Xload_slew582 _3241_/A VGND VGND VPWR VPWR _5968_/A sky130_fd_sc_hd__buf_4
X_5116_ _5116_/A _5116_/B VGND VGND VPWR VPWR _5117_/C sky130_fd_sc_hd__nand2_2
X_5047_ _4016_/X _4378_/X _4721_/X _5046_/X _5175_/S _5284_/S VGND VGND VPWR VPWR
+ _5047_/X sky130_fd_sc_hd__mux4_2
XFILLER_57_369 VGND VGND VPWR VPWR sky130_fd_sc_hd__decap_3
XFILLER_57_358 VGND VGND VPWR VPWR sky130_fd_sc_hd__fill_2
XFILLER_65_380 VGND VGND VPWR VPWR sky130_fd_sc_hd__decap_3
XFILLER_13_417 VGND VGND VPWR VPWR sky130_fd_sc_hd__fill_1
XFILLER_40_203 VGND VGND VPWR VPWR sky130_fd_sc_hd__decap_3
X_5949_ _4725_/Y _5740_/Y _5948_/X _5177_/A VGND VGND VPWR VPWR _5949_/X sky130_fd_sc_hd__a22o_2
XFILLER_0_332 VGND VGND VPWR VPWR sky130_fd_sc_hd__decap_3
XFILLER_48_336 VGND VGND VPWR VPWR sky130_fd_sc_hd__decap_3
XFILLER_63_306 VGND VGND VPWR VPWR sky130_fd_sc_hd__decap_3
XFILLER_56_391 VGND VGND VPWR VPWR sky130_fd_sc_hd__decap_3
XTAP_TAPCELL_ROW_74_846 VGND VPWR sky130_fd_sc_hd__tapvpwrvgnd_1
XFILLER_75_199 VGND VGND VPWR VPWR sky130_fd_sc_hd__decap_3
XFILLER_71_361 VGND VGND VPWR VPWR sky130_fd_sc_hd__decap_3
XFILLER_31_214 VGND VGND VPWR VPWR sky130_fd_sc_hd__decap_3
XFILLER_31_225 VGND VGND VPWR VPWR sky130_fd_sc_hd__decap_3
XFILLER_31_269 VGND VGND VPWR VPWR sky130_fd_sc_hd__fill_2
X_3300_ _6090_/A VGND VGND VPWR VPWR _3301_/A sky130_fd_sc_hd__inv_2
X_4280_ _6108_/A _3932_/Y _4279_/Y _4502_/S VGND VGND VPWR VPWR _4280_/X sky130_fd_sc_hd__o211a_2
X_3231_ _3495_/A VGND VGND VPWR VPWR _3572_/S sky130_fd_sc_hd__clkbuf_2
XFILLER_39_325 VGND VGND VPWR VPWR sky130_fd_sc_hd__decap_3
XTAP_TAPCELL_ROW_37_515 VGND VPWR sky130_fd_sc_hd__tapvpwrvgnd_1
XFILLER_81_169 VGND VGND VPWR VPWR sky130_fd_sc_hd__fill_2
XFILLER_22_203 VGND VGND VPWR VPWR sky130_fd_sc_hd__decap_3
X_5803_ _5220_/X _5739_/Y _5802_/X _4840_/Y VGND VGND VPWR VPWR _5803_/X sky130_fd_sc_hd__a22o_2
XTAP_TAPCELL_ROW_45_581 VGND VPWR sky130_fd_sc_hd__tapvpwrvgnd_1
XFILLER_22_247 VGND VGND VPWR VPWR sky130_fd_sc_hd__fill_2
X_3995_ _3965_/A _6151_/B _6152_/A _3982_/S VGND VGND VPWR VPWR _3995_/X sky130_fd_sc_hd__a22o_2
XFILLER_13_17 VGND VGND VPWR VPWR sky130_fd_sc_hd__fill_1
X_5734_ wire263/X _5938_/A1 _5734_/S VGND VGND VPWR VPWR _5734_/X sky130_fd_sc_hd__mux2_2
X_5665_ _3627_/X _5485_/B _5664_/X VGND VGND VPWR VPWR _5665_/Y sky130_fd_sc_hd__a21oi_2
X_4616_ _4627_/C _4616_/B _6194_/A VGND VGND VPWR VPWR _4783_/A sky130_fd_sc_hd__or3_2
X_5596_ _5951_/A1 _5574_/B _5574_/X _5669_/B2 _5595_/X VGND VGND VPWR VPWR _6000_/D
+ sky130_fd_sc_hd__a221o_2
X_4547_ _6224_/A _4513_/A _6189_/B _4546_/A VGND VGND VPWR VPWR _4547_/X sky130_fd_sc_hd__a22o_2
X_4478_ _4611_/A _4544_/A _4482_/B _4478_/D VGND VGND VPWR VPWR _4478_/X sky130_fd_sc_hd__or4_2
X_6217_ _6217_/A _6179_/X VGND VGND VPWR VPWR _6217_/X sky130_fd_sc_hd__or2b_2
X_3429_ _4200_/A _4199_/A _3554_/B VGND VGND VPWR VPWR _3429_/X sky130_fd_sc_hd__mux2_2
XFILLER_38_36 VGND VGND VPWR VPWR sky130_fd_sc_hd__fill_1
X_6148_ _6148_/A _6148_/B VGND VGND VPWR VPWR _6155_/C sky130_fd_sc_hd__or2_2
XFILLER_57_122 VGND VGND VPWR VPWR sky130_fd_sc_hd__decap_3
XFILLER_45_317 VGND VGND VPWR VPWR sky130_fd_sc_hd__decap_3
X_6079_ _6080_/A _6298_/C VGND VGND VPWR VPWR _6264_/B sky130_fd_sc_hd__or2_2
XFILLER_38_391 VGND VGND VPWR VPWR sky130_fd_sc_hd__decap_3
XFILLER_57_188 VGND VGND VPWR VPWR sky130_fd_sc_hd__decap_3
XFILLER_54_57 VGND VGND VPWR VPWR sky130_fd_sc_hd__fill_1
XTAP_TAPCELL_ROW_71_816 VGND VPWR sky130_fd_sc_hd__tapvpwrvgnd_1
XFILLER_60_309 VGND VGND VPWR VPWR sky130_fd_sc_hd__decap_3
XFILLER_13_225 VGND VGND VPWR VPWR sky130_fd_sc_hd__fill_2
XFILLER_53_383 VGND VGND VPWR VPWR sky130_fd_sc_hd__decap_3
XTAP_TAPCELL_ROW_0_173 VGND VPWR sky130_fd_sc_hd__tapvpwrvgnd_1
XFILLER_13_269 VGND VGND VPWR VPWR sky130_fd_sc_hd__fill_1
XTAP_TAPCELL_ROW_8_251 VGND VPWR sky130_fd_sc_hd__tapvpwrvgnd_1
XFILLER_48_133 VGND VGND VPWR VPWR sky130_fd_sc_hd__decap_3
XFILLER_48_144 VGND VGND VPWR VPWR sky130_fd_sc_hd__decap_3
XFILLER_36_317 VGND VGND VPWR VPWR sky130_fd_sc_hd__decap_3
XFILLER_29_391 VGND VGND VPWR VPWR sky130_fd_sc_hd__fill_1
XFILLER_44_383 VGND VGND VPWR VPWR sky130_fd_sc_hd__fill_1
XFILLER_71_191 VGND VGND VPWR VPWR sky130_fd_sc_hd__decap_3
X_3780_ _3780_/A _3780_/B VGND VGND VPWR VPWR _3780_/Y sky130_fd_sc_hd__nor2_2
XFILLER_12_280 VGND VGND VPWR VPWR sky130_fd_sc_hd__decap_3
X_5450_ _3232_/X _3594_/B _5375_/X VGND VGND VPWR VPWR _5450_/X sky130_fd_sc_hd__a21o_2
X_4401_ _4743_/A _5534_/B _4482_/B VGND VGND VPWR VPWR _4401_/X sky130_fd_sc_hd__or3b_2
XFILLER_8_284 VGND VGND VPWR VPWR sky130_fd_sc_hd__decap_3
X_5381_ _4759_/X _5380_/X _5381_/S VGND VGND VPWR VPWR _5381_/X sky130_fd_sc_hd__mux2_2
X_4332_ _4332_/A VGND VGND VPWR VPWR _5136_/A sky130_fd_sc_hd__clkbuf_1
X_4263_ _4263_/A _4263_/B _4263_/C VGND VGND VPWR VPWR _4263_/Y sky130_fd_sc_hd__nand3_2
XFILLER_5_84 VGND VGND VPWR VPWR sky130_fd_sc_hd__decap_3
X_6002_ _6002_/A _6002_/B _6002_/C VGND VGND VPWR VPWR _6003_/D sky130_fd_sc_hd__or3_2
X_4194_ _4757_/S _3427_/Y _4193_/Y VGND VGND VPWR VPWR _4194_/X sky130_fd_sc_hd__o21a_2
XFILLER_27_317 VGND VGND VPWR VPWR sky130_fd_sc_hd__fill_1
XFILLER_39_166 VGND VGND VPWR VPWR sky130_fd_sc_hd__fill_2
XFILLER_39_177 VGND VGND VPWR VPWR sky130_fd_sc_hd__decap_3
XFILLER_67_464 VGND VGND VPWR VPWR sky130_fd_sc_hd__fill_2
XFILLER_54_125 VGND VGND VPWR VPWR sky130_fd_sc_hd__decap_3
XFILLER_42_309 VGND VGND VPWR VPWR sky130_fd_sc_hd__decap_3
XFILLER_54_147 VGND VGND VPWR VPWR sky130_fd_sc_hd__decap_3
XFILLER_50_342 VGND VGND VPWR VPWR sky130_fd_sc_hd__decap_3
X_3978_ _3758_/X _3791_/X _3930_/X _3977_/X _4460_/S _4139_/S VGND VGND VPWR VPWR
+ _3978_/X sky130_fd_sc_hd__mux4_2
XFILLER_50_386 VGND VGND VPWR VPWR sky130_fd_sc_hd__decap_3
X_5717_ _5711_/X _5713_/X _5716_/X _5697_/S VGND VGND VPWR VPWR _5723_/C sky130_fd_sc_hd__a31o_2
XFILLER_40_26 VGND VGND VPWR VPWR sky130_fd_sc_hd__fill_2
X_5648_ _5648_/A _5648_/B VGND VGND VPWR VPWR _5674_/B sky130_fd_sc_hd__or2_2
X_5579_ _5579_/A _5579_/B _5580_/B _5580_/C VGND VGND VPWR VPWR _5579_/X sky130_fd_sc_hd__and4_2
XTAP_TAPCELL_ROW_5_221 VGND VPWR sky130_fd_sc_hd__tapvpwrvgnd_1
XFILLER_77_228 VGND VGND VPWR VPWR sky130_fd_sc_hd__decap_3
XFILLER_77_217 VGND VGND VPWR VPWR sky130_fd_sc_hd__decap_3
XFILLER_45_125 VGND VGND VPWR VPWR sky130_fd_sc_hd__decap_3
XFILLER_45_169 VGND VGND VPWR VPWR sky130_fd_sc_hd__decap_3
XTAP_TAPCELL_ROW_56_687 VGND VPWR sky130_fd_sc_hd__tapvpwrvgnd_1
XFILLER_60_128 VGND VGND VPWR VPWR sky130_fd_sc_hd__decap_3
XFILLER_41_320 VGND VGND VPWR VPWR sky130_fd_sc_hd__decap_3
XFILLER_53_191 VGND VGND VPWR VPWR sky130_fd_sc_hd__decap_3
XTAP_TAPCELL_ROW_11_278 VGND VPWR sky130_fd_sc_hd__tapvpwrvgnd_1
XFILLER_49_420 VGND VGND VPWR VPWR sky130_fd_sc_hd__fill_1
XFILLER_39_90 VGND VGND VPWR VPWR sky130_fd_sc_hd__decap_3
Xinput8 operand_a[11] VGND VGND VPWR VPWR input8/X sky130_fd_sc_hd__clkdlybuf4s25_1
XFILLER_76_250 VGND VGND VPWR VPWR sky130_fd_sc_hd__fill_2
XFILLER_36_125 VGND VGND VPWR VPWR sky130_fd_sc_hd__decap_3
XFILLER_49_486 VGND VGND VPWR VPWR sky130_fd_sc_hd__fill_1
XFILLER_76_294 VGND VGND VPWR VPWR sky130_fd_sc_hd__decap_3
XFILLER_17_361 VGND VGND VPWR VPWR sky130_fd_sc_hd__decap_3
X_4950_ _5696_/A _4938_/X _4949_/X _5061_/A VGND VGND VPWR VPWR _4950_/Y sky130_fd_sc_hd__o211ai_2
X_4881_ _5242_/B _4876_/X _4880_/Y VGND VGND VPWR VPWR _4881_/Y sky130_fd_sc_hd__o21ai_2
X_3901_ _4140_/A _3901_/B VGND VGND VPWR VPWR _4598_/A sky130_fd_sc_hd__nand2_2
X_3832_ _4422_/A _3832_/B VGND VGND VPWR VPWR _4558_/A sky130_fd_sc_hd__nand2_2
X_5502_ _5460_/A _5458_/A _5503_/A2 _5476_/S VGND VGND VPWR VPWR _5502_/X sky130_fd_sc_hd__a22o_2
X_3763_ _3303_/Y _3747_/X _3751_/X _3762_/X VGND VGND VPWR VPWR _3763_/X sky130_fd_sc_hd__a31o_2
X_6482_ _6492_/B _6479_/X _6481_/X _5628_/A VGND VGND VPWR VPWR _6482_/Y sky130_fd_sc_hd__a31oi_2
X_3694_ _6486_/B _3694_/B VGND VGND VPWR VPWR _3723_/A sky130_fd_sc_hd__nor2_2
X_5433_ _5433_/A _5530_/B VGND VGND VPWR VPWR _5434_/C sky130_fd_sc_hd__or2_2
X_5364_ _5418_/C _5425_/A _5363_/Y _5360_/B VGND VGND VPWR VPWR _5364_/X sky130_fd_sc_hd__a211o_2
X_4315_ _4273_/S _4268_/B _4283_/B VGND VGND VPWR VPWR _4315_/Y sky130_fd_sc_hd__o21ai_2
X_5295_ _4761_/X _5284_/X _5294_/Y VGND VGND VPWR VPWR _5295_/X sky130_fd_sc_hd__a21o_2
XFILLER_59_217 VGND VGND VPWR VPWR sky130_fd_sc_hd__decap_3
X_4246_ _5685_/A _4216_/Y _4217_/X _4245_/X VGND VGND VPWR VPWR _5994_/B sky130_fd_sc_hd__a31o_2
X_4177_ _4175_/A _4183_/B _4174_/Y _4176_/X VGND VGND VPWR VPWR _4178_/D sky130_fd_sc_hd__a31oi_2
XFILLER_27_103 VGND VGND VPWR VPWR sky130_fd_sc_hd__decap_3
XFILLER_82_253 VGND VGND VPWR VPWR sky130_fd_sc_hd__decap_3
XFILLER_82_242 VGND VGND VPWR VPWR sky130_fd_sc_hd__decap_3
XFILLER_27_169 VGND VGND VPWR VPWR sky130_fd_sc_hd__decap_3
XFILLER_42_117 VGND VGND VPWR VPWR sky130_fd_sc_hd__decap_3
XTAP_TAPCELL_ROW_81_911 VGND VPWR sky130_fd_sc_hd__tapvpwrvgnd_1
XFILLER_82_275 VGND VGND VPWR VPWR sky130_fd_sc_hd__decap_3
XFILLER_35_180 VGND VGND VPWR VPWR sky130_fd_sc_hd__decap_3
XFILLER_42_139 VGND VGND VPWR VPWR sky130_fd_sc_hd__fill_1
XTAP_TAPCELL_ROW_53_657 VGND VPWR sky130_fd_sc_hd__tapvpwrvgnd_1
Xfanout550 _3367_/B VGND VGND VPWR VPWR _3515_/B sky130_fd_sc_hd__clkdlybuf4s25_1
Xfanout561 input26/X VGND VGND VPWR VPWR _6460_/A0 sky130_fd_sc_hd__clkdlybuf4s25_1
Xfanout572 _6199_/C VGND VGND VPWR VPWR _6176_/A sky130_fd_sc_hd__clkdlybuf4s25_1
Xfanout583 input2/X VGND VGND VPWR VPWR _6485_/A sky130_fd_sc_hd__clkdlybuf4s25_1
Xfanout594 input16/X VGND VGND VPWR VPWR _4239_/A sky130_fd_sc_hd__clkdlybuf4s25_1
XFILLER_18_158 VGND VGND VPWR VPWR sky130_fd_sc_hd__decap_3
XFILLER_61_404 VGND VGND VPWR VPWR sky130_fd_sc_hd__decap_3
XFILLER_26_180 VGND VGND VPWR VPWR sky130_fd_sc_hd__decap_3
XFILLER_33_128 VGND VGND VPWR VPWR sky130_fd_sc_hd__decap_3
XTAP_TAPCELL_ROW_16_326 VGND VPWR sky130_fd_sc_hd__tapvpwrvgnd_1
XFILLER_14_375 VGND VGND VPWR VPWR sky130_fd_sc_hd__decap_3
XFILLER_41_172 VGND VGND VPWR VPWR sky130_fd_sc_hd__decap_3
XTAP_TAPCELL_ROW_24_392 VGND VPWR sky130_fd_sc_hd__tapvpwrvgnd_1
X_5080_ _5042_/A _5123_/B _5052_/S VGND VGND VPWR VPWR _5081_/S sky130_fd_sc_hd__o21a_2
X_4100_ _3877_/X _3930_/X _4052_/X _4099_/X _4221_/S _3942_/A VGND VGND VPWR VPWR
+ _4100_/X sky130_fd_sc_hd__mux4_2
XFILLER_56_209 VGND VGND VPWR VPWR sky130_fd_sc_hd__decap_3
X_4031_ _4124_/A _3998_/X _4008_/Y _4094_/A _4030_/X VGND VGND VPWR VPWR _5993_/B
+ sky130_fd_sc_hd__a221o_2
XFILLER_37_412 VGND VGND VPWR VPWR sky130_fd_sc_hd__decap_3
XFILLER_49_261 VGND VGND VPWR VPWR sky130_fd_sc_hd__decap_3
X_5982_ _5982_/A _5982_/B _5982_/C VGND VGND VPWR VPWR _5982_/Y sky130_fd_sc_hd__nor3_2
XFILLER_64_253 VGND VGND VPWR VPWR sky130_fd_sc_hd__decap_3
XFILLER_52_448 VGND VGND VPWR VPWR sky130_fd_sc_hd__fill_1
X_4933_ _4942_/A _4900_/A _4849_/A _4923_/A _5008_/S0 wire372/X VGND VGND VPWR VPWR
+ _4933_/X sky130_fd_sc_hd__mux4_2
XANTENNA_13 input42/X VGND VGND VPWR VPWR sky130_fd_sc_hd__diode_2
XFILLER_32_183 VGND VGND VPWR VPWR sky130_fd_sc_hd__decap_3
X_4864_ _4975_/A _4824_/S _4916_/C VGND VGND VPWR VPWR _4864_/X sky130_fd_sc_hd__o21a_2
XTAP_TAPCELL_ROW_50_627 VGND VPWR sky130_fd_sc_hd__tapvpwrvgnd_1
XANTENNA_24 _4890_/X VGND VGND VPWR VPWR sky130_fd_sc_hd__diode_2
XANTENNA_35 _5012_/C VGND VGND VPWR VPWR sky130_fd_sc_hd__diode_2
X_4795_ _4940_/A _4941_/A _6072_/A VGND VGND VPWR VPWR _4795_/X sky130_fd_sc_hd__mux2_2
X_3815_ _3826_/A _6126_/B VGND VGND VPWR VPWR _4077_/C sky130_fd_sc_hd__xnor2_2
XFILLER_20_389 VGND VGND VPWR VPWR sky130_fd_sc_hd__decap_3
X_3746_ _3225_/X _3226_/X _3233_/X _3235_/X _3842_/S _3633_/A VGND VGND VPWR VPWR
+ _5137_/B sky130_fd_sc_hd__mux4_2
X_6465_ _3264_/A _3464_/A _6109_/B _3357_/B _3520_/S _6438_/X VGND VGND VPWR VPWR
+ _6465_/X sky130_fd_sc_hd__mux4_2
X_5416_ _5416_/A _5416_/B _5416_/C VGND VGND VPWR VPWR _5416_/X sky130_fd_sc_hd__and3_2
X_3677_ _3667_/B _3558_/B _3558_/C _3608_/Y _6120_/B VGND VGND VPWR VPWR _3818_/A
+ sky130_fd_sc_hd__o311a_2
X_6396_ _6396_/A _6396_/B VGND VGND VPWR VPWR _6396_/Y sky130_fd_sc_hd__nor2_2
Xoutput142 _5993_/B VGND VGND VPWR VPWR result[14] sky130_fd_sc_hd__clkdlybuf4s25_1
Xoutput153 _5996_/C VGND VGND VPWR VPWR result[24] sky130_fd_sc_hd__clkdlybuf4s25_1
Xoutput164 _6000_/A VGND VGND VPWR VPWR result[34] sky130_fd_sc_hd__clkdlybuf4s25_1
Xoutput175 _5984_/D VGND VGND VPWR VPWR result[44] sky130_fd_sc_hd__clkdlybuf4s25_1
Xoutput186 _5982_/C VGND VGND VPWR VPWR result[54] sky130_fd_sc_hd__clkdlybuf4s25_1
X_5347_ _4011_/X _4885_/A _5904_/A3 _4010_/X VGND VGND VPWR VPWR _5347_/X sky130_fd_sc_hd__a22o_2
Xoutput197 _3661_/Y VGND VGND VPWR VPWR result[6] sky130_fd_sc_hd__clkdlybuf4s25_1
X_5278_ _6391_/D _5276_/X _5277_/X VGND VGND VPWR VPWR _5278_/Y sky130_fd_sc_hd__a21oi_2
X_4229_ _4239_/A _6171_/B VGND VGND VPWR VPWR _4263_/C sky130_fd_sc_hd__xor2_2
XTAP_TAPCELL_ROW_58_705 VGND VPWR sky130_fd_sc_hd__tapvpwrvgnd_1
XFILLER_55_231 VGND VGND VPWR VPWR sky130_fd_sc_hd__decap_3
XTAP_TAPCELL_ROW_66_771 VGND VPWR sky130_fd_sc_hd__tapvpwrvgnd_1
XFILLER_70_212 VGND VGND VPWR VPWR sky130_fd_sc_hd__decap_3
XFILLER_70_256 VGND VGND VPWR VPWR sky130_fd_sc_hd__decap_3
XFILLER_23_172 VGND VGND VPWR VPWR sky130_fd_sc_hd__decap_3
XFILLER_11_334 VGND VGND VPWR VPWR sky130_fd_sc_hd__fill_2
Xwire236 _4256_/Y VGND VGND VPWR VPWR _4354_/S sky130_fd_sc_hd__buf_2
Xwire247 _4797_/X VGND VGND VPWR VPWR _5939_/A sky130_fd_sc_hd__clkbuf_4
XFILLER_11_50 VGND VGND VPWR VPWR sky130_fd_sc_hd__fill_1
XFILLER_78_301 VGND VGND VPWR VPWR sky130_fd_sc_hd__fill_1
XFILLER_38_209 VGND VGND VPWR VPWR sky130_fd_sc_hd__decap_3
Xfanout380 fanout387/X VGND VGND VPWR VPWR _5801_/S1 sky130_fd_sc_hd__clkdlybuf4s25_1
Xfanout391 _4099_/S VGND VGND VPWR VPWR _4189_/S sky130_fd_sc_hd__clkdlybuf4s25_1
XFILLER_46_220 VGND VGND VPWR VPWR sky130_fd_sc_hd__decap_3
XFILLER_46_253 VGND VGND VPWR VPWR sky130_fd_sc_hd__decap_3
XTAP_TAPCELL_ROW_29_440 VGND VPWR sky130_fd_sc_hd__tapvpwrvgnd_1
XFILLER_36_80 VGND VGND VPWR VPWR sky130_fd_sc_hd__decap_3
XFILLER_46_286 VGND VGND VPWR VPWR sky130_fd_sc_hd__decap_3
XFILLER_61_234 VGND VGND VPWR VPWR sky130_fd_sc_hd__decap_3
XFILLER_61_278 VGND VGND VPWR VPWR sky130_fd_sc_hd__fill_2
XFILLER_14_150 VGND VGND VPWR VPWR sky130_fd_sc_hd__decap_3
Xinput22 operand_a[24] VGND VGND VPWR VPWR input22/X sky130_fd_sc_hd__clkdlybuf4s25_1
Xinput11 operand_a[14] VGND VGND VPWR VPWR input11/X sky130_fd_sc_hd__clkdlybuf4s25_1
X_4580_ _4577_/X _4579_/Y _4443_/A _4443_/B _4536_/B VGND VGND VPWR VPWR _4580_/X
+ sky130_fd_sc_hd__o2111a_2
X_3600_ _4842_/A _3600_/B _3600_/C VGND VGND VPWR VPWR _3600_/X sky130_fd_sc_hd__and3_2
Xinput55 operand_a[54] VGND VGND VPWR VPWR input55/X sky130_fd_sc_hd__clkdlybuf4s25_1
Xinput44 operand_a[44] VGND VGND VPWR VPWR input44/X sky130_fd_sc_hd__clkdlybuf4s25_1
Xinput33 operand_a[34] VGND VGND VPWR VPWR input33/X sky130_fd_sc_hd__clkdlybuf4s25_1
X_3531_ _3441_/X _3530_/X _3800_/A VGND VGND VPWR VPWR _3531_/X sky130_fd_sc_hd__mux2_2
Xinput88 operand_b[26] VGND VGND VPWR VPWR input88/X sky130_fd_sc_hd__clkdlybuf4s25_1
Xinput77 operand_b[16] VGND VGND VPWR VPWR input77/X sky130_fd_sc_hd__clkdlybuf4s25_1
Xinput66 operand_a[6] VGND VGND VPWR VPWR _6120_/A sky130_fd_sc_hd__clkdlybuf4s25_1
X_6250_ _6251_/B _6250_/B VGND VGND VPWR VPWR _6250_/Y sky130_fd_sc_hd__xnor2_2
Xinput99 operand_b[36] VGND VGND VPWR VPWR _5002_/A sky130_fd_sc_hd__clkdlybuf4s25_1
X_3462_ _6113_/A _3462_/B VGND VGND VPWR VPWR _5988_/C sky130_fd_sc_hd__nand2_2
X_6181_ _4352_/Y _4356_/Y _6217_/A VGND VGND VPWR VPWR _6181_/X sky130_fd_sc_hd__o21a_2
X_5201_ _5159_/A _5166_/A _5166_/B _5160_/A VGND VGND VPWR VPWR _5202_/B sky130_fd_sc_hd__o31ai_2
X_3393_ _5962_/A _4422_/A _3625_/A VGND VGND VPWR VPWR _4010_/C sky130_fd_sc_hd__mux2_2
X_5132_ _6446_/A0 _5128_/A _5054_/A _6450_/A3 _5173_/S0 wire372/X VGND VGND VPWR VPWR
+ _5132_/X sky130_fd_sc_hd__mux4_2
X_5063_ _6497_/A _5120_/D _5043_/X _5696_/A _5062_/X VGND VGND VPWR VPWR _5063_/X
+ sky130_fd_sc_hd__o221a_2
XFILLER_37_220 VGND VGND VPWR VPWR sky130_fd_sc_hd__decap_3
XFILLER_37_242 VGND VGND VPWR VPWR sky130_fd_sc_hd__decap_3
X_4014_ _6467_/A1 input9/X _4014_/S VGND VGND VPWR VPWR _4014_/X sky130_fd_sc_hd__mux2_2
XFILLER_52_212 VGND VGND VPWR VPWR sky130_fd_sc_hd__decap_3
XFILLER_40_418 VGND VGND VPWR VPWR sky130_fd_sc_hd__fill_2
XFILLER_52_267 VGND VGND VPWR VPWR sky130_fd_sc_hd__decap_3
X_5965_ _4054_/X _4759_/X _5380_/X _5964_/X _5381_/S _4937_/A VGND VGND VPWR VPWR
+ _5966_/B sky130_fd_sc_hd__mux4_2
X_5896_ _5896_/A _5960_/A VGND VGND VPWR VPWR _5896_/X sky130_fd_sc_hd__or2_2
X_4916_ _5162_/A _4916_/B _4916_/C VGND VGND VPWR VPWR _4916_/X sky130_fd_sc_hd__or3_2
XTAP_TAPCELL_ROW_35_498 VGND VPWR sky130_fd_sc_hd__tapvpwrvgnd_1
X_4847_ _4945_/A _4954_/B _4845_/X _4846_/X VGND VGND VPWR VPWR _4848_/B sky130_fd_sc_hd__a22o_2
X_4778_ _4778_/A _4778_/B VGND VGND VPWR VPWR _4778_/Y sky130_fd_sc_hd__nor2_2
X_3729_ _3727_/A _3814_/B _3728_/Y VGND VGND VPWR VPWR _3733_/B sky130_fd_sc_hd__a21oi_2
X_6448_ _6446_/X _6447_/X _6469_/S VGND VGND VPWR VPWR _6448_/X sky130_fd_sc_hd__mux2_2
X_6379_ _6393_/A _6392_/B VGND VGND VPWR VPWR _6379_/Y sky130_fd_sc_hd__nor2_2
XFILLER_28_231 VGND VGND VPWR VPWR sky130_fd_sc_hd__decap_3
XFILLER_16_404 VGND VGND VPWR VPWR sky130_fd_sc_hd__decap_3
XFILLER_28_253 VGND VGND VPWR VPWR sky130_fd_sc_hd__fill_2
XFILLER_43_223 VGND VGND VPWR VPWR sky130_fd_sc_hd__fill_1
XTAP_TAPCELL_ROW_26_410 VGND VPWR sky130_fd_sc_hd__tapvpwrvgnd_1
XFILLER_43_256 VGND VGND VPWR VPWR sky130_fd_sc_hd__decap_3
XFILLER_11_131 VGND VGND VPWR VPWR sky130_fd_sc_hd__fill_1
XFILLER_78_153 VGND VGND VPWR VPWR sky130_fd_sc_hd__fill_2
XFILLER_66_315 VGND VGND VPWR VPWR sky130_fd_sc_hd__decap_3
XFILLER_66_304 VGND VGND VPWR VPWR sky130_fd_sc_hd__decap_3
XFILLER_19_264 VGND VGND VPWR VPWR sky130_fd_sc_hd__decap_3
XFILLER_19_275 VGND VGND VPWR VPWR sky130_fd_sc_hd__fill_2
XFILLER_19_297 VGND VGND VPWR VPWR sky130_fd_sc_hd__decap_3
XFILLER_34_234 VGND VGND VPWR VPWR sky130_fd_sc_hd__decap_3
XFILLER_22_407 VGND VGND VPWR VPWR sky130_fd_sc_hd__decap_3
XFILLER_34_256 VGND VGND VPWR VPWR sky130_fd_sc_hd__decap_3
X_5750_ _5750_/A _5750_/B VGND VGND VPWR VPWR _5770_/S sky130_fd_sc_hd__nor2_2
XTAP_TAPCELL_ROW_60_722 VGND VPWR sky130_fd_sc_hd__tapvpwrvgnd_1
X_5681_ _5695_/A _5681_/B VGND VGND VPWR VPWR _5682_/A sky130_fd_sc_hd__xnor2_2
X_4701_ _4621_/B _4783_/A _4778_/B VGND VGND VPWR VPWR _4701_/X sky130_fd_sc_hd__a21o_2
X_4632_ _4460_/X _4631_/X _4721_/S VGND VGND VPWR VPWR _4632_/X sky130_fd_sc_hd__mux2_2
XTAP_TAPCELL_ROW_32_468 VGND VPWR sky130_fd_sc_hd__tapvpwrvgnd_1
XFILLER_8_62 VGND VGND VPWR VPWR sky130_fd_sc_hd__fill_1
Xmax_cap311 _3260_/C VGND VGND VPWR VPWR _3940_/A sky130_fd_sc_hd__buf_2
Xmax_cap300 _5242_/Y VGND VGND VPWR VPWR _5904_/A3 sky130_fd_sc_hd__buf_2
X_4563_ _4515_/X _4288_/X _6232_/A VGND VGND VPWR VPWR _4563_/X sky130_fd_sc_hd__mux2_2
X_6302_ _6391_/A _6300_/Y _6301_/X _5168_/B VGND VGND VPWR VPWR _6302_/X sky130_fd_sc_hd__a211o_2
Xmax_cap333 _3353_/Y VGND VGND VPWR VPWR _4019_/A sky130_fd_sc_hd__buf_2
Xmax_cap322 _4430_/B VGND VGND VPWR VPWR _4353_/C sky130_fd_sc_hd__clkbuf_2
X_4494_ _4513_/A _4455_/B _4429_/A VGND VGND VPWR VPWR _4494_/X sky130_fd_sc_hd__a21o_2
X_3514_ _4132_/A _3514_/B _3514_/C VGND VGND VPWR VPWR _3514_/X sky130_fd_sc_hd__or3_2
X_6233_ _6233_/A _6233_/B _6233_/C VGND VGND VPWR VPWR _6243_/D sky130_fd_sc_hd__nand3_2
Xmax_cap366 _6022_/C VGND VGND VPWR VPWR _6059_/B sky130_fd_sc_hd__clkbuf_2
X_3445_ _3443_/X _3444_/X _3529_/S VGND VGND VPWR VPWR _3445_/X sky130_fd_sc_hd__mux2_2
X_6164_ _6164_/A _6167_/D VGND VGND VPWR VPWR _6164_/Y sky130_fd_sc_hd__xnor2_2
X_3376_ _3908_/A _6467_/A3 _4049_/S _4181_/A _3376_/S0 _3653_/S VGND VGND VPWR VPWR
+ _3376_/X sky130_fd_sc_hd__mux4_2
X_6095_ _6100_/A input1/X VGND VGND VPWR VPWR _6095_/X sky130_fd_sc_hd__or2_2
X_5115_ _6275_/B _5114_/B _5097_/S VGND VGND VPWR VPWR _5116_/B sky130_fd_sc_hd__o21ai_2
XFILLER_69_186 VGND VGND VPWR VPWR sky130_fd_sc_hd__fill_2
XFILLER_57_315 VGND VGND VPWR VPWR sky130_fd_sc_hd__decap_3
X_5046_ _4877_/X _5045_/X _5662_/S VGND VGND VPWR VPWR _5046_/X sky130_fd_sc_hd__mux2_2
XFILLER_57_337 VGND VGND VPWR VPWR sky130_fd_sc_hd__decap_3
XFILLER_72_329 VGND VGND VPWR VPWR sky130_fd_sc_hd__decap_3
XFILLER_25_234 VGND VGND VPWR VPWR sky130_fd_sc_hd__decap_3
XFILLER_25_256 VGND VGND VPWR VPWR sky130_fd_sc_hd__decap_3
XFILLER_25_278 VGND VGND VPWR VPWR sky130_fd_sc_hd__fill_2
XFILLER_40_215 VGND VGND VPWR VPWR sky130_fd_sc_hd__decap_3
X_5948_ _5046_/X _5339_/X _5662_/X _5947_/X _5948_/S0 _5948_/S1 VGND VGND VPWR VPWR
+ _5948_/X sky130_fd_sc_hd__mux4_2
X_5879_ _5925_/A _6040_/B VGND VGND VPWR VPWR _6420_/A sky130_fd_sc_hd__nor2_2
XFILLER_48_315 VGND VGND VPWR VPWR sky130_fd_sc_hd__decap_3
XFILLER_48_359 VGND VGND VPWR VPWR sky130_fd_sc_hd__decap_3
XFILLER_63_318 VGND VGND VPWR VPWR sky130_fd_sc_hd__decap_3
XTAP_TAPCELL_ROW_74_847 VGND VPWR sky130_fd_sc_hd__tapvpwrvgnd_1
XFILLER_71_340 VGND VGND VPWR VPWR sky130_fd_sc_hd__decap_3
XFILLER_16_267 VGND VGND VPWR VPWR sky130_fd_sc_hd__decap_3
XFILLER_16_289 VGND VGND VPWR VPWR sky130_fd_sc_hd__fill_2
XFILLER_71_373 VGND VGND VPWR VPWR sky130_fd_sc_hd__fill_2
XFILLER_33_92 VGND VGND VPWR VPWR sky130_fd_sc_hd__fill_2
XFILLER_8_477 VGND VGND VPWR VPWR sky130_fd_sc_hd__fill_1
X_3230_ _3559_/D VGND VGND VPWR VPWR _3495_/A sky130_fd_sc_hd__clkbuf_2
XFILLER_12_3 VGND VGND VPWR VPWR sky130_fd_sc_hd__decap_3
XFILLER_39_337 VGND VGND VPWR VPWR sky130_fd_sc_hd__fill_2
XFILLER_39_359 VGND VGND VPWR VPWR sky130_fd_sc_hd__decap_3
XFILLER_54_318 VGND VGND VPWR VPWR sky130_fd_sc_hd__decap_3
XFILLER_66_156 VGND VGND VPWR VPWR sky130_fd_sc_hd__fill_1
XFILLER_47_381 VGND VGND VPWR VPWR sky130_fd_sc_hd__decap_3
XTAP_TAPCELL_ROW_37_516 VGND VPWR sky130_fd_sc_hd__tapvpwrvgnd_1
XFILLER_66_189 VGND VGND VPWR VPWR sky130_fd_sc_hd__decap_3
X_5802_ _5338_/X _5506_/X _5661_/X _5801_/X _5947_/S _5239_/X VGND VGND VPWR VPWR
+ _5802_/X sky130_fd_sc_hd__mux4_2
XFILLER_62_362 VGND VGND VPWR VPWR sky130_fd_sc_hd__fill_2
X_3994_ _4042_/A _6158_/A VGND VGND VPWR VPWR _6152_/B sky130_fd_sc_hd__xor2_2
XTAP_TAPCELL_ROW_45_582 VGND VPWR sky130_fd_sc_hd__tapvpwrvgnd_1
X_5733_ _4422_/A _3750_/B _5733_/S VGND VGND VPWR VPWR _5733_/X sky130_fd_sc_hd__mux2_2
X_5664_ _5859_/A _5663_/X _5664_/B1 VGND VGND VPWR VPWR _5664_/X sky130_fd_sc_hd__o21a_2
X_5595_ _4813_/A _5583_/X _5589_/Y _5594_/X VGND VGND VPWR VPWR _5595_/X sky130_fd_sc_hd__a211o_2
X_4615_ _4613_/X _4614_/Y _4578_/B VGND VGND VPWR VPWR _4621_/B sky130_fd_sc_hd__a21o_2
X_4546_ _4546_/A _6189_/B VGND VGND VPWR VPWR _4546_/X sky130_fd_sc_hd__or2_2
X_4477_ _4124_/A _4455_/X _4478_/D _4168_/A _4476_/X VGND VGND VPWR VPWR _4479_/B
+ sky130_fd_sc_hd__a221o_2
X_6216_ _6164_/A _4252_/A _6215_/X VGND VGND VPWR VPWR _6216_/Y sky130_fd_sc_hd__o21ai_2
X_3428_ _3464_/A VGND VGND VPWR VPWR _3554_/B sky130_fd_sc_hd__inv_2
X_6147_ _6125_/X _6141_/X _6146_/X VGND VGND VPWR VPWR _6148_/B sky130_fd_sc_hd__a21o_2
X_3359_ _3357_/Y _3358_/Y _3420_/A VGND VGND VPWR VPWR _3360_/B sky130_fd_sc_hd__a21o_2
X_6078_ _6078_/A _6250_/B _6078_/C _6078_/D VGND VGND VPWR VPWR _6298_/C sky130_fd_sc_hd__and4_2
XFILLER_57_178 VGND VGND VPWR VPWR sky130_fd_sc_hd__decap_3
XFILLER_45_329 VGND VGND VPWR VPWR sky130_fd_sc_hd__decap_3
X_5029_ _5029_/A VGND VGND VPWR VPWR _5051_/A sky130_fd_sc_hd__clkbuf_1
XFILLER_53_340 VGND VGND VPWR VPWR sky130_fd_sc_hd__decap_3
XFILLER_53_362 VGND VGND VPWR VPWR sky130_fd_sc_hd__decap_3
XTAP_TAPCELL_ROW_71_817 VGND VPWR sky130_fd_sc_hd__tapvpwrvgnd_1
XTAP_TAPCELL_ROW_0_174 VGND VPWR sky130_fd_sc_hd__tapvpwrvgnd_1
XFILLER_13_248 VGND VGND VPWR VPWR sky130_fd_sc_hd__decap_3
XFILLER_21_281 VGND VGND VPWR VPWR sky130_fd_sc_hd__decap_3
XFILLER_79_77 VGND VGND VPWR VPWR sky130_fd_sc_hd__fill_1
XFILLER_79_55 VGND VGND VPWR VPWR sky130_fd_sc_hd__fill_1
XTAP_TAPCELL_ROW_8_252 VGND VPWR sky130_fd_sc_hd__tapvpwrvgnd_1
XFILLER_0_141 VGND VGND VPWR VPWR sky130_fd_sc_hd__decap_3
XFILLER_36_307 VGND VGND VPWR VPWR sky130_fd_sc_hd__fill_1
XFILLER_48_156 VGND VGND VPWR VPWR sky130_fd_sc_hd__decap_3
XFILLER_29_370 VGND VGND VPWR VPWR sky130_fd_sc_hd__decap_3
XFILLER_36_329 VGND VGND VPWR VPWR sky130_fd_sc_hd__decap_3
X_4400_ _4586_/A _4586_/B VGND VGND VPWR VPWR _4482_/B sky130_fd_sc_hd__or2_2
X_5380_ _4933_/X _5082_/X _5237_/X _5379_/X _5616_/A _5548_/S VGND VGND VPWR VPWR
+ _5380_/X sky130_fd_sc_hd__mux4_2
X_4331_ _6106_/A _3597_/X _4502_/S VGND VGND VPWR VPWR _4331_/X sky130_fd_sc_hd__a21o_2
X_4262_ _4302_/A1 _4431_/A _4261_/Y VGND VGND VPWR VPWR _4262_/X sky130_fd_sc_hd__o21a_2
X_6001_ _6001_/A _6001_/B _5999_/Y _6000_/Y VGND VGND VPWR VPWR _6002_/C sky130_fd_sc_hd__or4bb_2
X_4193_ _4757_/S _4193_/B VGND VGND VPWR VPWR _4193_/Y sky130_fd_sc_hd__nand2_2
XPHY_EDGE_ROW_19_Left_102 VGND VGND VPWR VPWR sky130_fd_sc_hd__decap_3
XFILLER_39_189 VGND VGND VPWR VPWR sky130_fd_sc_hd__fill_2
XFILLER_54_137 VGND VGND VPWR VPWR sky130_fd_sc_hd__decap_3
XFILLER_50_321 VGND VGND VPWR VPWR sky130_fd_sc_hd__decap_3
XFILLER_50_354 VGND VGND VPWR VPWR sky130_fd_sc_hd__decap_3
XFILLER_50_365 VGND VGND VPWR VPWR sky130_fd_sc_hd__decap_3
X_3977_ _6467_/A3 _3908_/A _4014_/S VGND VGND VPWR VPWR _3977_/X sky130_fd_sc_hd__mux2_2
XFILLER_50_398 VGND VGND VPWR VPWR sky130_fd_sc_hd__decap_3
X_5716_ _5716_/A _5716_/B VGND VGND VPWR VPWR _5716_/X sky130_fd_sc_hd__and2_2
XPHY_EDGE_ROW_28_Left_111 VGND VGND VPWR VPWR sky130_fd_sc_hd__decap_3
X_5647_ _5647_/A _5647_/B VGND VGND VPWR VPWR _5648_/B sky130_fd_sc_hd__nor2_2
X_5578_ _5556_/B _5675_/B _5505_/A VGND VGND VPWR VPWR _5580_/C sky130_fd_sc_hd__o21a_2
X_4529_ _4627_/A _4627_/B VGND VGND VPWR VPWR _4616_/B sky130_fd_sc_hd__or2_2
XTAP_TAPCELL_ROW_5_222 VGND VPWR sky130_fd_sc_hd__tapvpwrvgnd_1
XPHY_EDGE_ROW_37_Left_120 VGND VGND VPWR VPWR sky130_fd_sc_hd__decap_3
XFILLER_58_410 VGND VGND VPWR VPWR sky130_fd_sc_hd__decap_3
XFILLER_18_307 VGND VGND VPWR VPWR sky130_fd_sc_hd__fill_1
XFILLER_65_57 VGND VGND VPWR VPWR sky130_fd_sc_hd__fill_1
XFILLER_45_148 VGND VGND VPWR VPWR sky130_fd_sc_hd__decap_3
XFILLER_26_362 VGND VGND VPWR VPWR sky130_fd_sc_hd__fill_2
XFILLER_41_332 VGND VGND VPWR VPWR sky130_fd_sc_hd__decap_3
XFILLER_41_343 VGND VGND VPWR VPWR sky130_fd_sc_hd__fill_1
XFILLER_41_354 VGND VGND VPWR VPWR sky130_fd_sc_hd__decap_3
XTAP_TAPCELL_ROW_11_279 VGND VPWR sky130_fd_sc_hd__tapvpwrvgnd_1
XFILLER_5_288 VGND VGND VPWR VPWR sky130_fd_sc_hd__decap_3
XFILLER_49_476 VGND VGND VPWR VPWR sky130_fd_sc_hd__decap_3
Xinput9 operand_a[12] VGND VGND VPWR VPWR input9/X sky130_fd_sc_hd__clkdlybuf4s25_1
XTAP_TAPCELL_ROW_47_600 VGND VPWR sky130_fd_sc_hd__tapvpwrvgnd_1
XTAP_TAPCELL_ROW_19_346 VGND VPWR sky130_fd_sc_hd__tapvpwrvgnd_1
XFILLER_32_321 VGND VGND VPWR VPWR sky130_fd_sc_hd__fill_1
X_4880_ _5440_/A _4879_/X _5664_/B1 VGND VGND VPWR VPWR _4880_/Y sky130_fd_sc_hd__o21ai_2
X_3900_ _4462_/S VGND VGND VPWR VPWR _4379_/S sky130_fd_sc_hd__clkbuf_1
X_3831_ _3780_/A _6437_/S _6442_/A VGND VGND VPWR VPWR _3832_/B sky130_fd_sc_hd__a21o_2
X_3762_ _3940_/A _3757_/X _4457_/A _3594_/X VGND VGND VPWR VPWR _3762_/X sky130_fd_sc_hd__a22o_2
X_5501_ _5501_/A _5501_/B VGND VGND VPWR VPWR _5580_/B sky130_fd_sc_hd__and2_2
X_6481_ _6481_/A _6481_/B VGND VGND VPWR VPWR _6481_/X sky130_fd_sc_hd__or2_2
X_3693_ _3777_/C _3693_/B VGND VGND VPWR VPWR _3693_/Y sky130_fd_sc_hd__xnor2_2
X_5432_ _6306_/A _5072_/D _5431_/X VGND VGND VPWR VPWR _5433_/A sky130_fd_sc_hd__o21a_2
X_5363_ _5414_/A VGND VGND VPWR VPWR _5363_/Y sky130_fd_sc_hd__inv_2
X_4314_ _4497_/A VGND VGND VPWR VPWR _5696_/A sky130_fd_sc_hd__clkbuf_2
X_5294_ _5294_/A _5294_/B VGND VGND VPWR VPWR _5294_/Y sky130_fd_sc_hd__nand2_2
X_4245_ _4937_/A _4226_/X _4232_/Y _4124_/A _4244_/X VGND VGND VPWR VPWR _4245_/X
+ sky130_fd_sc_hd__a221o_2
X_4176_ _4109_/S _4183_/B _4135_/B _4175_/Y _4089_/B VGND VGND VPWR VPWR _4176_/X
+ sky130_fd_sc_hd__a32o_2
XFILLER_67_240 VGND VGND VPWR VPWR sky130_fd_sc_hd__decap_3
XFILLER_55_402 VGND VGND VPWR VPWR sky130_fd_sc_hd__decap_3
XFILLER_55_424 VGND VGND VPWR VPWR sky130_fd_sc_hd__decap_3
XFILLER_67_262 VGND VGND VPWR VPWR sky130_fd_sc_hd__decap_3
XTAP_TAPCELL_ROW_81_912 VGND VPWR sky130_fd_sc_hd__tapvpwrvgnd_1
XFILLER_35_192 VGND VGND VPWR VPWR sky130_fd_sc_hd__decap_3
XTAP_TAPCELL_ROW_53_658 VGND VPWR sky130_fd_sc_hd__tapvpwrvgnd_1
XFILLER_23_376 VGND VGND VPWR VPWR sky130_fd_sc_hd__decap_3
XFILLER_50_195 VGND VGND VPWR VPWR sky130_fd_sc_hd__fill_1
Xfanout540 _6447_/A1 VGND VGND VPWR VPWR _4900_/A sky130_fd_sc_hd__clkdlybuf4s25_1
Xfanout551 _6486_/A VGND VGND VPWR VPWR _3367_/B sky130_fd_sc_hd__clkdlybuf4s25_1
Xfanout562 input25/X VGND VGND VPWR VPWR _4599_/A sky130_fd_sc_hd__clkdlybuf4s25_1
Xfanout573 input20/X VGND VGND VPWR VPWR _6199_/C sky130_fd_sc_hd__clkdlybuf4s25_1
Xfanout584 _3292_/A VGND VGND VPWR VPWR _3515_/A sky130_fd_sc_hd__clkdlybuf4s25_1
XFILLER_58_240 VGND VGND VPWR VPWR sky130_fd_sc_hd__decap_3
XFILLER_46_424 VGND VGND VPWR VPWR sky130_fd_sc_hd__decap_3
Xfanout595 input16/X VGND VGND VPWR VPWR _4241_/C sky130_fd_sc_hd__clkdlybuf4s25_1
XFILLER_58_262 VGND VGND VPWR VPWR sky130_fd_sc_hd__decap_3
XFILLER_73_243 VGND VGND VPWR VPWR sky130_fd_sc_hd__fill_2
XFILLER_73_276 VGND VGND VPWR VPWR sky130_fd_sc_hd__decap_3
XTAP_TAPCELL_ROW_16_327 VGND VPWR sky130_fd_sc_hd__tapvpwrvgnd_1
XFILLER_14_365 VGND VGND VPWR VPWR sky130_fd_sc_hd__decap_3
XFILLER_14_387 VGND VGND VPWR VPWR sky130_fd_sc_hd__decap_3
XTAP_TAPCELL_ROW_24_393 VGND VPWR sky130_fd_sc_hd__tapvpwrvgnd_1
X_4030_ _4168_/A _4708_/B _4013_/X _4029_/X VGND VGND VPWR VPWR _4030_/X sky130_fd_sc_hd__a211o_2
XPHY_EDGE_ROW_10_Right_10 VGND VGND VPWR VPWR sky130_fd_sc_hd__decap_3
XFILLER_37_402 VGND VGND VPWR VPWR sky130_fd_sc_hd__fill_1
XFILLER_49_284 VGND VGND VPWR VPWR sky130_fd_sc_hd__decap_3
XFILLER_64_221 VGND VGND VPWR VPWR sky130_fd_sc_hd__decap_3
X_5981_ _5981_/A _5981_/B _5981_/C _5981_/D VGND VGND VPWR VPWR _5983_/C sky130_fd_sc_hd__or4_2
X_4932_ _6473_/S _3460_/X _4931_/X _4879_/S VGND VGND VPWR VPWR _4937_/B sky130_fd_sc_hd__a211o_2
XFILLER_17_192 VGND VGND VPWR VPWR sky130_fd_sc_hd__fill_1
XANTENNA_14 input43/X VGND VGND VPWR VPWR sky130_fd_sc_hd__diode_2
XFILLER_20_302 VGND VGND VPWR VPWR sky130_fd_sc_hd__decap_3
XFILLER_32_151 VGND VGND VPWR VPWR sky130_fd_sc_hd__decap_3
X_4863_ _4863_/A _4910_/A VGND VGND VPWR VPWR _4975_/A sky130_fd_sc_hd__and2_2
XTAP_TAPCELL_ROW_50_628 VGND VPWR sky130_fd_sc_hd__tapvpwrvgnd_1
XANTENNA_25 _5023_/D VGND VGND VPWR VPWR sky130_fd_sc_hd__diode_2
XANTENNA_36 _3798_/A VGND VGND VPWR VPWR sky130_fd_sc_hd__diode_2
XFILLER_20_357 VGND VGND VPWR VPWR sky130_fd_sc_hd__decap_3
X_4794_ _4818_/A VGND VGND VPWR VPWR _6072_/A sky130_fd_sc_hd__inv_2
X_3814_ _4077_/A _3814_/B _3817_/C VGND VGND VPWR VPWR _3820_/A sky130_fd_sc_hd__or3_2
X_3745_ _3745_/A _3745_/B VGND VGND VPWR VPWR _3745_/Y sky130_fd_sc_hd__xnor2_2
X_6464_ _3754_/A _6464_/A1 _3908_/A _3812_/A _3791_/S _6438_/X VGND VGND VPWR VPWR
+ _6464_/X sky130_fd_sc_hd__mux4_2
X_5415_ _5416_/B _5416_/C _5416_/A VGND VGND VPWR VPWR _5415_/Y sky130_fd_sc_hd__a21oi_2
X_3676_ _3689_/A _3676_/B VGND VGND VPWR VPWR _3676_/X sky130_fd_sc_hd__xor2_2
X_6395_ _6382_/X _6388_/X _6390_/X _6394_/X VGND VGND VPWR VPWR _6396_/B sky130_fd_sc_hd__o211a_2
Xoutput143 _5993_/C VGND VGND VPWR VPWR result[15] sky130_fd_sc_hd__clkdlybuf4s25_1
Xoutput154 _5986_/A VGND VGND VPWR VPWR result[25] sky130_fd_sc_hd__clkdlybuf4s25_1
Xoutput165 _6000_/B VGND VGND VPWR VPWR result[35] sky130_fd_sc_hd__clkdlybuf4s25_1
Xoutput176 _5981_/A VGND VGND VPWR VPWR result[45] sky130_fd_sc_hd__clkdlybuf4s25_1
X_5346_ _5422_/A _5414_/A VGND VGND VPWR VPWR _5360_/A sky130_fd_sc_hd__xnor2_2
Xoutput187 _5983_/A VGND VGND VPWR VPWR result[55] sky130_fd_sc_hd__clkdlybuf4s25_1
Xoutput198 _3722_/Y VGND VGND VPWR VPWR result[7] sky130_fd_sc_hd__clkdlybuf4s25_1
X_5277_ _5270_/A2 _5277_/B _5277_/C VGND VGND VPWR VPWR _5277_/X sky130_fd_sc_hd__and3b_2
X_4228_ _4228_/A _4231_/B VGND VGND VPWR VPWR _4228_/Y sky130_fd_sc_hd__nand2_2
X_4159_ _4473_/A VGND VGND VPWR VPWR _4797_/A sky130_fd_sc_hd__clkbuf_1
XFILLER_43_416 VGND VGND VPWR VPWR sky130_fd_sc_hd__decap_3
XFILLER_55_254 VGND VGND VPWR VPWR sky130_fd_sc_hd__decap_3
XFILLER_55_276 VGND VGND VPWR VPWR sky130_fd_sc_hd__decap_3
XTAP_TAPCELL_ROW_66_772 VGND VPWR sky130_fd_sc_hd__tapvpwrvgnd_1
XFILLER_55_287 VGND VGND VPWR VPWR sky130_fd_sc_hd__decap_3
XFILLER_70_224 VGND VGND VPWR VPWR sky130_fd_sc_hd__decap_3
XFILLER_23_140 VGND VGND VPWR VPWR sky130_fd_sc_hd__fill_1
XFILLER_70_268 VGND VGND VPWR VPWR sky130_fd_sc_hd__decap_3
XFILLER_23_151 VGND VGND VPWR VPWR sky130_fd_sc_hd__decap_3
XFILLER_62_69 VGND VGND VPWR VPWR sky130_fd_sc_hd__fill_2
XFILLER_23_184 VGND VGND VPWR VPWR sky130_fd_sc_hd__fill_2
Xwire204 _4969_/X VGND VGND VPWR VPWR _5573_/A sky130_fd_sc_hd__clkbuf_4
Xwire248 _4441_/Y VGND VGND VPWR VPWR _4485_/B sky130_fd_sc_hd__buf_2
Xfanout370 input82/X VGND VGND VPWR VPWR _6173_/A sky130_fd_sc_hd__clkdlybuf4s25_1
Xfanout381 fanout387/X VGND VGND VPWR VPWR _5963_/S1 sky130_fd_sc_hd__clkdlybuf4s25_1
XFILLER_46_232 VGND VGND VPWR VPWR sky130_fd_sc_hd__decap_3
XTAP_TAPCELL_ROW_29_441 VGND VPWR sky130_fd_sc_hd__tapvpwrvgnd_1
XFILLER_61_202 VGND VGND VPWR VPWR sky130_fd_sc_hd__decap_3
XFILLER_36_70 VGND VGND VPWR VPWR sky130_fd_sc_hd__decap_3
XFILLER_46_298 VGND VGND VPWR VPWR sky130_fd_sc_hd__decap_3
XFILLER_61_213 VGND VGND VPWR VPWR sky130_fd_sc_hd__decap_3
XFILLER_61_246 VGND VGND VPWR VPWR sky130_fd_sc_hd__decap_3
Xinput12 operand_a[15] VGND VGND VPWR VPWR input12/X sky130_fd_sc_hd__clkdlybuf4s25_1
Xinput45 operand_a[45] VGND VGND VPWR VPWR input45/X sky130_fd_sc_hd__clkdlybuf4s25_1
Xinput34 operand_a[35] VGND VGND VPWR VPWR input34/X sky130_fd_sc_hd__clkdlybuf4s25_1
Xinput23 operand_a[25] VGND VGND VPWR VPWR input23/X sky130_fd_sc_hd__clkdlybuf4s25_1
X_3530_ _3982_/S _6467_/A2 _4181_/A _4239_/A _3654_/S0 _3654_/S1 VGND VGND VPWR VPWR
+ _3530_/X sky130_fd_sc_hd__mux4_2
Xinput89 operand_b[27] VGND VGND VPWR VPWR input89/X sky130_fd_sc_hd__clkdlybuf4s25_1
Xinput78 operand_b[17] VGND VGND VPWR VPWR input78/X sky130_fd_sc_hd__clkdlybuf4s25_1
Xinput67 operand_a[7] VGND VGND VPWR VPWR input67/X sky130_fd_sc_hd__clkdlybuf4s25_1
Xinput56 operand_a[55] VGND VGND VPWR VPWR input56/X sky130_fd_sc_hd__clkdlybuf4s25_1
XFILLER_6_350 VGND VGND VPWR VPWR sky130_fd_sc_hd__fill_1
X_3461_ _3750_/A _3456_/Y _3460_/X _3710_/A VGND VGND VPWR VPWR _3462_/B sky130_fd_sc_hd__a2bb2o_2
X_6180_ _4240_/S _6217_/A _6179_/X VGND VGND VPWR VPWR _6180_/Y sky130_fd_sc_hd__o21ai_2
X_5200_ _6391_/C _5200_/B VGND VGND VPWR VPWR _5274_/C sky130_fd_sc_hd__xnor2_2
X_3392_ _4465_/S _3392_/B VGND VGND VPWR VPWR _3398_/A sky130_fd_sc_hd__or2_2
X_5131_ _5131_/A _5131_/B VGND VGND VPWR VPWR _5131_/Y sky130_fd_sc_hd__xnor2_2
XFILLER_69_335 VGND VGND VPWR VPWR sky130_fd_sc_hd__fill_1
X_5062_ _3647_/Y _4841_/Y _5048_/Y _5587_/A _5061_/X VGND VGND VPWR VPWR _5062_/X
+ sky130_fd_sc_hd__o221a_2
X_4013_ _3580_/Y _4009_/X _4012_/X _3883_/A VGND VGND VPWR VPWR _4013_/X sky130_fd_sc_hd__a22o_2
XFILLER_25_405 VGND VGND VPWR VPWR sky130_fd_sc_hd__decap_3
XFILLER_37_287 VGND VGND VPWR VPWR sky130_fd_sc_hd__decap_3
XFILLER_52_235 VGND VGND VPWR VPWR sky130_fd_sc_hd__decap_3
X_5964_ _5546_/X _5702_/X _5828_/X _5963_/X _5947_/S _5239_/X VGND VGND VPWR VPWR
+ _5964_/X sky130_fd_sc_hd__mux4_2
XTAP_TAPCELL_ROW_63_742 VGND VPWR sky130_fd_sc_hd__tapvpwrvgnd_1
X_5895_ _5853_/B _6496_/C _6496_/D VGND VGND VPWR VPWR _5960_/A sky130_fd_sc_hd__and3b_2
X_4915_ _4440_/X _4442_/X _4784_/X _4916_/B _4916_/C VGND VGND VPWR VPWR _4915_/X
+ sky130_fd_sc_hd__a2111o_2
XFILLER_20_121 VGND VGND VPWR VPWR sky130_fd_sc_hd__fill_1
XFILLER_20_132 VGND VGND VPWR VPWR sky130_fd_sc_hd__fill_1
X_4846_ _4846_/A VGND VGND VPWR VPWR _4846_/X sky130_fd_sc_hd__clkbuf_1
XFILLER_60_290 VGND VGND VPWR VPWR sky130_fd_sc_hd__fill_1
XFILLER_20_176 VGND VGND VPWR VPWR sky130_fd_sc_hd__decap_3
X_4777_ _4954_/A _4824_/S VGND VGND VPWR VPWR _4777_/Y sky130_fd_sc_hd__xnor2_2
X_3728_ _3728_/A _3745_/A VGND VGND VPWR VPWR _3728_/Y sky130_fd_sc_hd__nand2_2
X_6447_ _6447_/A0 _6447_/A1 input34/X _6447_/A3 _6447_/S0 _6438_/X VGND VGND VPWR
+ VPWR _6447_/X sky130_fd_sc_hd__mux4_2
X_3659_ _3735_/A _3642_/X _3647_/Y _3363_/Y _3658_/Y VGND VGND VPWR VPWR _3659_/X
+ sky130_fd_sc_hd__o221a_2
X_6378_ _6349_/A _6370_/X _6336_/Y _6377_/Y VGND VGND VPWR VPWR _6378_/X sky130_fd_sc_hd__a211o_2
XFILLER_0_515 VGND VGND VPWR VPWR sky130_fd_sc_hd__fill_1
X_5329_ _5906_/A1 _5308_/B _5328_/X VGND VGND VPWR VPWR _5329_/Y sky130_fd_sc_hd__a21oi_2
XFILLER_28_243 VGND VGND VPWR VPWR sky130_fd_sc_hd__fill_1
XFILLER_28_287 VGND VGND VPWR VPWR sky130_fd_sc_hd__decap_3
XTAP_TAPCELL_ROW_26_411 VGND VPWR sky130_fd_sc_hd__tapvpwrvgnd_1
XFILLER_43_235 VGND VGND VPWR VPWR sky130_fd_sc_hd__decap_3
XFILLER_11_165 VGND VGND VPWR VPWR sky130_fd_sc_hd__decap_3
XFILLER_22_83 VGND VGND VPWR VPWR sky130_fd_sc_hd__fill_1
XFILLER_7_169 VGND VGND VPWR VPWR sky130_fd_sc_hd__fill_1
XFILLER_66_327 VGND VGND VPWR VPWR sky130_fd_sc_hd__decap_3
XFILLER_34_213 VGND VGND VPWR VPWR sky130_fd_sc_hd__decap_3
XFILLER_34_246 VGND VGND VPWR VPWR sky130_fd_sc_hd__decap_3
XFILLER_34_268 VGND VGND VPWR VPWR sky130_fd_sc_hd__decap_3
XTAP_TAPCELL_ROW_60_723 VGND VPWR sky130_fd_sc_hd__tapvpwrvgnd_1
X_5680_ _5649_/B _5674_/X _5679_/X VGND VGND VPWR VPWR _5681_/B sky130_fd_sc_hd__a21o_2
X_4700_ _4700_/A _6243_/C VGND VGND VPWR VPWR _4778_/B sky130_fd_sc_hd__nand2_2
X_4631_ _4679_/A _4599_/A _6457_/A1 _6457_/A3 _4675_/S0 _4675_/S1 VGND VGND VPWR VPWR
+ _4631_/X sky130_fd_sc_hd__mux4_2
XTAP_TAPCELL_ROW_32_469 VGND VPWR sky130_fd_sc_hd__tapvpwrvgnd_1
XFILLER_8_85 VGND VGND VPWR VPWR sky130_fd_sc_hd__fill_1
Xmax_cap301 _4200_/X VGND VGND VPWR VPWR _4940_/A sky130_fd_sc_hd__buf_2
X_4562_ _6193_/S VGND VGND VPWR VPWR _6232_/A sky130_fd_sc_hd__inv_2
X_6301_ _6383_/A _6383_/B _5188_/S VGND VGND VPWR VPWR _6301_/X sky130_fd_sc_hd__o21a_2
Xmax_cap334 _4372_/B VGND VGND VPWR VPWR _5242_/B sky130_fd_sc_hd__buf_2
X_4493_ _6185_/A _4541_/S _4627_/B _4492_/X VGND VGND VPWR VPWR _4493_/X sky130_fd_sc_hd__o211a_2
X_3513_ _3668_/A _3559_/C _3547_/C VGND VGND VPWR VPWR _3514_/C sky130_fd_sc_hd__and3_2
X_6232_ _6232_/A _6232_/B _6232_/C VGND VGND VPWR VPWR _6232_/X sky130_fd_sc_hd__and3_2
X_3444_ _3556_/A _3548_/B _3600_/B _3681_/A _6100_/A _3711_/S VGND VGND VPWR VPWR
+ _3444_/X sky130_fd_sc_hd__mux4_2
X_6163_ _6167_/B _6167_/D VGND VGND VPWR VPWR _6163_/X sky130_fd_sc_hd__and2_2
X_3375_ _6453_/A _3323_/X _3337_/Y _3374_/X VGND VGND VPWR VPWR _3375_/X sky130_fd_sc_hd__a211o_2
X_6094_ _6120_/B _4077_/A _6089_/Y _6138_/A _6093_/X VGND VGND VPWR VPWR _6094_/X
+ sky130_fd_sc_hd__a221o_2
X_5114_ _6275_/B _5114_/B VGND VGND VPWR VPWR _5116_/A sky130_fd_sc_hd__nand2_2
XFILLER_57_327 VGND VGND VPWR VPWR sky130_fd_sc_hd__decap_3
X_5045_ _6450_/A1 _6450_/A3 _6265_/A _4942_/A _5173_/S0 wire372/X VGND VGND VPWR VPWR
+ _5045_/X sky130_fd_sc_hd__mux4_2
XFILLER_69_198 VGND VGND VPWR VPWR sky130_fd_sc_hd__decap_3
XFILLER_57_349 VGND VGND VPWR VPWR sky130_fd_sc_hd__decap_3
XFILLER_27_39 VGND VGND VPWR VPWR sky130_fd_sc_hd__decap_3
XFILLER_25_213 VGND VGND VPWR VPWR sky130_fd_sc_hd__decap_3
XFILLER_65_393 VGND VGND VPWR VPWR sky130_fd_sc_hd__decap_3
X_5947_ _5801_/X _5946_/X _5947_/S VGND VGND VPWR VPWR _5947_/X sky130_fd_sc_hd__mux2_2
XFILLER_33_290 VGND VGND VPWR VPWR sky130_fd_sc_hd__decap_3
XFILLER_40_227 VGND VGND VPWR VPWR sky130_fd_sc_hd__decap_3
XFILLER_40_249 VGND VGND VPWR VPWR sky130_fd_sc_hd__decap_3
X_5878_ _5932_/A VGND VGND VPWR VPWR _5925_/A sky130_fd_sc_hd__inv_2
X_4829_ _4848_/A VGND VGND VPWR VPWR _4829_/X sky130_fd_sc_hd__clkbuf_1
XFILLER_48_305 VGND VGND VPWR VPWR sky130_fd_sc_hd__decap_3
XFILLER_48_327 VGND VGND VPWR VPWR sky130_fd_sc_hd__decap_3
XFILLER_16_213 VGND VGND VPWR VPWR sky130_fd_sc_hd__decap_3
XFILLER_56_382 VGND VGND VPWR VPWR sky130_fd_sc_hd__decap_3
XTAP_TAPCELL_ROW_74_848 VGND VPWR sky130_fd_sc_hd__tapvpwrvgnd_1
XFILLER_16_235 VGND VGND VPWR VPWR sky130_fd_sc_hd__decap_3
XFILLER_17_83 VGND VGND VPWR VPWR sky130_fd_sc_hd__fill_1
XFILLER_71_352 VGND VGND VPWR VPWR sky130_fd_sc_hd__decap_3
XFILLER_71_330 VGND VGND VPWR VPWR sky130_fd_sc_hd__decap_3
XFILLER_31_205 VGND VGND VPWR VPWR sky130_fd_sc_hd__decap_3
XFILLER_24_290 VGND VGND VPWR VPWR sky130_fd_sc_hd__fill_1
XFILLER_31_249 VGND VGND VPWR VPWR sky130_fd_sc_hd__decap_3
XFILLER_12_474 VGND VGND VPWR VPWR sky130_fd_sc_hd__fill_2
XFILLER_47_393 VGND VGND VPWR VPWR sky130_fd_sc_hd__decap_3
XFILLER_62_330 VGND VGND VPWR VPWR sky130_fd_sc_hd__decap_3
X_5801_ _6429_/B _6431_/A0 _5752_/A _6440_/A2 _5801_/S0 _5801_/S1 VGND VGND VPWR VPWR
+ _5801_/X sky130_fd_sc_hd__mux4_2
XPHY_EDGE_ROW_8_Right_8 VGND VGND VPWR VPWR sky130_fd_sc_hd__decap_3
XFILLER_62_374 VGND VGND VPWR VPWR sky130_fd_sc_hd__fill_1
X_5732_ _5732_/A _5732_/B VGND VGND VPWR VPWR _5733_/S sky130_fd_sc_hd__nor2_2
X_3993_ _3993_/A VGND VGND VPWR VPWR _4687_/D sky130_fd_sc_hd__clkbuf_1
XTAP_TAPCELL_ROW_45_583 VGND VPWR sky130_fd_sc_hd__tapvpwrvgnd_1
XFILLER_62_396 VGND VGND VPWR VPWR sky130_fd_sc_hd__decap_3
XFILLER_15_290 VGND VGND VPWR VPWR sky130_fd_sc_hd__fill_1
XFILLER_30_282 VGND VGND VPWR VPWR sky130_fd_sc_hd__decap_3
X_5663_ _4721_/X _5046_/X _5339_/X _5662_/X _5175_/S _5049_/S VGND VGND VPWR VPWR
+ _5663_/X sky130_fd_sc_hd__mux4_2
X_5594_ _5050_/A _5590_/X _5593_/X _5609_/A wire230/X VGND VGND VPWR VPWR _5594_/X
+ sky130_fd_sc_hd__a221o_2
X_4614_ _4614_/A _4614_/B VGND VGND VPWR VPWR _4614_/Y sky130_fd_sc_hd__nor2_2
X_4545_ _5534_/C _4545_/B VGND VGND VPWR VPWR _4545_/Y sky130_fd_sc_hd__xnor2_2
X_4476_ _3750_/B _3303_/Y _4456_/Y _4468_/Y _4475_/X VGND VGND VPWR VPWR _4476_/X
+ sky130_fd_sc_hd__a311o_2
X_6215_ _6167_/B _6213_/Y _6167_/D _6214_/X VGND VGND VPWR VPWR _6215_/X sky130_fd_sc_hd__o31a_2
X_3427_ _3985_/A _3427_/B VGND VGND VPWR VPWR _3427_/Y sky130_fd_sc_hd__nand2_2
XPHY_EDGE_ROW_39_Right_39 VGND VGND VPWR VPWR sky130_fd_sc_hd__decap_3
X_6146_ input8/X _6143_/X _6144_/Y _6145_/X VGND VGND VPWR VPWR _6146_/X sky130_fd_sc_hd__a211o_2
X_3358_ _3348_/A _3357_/B _3292_/A VGND VGND VPWR VPWR _3358_/Y sky130_fd_sc_hd__o21ai_2
Xload_slew392 _4189_/S VGND VGND VPWR VPWR _3695_/S0 sky130_fd_sc_hd__buf_4
XPHY_EDGE_ROW_13_Left_96 VGND VGND VPWR VPWR sky130_fd_sc_hd__decap_3
XFILLER_57_113 VGND VGND VPWR VPWR sky130_fd_sc_hd__decap_3
XFILLER_45_308 VGND VGND VPWR VPWR sky130_fd_sc_hd__decap_3
X_6077_ _6077_/A _6077_/B _6077_/C _6270_/A VGND VGND VPWR VPWR _6078_/D sky130_fd_sc_hd__and4_2
X_3289_ _3361_/C VGND VGND VPWR VPWR _3369_/B sky130_fd_sc_hd__inv_2
XFILLER_38_371 VGND VGND VPWR VPWR sky130_fd_sc_hd__decap_3
X_5028_ _5087_/A _5085_/A VGND VGND VPWR VPWR _5029_/A sky130_fd_sc_hd__or2_2
XFILLER_65_190 VGND VGND VPWR VPWR sky130_fd_sc_hd__fill_2
XFILLER_41_514 VGND VGND VPWR VPWR sky130_fd_sc_hd__fill_2
XFILLER_53_374 VGND VGND VPWR VPWR sky130_fd_sc_hd__decap_3
XTAP_TAPCELL_ROW_71_818 VGND VPWR sky130_fd_sc_hd__tapvpwrvgnd_1
XTAP_TAPCELL_ROW_0_175 VGND VPWR sky130_fd_sc_hd__tapvpwrvgnd_1
XFILLER_53_396 VGND VGND VPWR VPWR sky130_fd_sc_hd__fill_2
XPHY_EDGE_ROW_48_Right_48 VGND VGND VPWR VPWR sky130_fd_sc_hd__decap_3
XPHY_EDGE_ROW_57_Right_57 VGND VGND VPWR VPWR sky130_fd_sc_hd__decap_3
XTAP_TAPCELL_ROW_8_253 VGND VPWR sky130_fd_sc_hd__tapvpwrvgnd_1
XFILLER_76_444 VGND VGND VPWR VPWR sky130_fd_sc_hd__fill_1
XFILLER_48_168 VGND VGND VPWR VPWR sky130_fd_sc_hd__decap_3
XFILLER_29_382 VGND VGND VPWR VPWR sky130_fd_sc_hd__decap_3
XFILLER_29_393 VGND VGND VPWR VPWR sky130_fd_sc_hd__decap_3
XFILLER_44_330 VGND VGND VPWR VPWR sky130_fd_sc_hd__decap_3
XFILLER_44_363 VGND VGND VPWR VPWR sky130_fd_sc_hd__fill_1
XPHY_EDGE_ROW_66_Right_66 VGND VGND VPWR VPWR sky130_fd_sc_hd__decap_3
XFILLER_71_182 VGND VGND VPWR VPWR sky130_fd_sc_hd__decap_3
XFILLER_44_81 VGND VGND VPWR VPWR sky130_fd_sc_hd__decap_3
XTAP_TAPCELL_ROW_42_553 VGND VPWR sky130_fd_sc_hd__tapvpwrvgnd_1
XPHY_EDGE_ROW_75_Right_75 VGND VGND VPWR VPWR sky130_fd_sc_hd__decap_3
X_4330_ _3978_/X _4329_/X _4379_/S VGND VGND VPWR VPWR _4330_/X sky130_fd_sc_hd__mux2_2
X_4261_ _4302_/A1 _4259_/A _4258_/Y _4260_/X VGND VGND VPWR VPWR _4261_/Y sky130_fd_sc_hd__a31oi_2
X_6000_ _6000_/A _6000_/B _6000_/C _6000_/D VGND VGND VPWR VPWR _6000_/Y sky130_fd_sc_hd__nor4_2
XFILLER_39_124 VGND VGND VPWR VPWR sky130_fd_sc_hd__decap_3
X_4192_ _3645_/X _3842_/X _4015_/X _4190_/X _4191_/X _6108_/A VGND VGND VPWR VPWR
+ _4193_/B sky130_fd_sc_hd__mux4_2
XFILLER_79_271 VGND VGND VPWR VPWR sky130_fd_sc_hd__decap_3
XFILLER_54_116 VGND VGND VPWR VPWR sky130_fd_sc_hd__decap_3
XFILLER_47_190 VGND VGND VPWR VPWR sky130_fd_sc_hd__decap_3
XFILLER_23_503 VGND VGND VPWR VPWR sky130_fd_sc_hd__fill_1
XFILLER_35_396 VGND VGND VPWR VPWR sky130_fd_sc_hd__decap_3
XFILLER_50_333 VGND VGND VPWR VPWR sky130_fd_sc_hd__decap_3
XFILLER_62_182 VGND VGND VPWR VPWR sky130_fd_sc_hd__decap_3
X_3976_ _3976_/A VGND VGND VPWR VPWR _3976_/X sky130_fd_sc_hd__clkbuf_1
XFILLER_50_377 VGND VGND VPWR VPWR sky130_fd_sc_hd__decap_3
X_5715_ _5658_/A _5678_/A _5714_/Y VGND VGND VPWR VPWR _5716_/B sky130_fd_sc_hd__o21ai_2
X_5646_ _5649_/B _5646_/B VGND VGND VPWR VPWR _6494_/C sky130_fd_sc_hd__nand2_2
X_5577_ _5712_/A _5710_/B _5576_/X VGND VGND VPWR VPWR _5635_/B sky130_fd_sc_hd__o21a_2
X_4528_ _6221_/B _4489_/B _4487_/X VGND VGND VPWR VPWR _4536_/B sky130_fd_sc_hd__a21o_2
X_4459_ _4429_/A _6199_/C _4504_/S VGND VGND VPWR VPWR _4459_/X sky130_fd_sc_hd__mux2_2
XTAP_TAPCELL_ROW_5_223 VGND VPWR sky130_fd_sc_hd__tapvpwrvgnd_1
X_6129_ _6129_/A _6144_/C VGND VGND VPWR VPWR _6129_/Y sky130_fd_sc_hd__xnor2_2
XFILLER_45_116 VGND VGND VPWR VPWR sky130_fd_sc_hd__decap_3
XFILLER_58_477 VGND VGND VPWR VPWR sky130_fd_sc_hd__fill_2
XFILLER_65_69 VGND VGND VPWR VPWR sky130_fd_sc_hd__fill_2
XFILLER_60_119 VGND VGND VPWR VPWR sky130_fd_sc_hd__decap_3
XFILLER_41_311 VGND VGND VPWR VPWR sky130_fd_sc_hd__decap_3
XFILLER_53_160 VGND VGND VPWR VPWR sky130_fd_sc_hd__decap_3
XFILLER_53_182 VGND VGND VPWR VPWR sky130_fd_sc_hd__decap_3
XFILLER_81_35 VGND VGND VPWR VPWR sky130_fd_sc_hd__fill_1
XFILLER_41_366 VGND VGND VPWR VPWR sky130_fd_sc_hd__decap_3
XFILLER_14_73 VGND VGND VPWR VPWR sky130_fd_sc_hd__decap_3
XFILLER_68_208 VGND VGND VPWR VPWR sky130_fd_sc_hd__decap_3
XFILLER_49_411 VGND VGND VPWR VPWR sky130_fd_sc_hd__decap_3
XFILLER_76_241 VGND VGND VPWR VPWR sky130_fd_sc_hd__decap_3
XFILLER_36_116 VGND VGND VPWR VPWR sky130_fd_sc_hd__decap_3
XTAP_TAPCELL_ROW_47_601 VGND VPWR sky130_fd_sc_hd__tapvpwrvgnd_1
XFILLER_76_285 VGND VGND VPWR VPWR sky130_fd_sc_hd__decap_3
XTAP_TAPCELL_ROW_19_347 VGND VPWR sky130_fd_sc_hd__tapvpwrvgnd_1
XFILLER_64_458 VGND VGND VPWR VPWR sky130_fd_sc_hd__fill_1
XFILLER_51_119 VGND VGND VPWR VPWR sky130_fd_sc_hd__decap_3
XFILLER_17_396 VGND VGND VPWR VPWR sky130_fd_sc_hd__decap_3
XFILLER_44_171 VGND VGND VPWR VPWR sky130_fd_sc_hd__decap_3
XFILLER_55_91 VGND VGND VPWR VPWR sky130_fd_sc_hd__decap_3
XFILLER_44_193 VGND VGND VPWR VPWR sky130_fd_sc_hd__decap_3
X_3830_ _4382_/S _3830_/B VGND VGND VPWR VPWR _3830_/Y sky130_fd_sc_hd__nor2_2
X_3761_ _3759_/X _3760_/Y _3761_/S VGND VGND VPWR VPWR _4457_/A sky130_fd_sc_hd__mux2_2
X_5500_ _5500_/A _5500_/B VGND VGND VPWR VPWR _5500_/Y sky130_fd_sc_hd__xnor2_2
X_6480_ _5918_/A _6423_/B _6476_/A VGND VGND VPWR VPWR _6481_/B sky130_fd_sc_hd__a21oi_2
X_3692_ _3940_/A _3856_/A _3856_/B _3856_/C VGND VGND VPWR VPWR _3693_/B sky130_fd_sc_hd__and4_2
XFILLER_72_3 VGND VGND VPWR VPWR sky130_fd_sc_hd__fill_2
X_5431_ _6306_/A _5071_/A _5071_/B _5097_/S VGND VGND VPWR VPWR _5431_/X sky130_fd_sc_hd__a31o_2
X_5362_ _5396_/A _5337_/Y _5357_/X _5361_/Y VGND VGND VPWR VPWR _5981_/B sky130_fd_sc_hd__a211o_2
X_4313_ _4266_/B _4311_/X _4312_/X VGND VGND VPWR VPWR _4313_/X sky130_fd_sc_hd__o21a_2
X_5293_ _4416_/A _3895_/Y _3945_/Y _5090_/B _3947_/B VGND VGND VPWR VPWR _5294_/B
+ sky130_fd_sc_hd__a311o_2
XFILLER_59_208 VGND VGND VPWR VPWR sky130_fd_sc_hd__decap_3
X_4244_ _4207_/A _4235_/X _4236_/X _4154_/Y _4243_/X VGND VGND VPWR VPWR _4244_/X
+ sky130_fd_sc_hd__a221o_2
X_4175_ _4175_/A _6167_/B _4183_/B VGND VGND VPWR VPWR _4175_/Y sky130_fd_sc_hd__nor3_2
XFILLER_55_414 VGND VGND VPWR VPWR sky130_fd_sc_hd__fill_1
XFILLER_67_274 VGND VGND VPWR VPWR sky130_fd_sc_hd__decap_3
XFILLER_55_436 VGND VGND VPWR VPWR sky130_fd_sc_hd__decap_3
XFILLER_50_130 VGND VGND VPWR VPWR sky130_fd_sc_hd__decap_3
XTAP_TAPCELL_ROW_53_659 VGND VPWR sky130_fd_sc_hd__tapvpwrvgnd_1
XFILLER_23_388 VGND VGND VPWR VPWR sky130_fd_sc_hd__decap_3
X_3959_ _3966_/S _3959_/B VGND VGND VPWR VPWR _3959_/Y sky130_fd_sc_hd__xnor2_2
X_5629_ _5629_/A _5629_/B _5628_/X VGND VGND VPWR VPWR _5630_/A sky130_fd_sc_hd__or3b_2
Xfanout530 input38/X VGND VGND VPWR VPWR _5128_/A sky130_fd_sc_hd__clkdlybuf4s25_1
Xfanout541 input33/X VGND VGND VPWR VPWR _6447_/A1 sky130_fd_sc_hd__clkdlybuf4s25_1
Xfanout552 input3/X VGND VGND VPWR VPWR _6486_/A sky130_fd_sc_hd__clkdlybuf4s25_1
Xfanout563 input25/X VGND VGND VPWR VPWR _6457_/A2 sky130_fd_sc_hd__clkdlybuf4s25_1
Xfanout574 _5098_/A1 VGND VGND VPWR VPWR _4561_/A sky130_fd_sc_hd__clkdlybuf4s25_1
XFILLER_46_414 VGND VGND VPWR VPWR sky130_fd_sc_hd__decap_3
Xfanout596 _6458_/A1 VGND VGND VPWR VPWR _4230_/A sky130_fd_sc_hd__clkdlybuf4s25_1
XFILLER_73_200 VGND VGND VPWR VPWR sky130_fd_sc_hd__decap_3
XFILLER_58_274 VGND VGND VPWR VPWR sky130_fd_sc_hd__decap_3
XFILLER_73_211 VGND VGND VPWR VPWR sky130_fd_sc_hd__decap_3
XFILLER_14_300 VGND VGND VPWR VPWR sky130_fd_sc_hd__fill_1
XFILLER_14_322 VGND VGND VPWR VPWR sky130_fd_sc_hd__decap_3
XFILLER_73_299 VGND VGND VPWR VPWR sky130_fd_sc_hd__decap_3
XFILLER_14_399 VGND VGND VPWR VPWR sky130_fd_sc_hd__decap_3
XFILLER_41_152 VGND VGND VPWR VPWR sky130_fd_sc_hd__decap_3
XFILLER_41_196 VGND VGND VPWR VPWR sky130_fd_sc_hd__decap_3
XTAP_TAPCELL_ROW_24_394 VGND VPWR sky130_fd_sc_hd__tapvpwrvgnd_1
XFILLER_1_281 VGND VGND VPWR VPWR sky130_fd_sc_hd__fill_2
XFILLER_64_200 VGND VGND VPWR VPWR sky130_fd_sc_hd__decap_3
XFILLER_52_406 VGND VGND VPWR VPWR sky130_fd_sc_hd__decap_3
X_5980_ _5627_/A _5961_/X _5974_/Y _5979_/X VGND VGND VPWR VPWR _6501_/A sky130_fd_sc_hd__a211o_2
XPHY_EDGE_ROW_56_Left_139 VGND VGND VPWR VPWR sky130_fd_sc_hd__decap_3
XFILLER_17_160 VGND VGND VPWR VPWR sky130_fd_sc_hd__fill_1
X_4931_ _4973_/A _4224_/B _4930_/X _4931_/B2 VGND VGND VPWR VPWR _4931_/X sky130_fd_sc_hd__a22o_2
XFILLER_32_130 VGND VGND VPWR VPWR sky130_fd_sc_hd__fill_2
XFILLER_32_141 VGND VGND VPWR VPWR sky130_fd_sc_hd__fill_1
X_4862_ _4919_/A _4919_/B VGND VGND VPWR VPWR _4954_/C sky130_fd_sc_hd__or2_2
XFILLER_32_163 VGND VGND VPWR VPWR sky130_fd_sc_hd__decap_3
X_3813_ _3752_/X _3812_/X _3786_/X VGND VGND VPWR VPWR _3817_/C sky130_fd_sc_hd__a21o_2
XTAP_TAPCELL_ROW_50_629 VGND VPWR sky130_fd_sc_hd__tapvpwrvgnd_1
XANTENNA_15 _5352_/C VGND VGND VPWR VPWR sky130_fd_sc_hd__diode_2
XANTENNA_26 _6002_/C VGND VGND VPWR VPWR sky130_fd_sc_hd__diode_2
XANTENNA_37 _6100_/A VGND VGND VPWR VPWR sky130_fd_sc_hd__diode_2
X_4793_ _6071_/B VGND VGND VPWR VPWR _4922_/A sky130_fd_sc_hd__inv_2
X_3744_ _3744_/A _3744_/B VGND VGND VPWR VPWR _3745_/B sky130_fd_sc_hd__nand2_2
XFILLER_9_370 VGND VGND VPWR VPWR sky130_fd_sc_hd__fill_2
X_6463_ _6459_/X _6462_/X _6463_/S VGND VGND VPWR VPWR _6463_/X sky130_fd_sc_hd__mux2_2
X_3675_ _3666_/X _3667_/X _3669_/X _3674_/X VGND VGND VPWR VPWR _3676_/B sky130_fd_sc_hd__a31o_2
XPHY_EDGE_ROW_65_Left_148 VGND VGND VPWR VPWR sky130_fd_sc_hd__decap_3
X_5414_ _5414_/A _6290_/A VGND VGND VPWR VPWR _5414_/Y sky130_fd_sc_hd__nor2_2
X_6394_ _6393_/C _6392_/X _6393_/X _5256_/A VGND VGND VPWR VPWR _6394_/X sky130_fd_sc_hd__o2bb2a_2
Xoutput144 _5994_/A VGND VGND VPWR VPWR result[16] sky130_fd_sc_hd__clkdlybuf4s25_1
Xoutput155 _4571_/X VGND VGND VPWR VPWR result[26] sky130_fd_sc_hd__clkdlybuf4s25_1
Xoutput166 _6000_/C VGND VGND VPWR VPWR result[36] sky130_fd_sc_hd__clkdlybuf4s25_1
Xoutput177 _5981_/B VGND VGND VPWR VPWR result[46] sky130_fd_sc_hd__clkdlybuf4s25_1
X_5345_ _5416_/B _5416_/C VGND VGND VPWR VPWR _5414_/A sky130_fd_sc_hd__nand2_2
Xoutput188 _5983_/B VGND VGND VPWR VPWR result[56] sky130_fd_sc_hd__clkdlybuf4s25_1
Xoutput199 _5991_/A VGND VGND VPWR VPWR result[8] sky130_fd_sc_hd__clkdlybuf4s25_1
X_5276_ _5277_/B _5277_/C _5270_/A2 VGND VGND VPWR VPWR _5276_/X sky130_fd_sc_hd__a21bo_2
X_4227_ _4230_/A _6161_/A VGND VGND VPWR VPWR _4228_/A sky130_fd_sc_hd__nand2_2
X_4158_ _4018_/A _6170_/A _4157_/X VGND VGND VPWR VPWR _4158_/Y sky130_fd_sc_hd__o21ai_2
XPHY_EDGE_ROW_74_Left_157 VGND VGND VPWR VPWR sky130_fd_sc_hd__decap_3
X_4089_ _4183_/A _4089_/B VGND VGND VPWR VPWR _4093_/A sky130_fd_sc_hd__xnor2_2
XTAP_TAPCELL_ROW_66_773 VGND VPWR sky130_fd_sc_hd__tapvpwrvgnd_1
XFILLER_70_236 VGND VGND VPWR VPWR sky130_fd_sc_hd__decap_3
XFILLER_70_203 VGND VGND VPWR VPWR sky130_fd_sc_hd__decap_3
XFILLER_23_163 VGND VGND VPWR VPWR sky130_fd_sc_hd__decap_3
XFILLER_11_325 VGND VGND VPWR VPWR sky130_fd_sc_hd__decap_3
XFILLER_11_369 VGND VGND VPWR VPWR sky130_fd_sc_hd__decap_3
Xwire227 _3976_/X VGND VGND VPWR VPWR wire227/X sky130_fd_sc_hd__buf_2
XFILLER_7_329 VGND VGND VPWR VPWR sky130_fd_sc_hd__fill_2
Xwire249 _5084_/S VGND VGND VPWR VPWR _4502_/S sky130_fd_sc_hd__buf_2
XTAP_TAPCELL_ROW_21_364 VGND VPWR sky130_fd_sc_hd__tapvpwrvgnd_1
XFILLER_3_513 VGND VGND VPWR VPWR sky130_fd_sc_hd__decap_3
XFILLER_11_96 VGND VGND VPWR VPWR sky130_fd_sc_hd__decap_3
XFILLER_78_325 VGND VGND VPWR VPWR sky130_fd_sc_hd__decap_3
Xfanout360 input89/X VGND VGND VPWR VPWR _6233_/B sky130_fd_sc_hd__clkdlybuf4s25_1
Xfanout371 wire374/X VGND VGND VPWR VPWR wire372/A sky130_fd_sc_hd__clkdlybuf4s25_1
Xfanout382 fanout387/X VGND VGND VPWR VPWR _3590_/B sky130_fd_sc_hd__clkdlybuf4s25_1
Xfanout393 fanout406/X VGND VGND VPWR VPWR _4099_/S sky130_fd_sc_hd__clkdlybuf4s25_1
XFILLER_46_211 VGND VGND VPWR VPWR sky130_fd_sc_hd__decap_3
XTAP_TAPCELL_ROW_29_442 VGND VPWR sky130_fd_sc_hd__tapvpwrvgnd_1
XFILLER_46_277 VGND VGND VPWR VPWR sky130_fd_sc_hd__decap_3
XPHY_EDGE_ROW_1_Left_84 VGND VGND VPWR VPWR sky130_fd_sc_hd__decap_3
XFILLER_14_141 VGND VGND VPWR VPWR sky130_fd_sc_hd__decap_3
Xinput13 operand_a[16] VGND VGND VPWR VPWR input13/X sky130_fd_sc_hd__clkdlybuf4s25_1
Xinput46 operand_a[46] VGND VGND VPWR VPWR input46/X sky130_fd_sc_hd__clkdlybuf4s25_1
Xinput35 operand_a[36] VGND VGND VPWR VPWR input35/X sky130_fd_sc_hd__clkdlybuf4s25_1
Xinput24 operand_a[26] VGND VGND VPWR VPWR input24/X sky130_fd_sc_hd__clkdlybuf4s25_1
Xinput79 operand_b[18] VGND VGND VPWR VPWR _6161_/A sky130_fd_sc_hd__clkdlybuf4s25_1
Xinput68 operand_a[8] VGND VGND VPWR VPWR input68/X sky130_fd_sc_hd__clkdlybuf4s25_1
Xinput57 operand_a[56] VGND VGND VPWR VPWR input57/X sky130_fd_sc_hd__clkdlybuf4s25_1
X_3460_ _3970_/A _3458_/X _3459_/X _3750_/A VGND VGND VPWR VPWR _3460_/X sky130_fd_sc_hd__o211a_2
X_3391_ _3319_/X _3459_/B _4506_/S VGND VGND VPWR VPWR _3392_/B sky130_fd_sc_hd__mux2_2
X_5130_ _4824_/S _5193_/B _5129_/Y VGND VGND VPWR VPWR _5131_/B sky130_fd_sc_hd__o21a_2
X_5061_ _5061_/A _5061_/B _5061_/C VGND VGND VPWR VPWR _5061_/X sky130_fd_sc_hd__and3_2
X_4012_ _4196_/B _4010_/X _4011_/X _4146_/A VGND VGND VPWR VPWR _4012_/X sky130_fd_sc_hd__a22o_2
XFILLER_80_501 VGND VGND VPWR VPWR sky130_fd_sc_hd__fill_1
XFILLER_37_277 VGND VGND VPWR VPWR sky130_fd_sc_hd__decap_3
XFILLER_52_203 VGND VGND VPWR VPWR sky130_fd_sc_hd__decap_3
X_5963_ _6476_/A _5918_/A _5932_/A _6428_/A2 _5963_/S0 _5963_/S1 VGND VGND VPWR VPWR
+ _5963_/X sky130_fd_sc_hd__mux4_2
XFILLER_52_247 VGND VGND VPWR VPWR sky130_fd_sc_hd__decap_3
X_4914_ _6072_/A _4916_/B _6071_/B _5162_/A VGND VGND VPWR VPWR _4914_/X sky130_fd_sc_hd__or4b_2
XTAP_TAPCELL_ROW_63_743 VGND VPWR sky130_fd_sc_hd__tapvpwrvgnd_1
X_5894_ _6496_/D _5894_/B VGND VGND VPWR VPWR _5896_/A sky130_fd_sc_hd__nor2_2
XFILLER_32_29 VGND VGND VPWR VPWR sky130_fd_sc_hd__fill_1
X_4845_ _5178_/A _4916_/B _4817_/A VGND VGND VPWR VPWR _4845_/X sky130_fd_sc_hd__a21bo_2
X_4776_ _5193_/A _4776_/B VGND VGND VPWR VPWR _4824_/S sky130_fd_sc_hd__and2_2
X_3727_ _3727_/A _3814_/B _3727_/C VGND VGND VPWR VPWR _3733_/A sky130_fd_sc_hd__and3_2
X_6446_ _6446_/A0 input42/X input43/X input41/X _6447_/S0 _6438_/X VGND VGND VPWR
+ VPWR _6446_/X sky130_fd_sc_hd__mux4_2
X_3658_ _3976_/A _3658_/B VGND VGND VPWR VPWR _3658_/Y sky130_fd_sc_hd__nand2_2
X_6377_ _6371_/Y _6373_/X _6376_/X VGND VGND VPWR VPWR _6377_/Y sky130_fd_sc_hd__o21ai_2
X_3589_ _3985_/B _3501_/Y _3588_/X _3495_/A VGND VGND VPWR VPWR _5014_/B sky130_fd_sc_hd__a22oi_2
X_5328_ _4940_/A _4941_/A _5328_/S VGND VGND VPWR VPWR _5328_/X sky130_fd_sc_hd__mux2_2
X_5259_ _5259_/A _5259_/B VGND VGND VPWR VPWR _5302_/B sky130_fd_sc_hd__nand2_2
XFILLER_28_200 VGND VGND VPWR VPWR sky130_fd_sc_hd__decap_3
XFILLER_16_417 VGND VGND VPWR VPWR sky130_fd_sc_hd__decap_3
XFILLER_43_214 VGND VGND VPWR VPWR sky130_fd_sc_hd__decap_3
XTAP_TAPCELL_ROW_26_412 VGND VPWR sky130_fd_sc_hd__tapvpwrvgnd_1
XFILLER_43_247 VGND VGND VPWR VPWR sky130_fd_sc_hd__decap_3
XFILLER_11_188 VGND VGND VPWR VPWR sky130_fd_sc_hd__fill_1
XFILLER_3_354 VGND VGND VPWR VPWR sky130_fd_sc_hd__fill_1
XFILLER_19_211 VGND VGND VPWR VPWR sky130_fd_sc_hd__fill_1
XFILLER_59_391 VGND VGND VPWR VPWR sky130_fd_sc_hd__fill_1
XFILLER_47_70 VGND VGND VPWR VPWR sky130_fd_sc_hd__fill_2
XTAP_TAPCELL_ROW_77_868 VGND VPWR sky130_fd_sc_hd__tapvpwrvgnd_1
XFILLER_34_203 VGND VGND VPWR VPWR sky130_fd_sc_hd__fill_1
XFILLER_34_225 VGND VGND VPWR VPWR sky130_fd_sc_hd__decap_3
XFILLER_42_280 VGND VGND VPWR VPWR sky130_fd_sc_hd__fill_2
XFILLER_42_291 VGND VGND VPWR VPWR sky130_fd_sc_hd__decap_3
X_4630_ _4768_/A _4630_/B VGND VGND VPWR VPWR _4630_/Y sky130_fd_sc_hd__xnor2_2
XFILLER_30_486 VGND VGND VPWR VPWR sky130_fd_sc_hd__fill_2
X_6300_ _6383_/A _6383_/B VGND VGND VPWR VPWR _6300_/Y sky130_fd_sc_hd__xnor2_2
Xmax_cap302 _4199_/X VGND VGND VPWR VPWR _4941_/A sky130_fd_sc_hd__buf_2
X_4561_ _4561_/A _6233_/A VGND VGND VPWR VPWR _4561_/X sky130_fd_sc_hd__or2_2
Xmax_cap324 _4170_/A VGND VGND VPWR VPWR _4183_/A sky130_fd_sc_hd__buf_2
Xmax_cap313 _3698_/S VGND VGND VPWR VPWR _3469_/S sky130_fd_sc_hd__buf_4
X_4492_ _6185_/A _4541_/S _6224_/A VGND VGND VPWR VPWR _4492_/X sky130_fd_sc_hd__a21o_2
X_3512_ _3559_/C _3547_/C _3668_/A VGND VGND VPWR VPWR _3514_/B sky130_fd_sc_hd__a21oi_2
X_6231_ _6192_/A _6228_/X _6230_/X _6232_/A VGND VGND VPWR VPWR _6231_/X sky130_fd_sc_hd__o22a_2
X_3443_ _3664_/A _3754_/A _3812_/A _6464_/A1 _3652_/S _3791_/S VGND VGND VPWR VPWR
+ _3443_/X sky130_fd_sc_hd__mux4_2
X_6162_ _6162_/A _6162_/B VGND VGND VPWR VPWR _6167_/D sky130_fd_sc_hd__nand2_2
X_5113_ _5429_/A _5429_/B _5429_/C _5072_/D VGND VGND VPWR VPWR _5114_/B sky130_fd_sc_hd__o31a_2
X_3374_ _3260_/C _3356_/X _3360_/Y _3373_/X VGND VGND VPWR VPWR _3374_/X sky130_fd_sc_hd__a31o_2
X_6093_ _6014_/B _6090_/X _6091_/X _6092_/Y VGND VGND VPWR VPWR _6093_/X sky130_fd_sc_hd__a31o_2
XFILLER_69_177 VGND VGND VPWR VPWR sky130_fd_sc_hd__decap_3
Xload_slew585 _3515_/A VGND VGND VPWR VPWR _3349_/A sky130_fd_sc_hd__clkbuf_2
X_5044_ _3627_/X _3634_/X _5049_/S VGND VGND VPWR VPWR _5044_/X sky130_fd_sc_hd__mux2_2
XFILLER_65_383 VGND VGND VPWR VPWR sky130_fd_sc_hd__decap_3
XFILLER_25_225 VGND VGND VPWR VPWR sky130_fd_sc_hd__decap_3
XFILLER_25_269 VGND VGND VPWR VPWR sky130_fd_sc_hd__decap_3
XFILLER_40_206 VGND VGND VPWR VPWR sky130_fd_sc_hd__decap_3
X_5946_ _5918_/A _5932_/A _6428_/A2 _5946_/A3 _5963_/S0 _5963_/S1 VGND VGND VPWR VPWR
+ _5946_/X sky130_fd_sc_hd__mux4_2
X_5877_ _5923_/B _5923_/C _5923_/D VGND VGND VPWR VPWR _5877_/X sky130_fd_sc_hd__and3_2
X_4828_ _4975_/B _4828_/B VGND VGND VPWR VPWR _4828_/Y sky130_fd_sc_hd__xnor2_2
X_4759_ _4221_/X _4414_/X _4592_/X _4758_/X _5442_/S _6106_/A VGND VGND VPWR VPWR
+ _4759_/X sky130_fd_sc_hd__mux4_2
X_6429_ _6429_/A _6429_/B _6473_/S VGND VGND VPWR VPWR _6429_/X sky130_fd_sc_hd__or3_2
XFILLER_0_335 VGND VGND VPWR VPWR sky130_fd_sc_hd__fill_1
XFILLER_68_36 VGND VGND VPWR VPWR sky130_fd_sc_hd__fill_2
XFILLER_48_339 VGND VGND VPWR VPWR sky130_fd_sc_hd__decap_3
XFILLER_63_309 VGND VGND VPWR VPWR sky130_fd_sc_hd__decap_3
XFILLER_56_361 VGND VGND VPWR VPWR sky130_fd_sc_hd__decap_3
XTAP_TAPCELL_ROW_74_849 VGND VPWR sky130_fd_sc_hd__tapvpwrvgnd_1
XFILLER_56_394 VGND VGND VPWR VPWR sky130_fd_sc_hd__fill_2
XFILLER_31_217 VGND VGND VPWR VPWR sky130_fd_sc_hd__decap_3
XFILLER_71_364 VGND VGND VPWR VPWR sky130_fd_sc_hd__decap_3
XFILLER_31_228 VGND VGND VPWR VPWR sky130_fd_sc_hd__decap_3
XFILLER_39_328 VGND VGND VPWR VPWR sky130_fd_sc_hd__decap_3
XFILLER_54_309 VGND VGND VPWR VPWR sky130_fd_sc_hd__decap_3
XFILLER_62_342 VGND VGND VPWR VPWR sky130_fd_sc_hd__decap_3
XFILLER_22_206 VGND VGND VPWR VPWR sky130_fd_sc_hd__fill_2
X_5800_ _5216_/B _5510_/B _5740_/A VGND VGND VPWR VPWR _5800_/Y sky130_fd_sc_hd__o21ai_2
X_3992_ _3620_/X _3959_/Y _3991_/X VGND VGND VPWR VPWR _5993_/A sky130_fd_sc_hd__o21ai_2
XFILLER_22_228 VGND VGND VPWR VPWR sky130_fd_sc_hd__decap_3
X_5731_ _5731_/A _5753_/A VGND VGND VPWR VPWR _5731_/X sky130_fd_sc_hd__xor2_2
XTAP_TAPCELL_ROW_45_584 VGND VPWR sky130_fd_sc_hd__tapvpwrvgnd_1
XFILLER_30_250 VGND VGND VPWR VPWR sky130_fd_sc_hd__fill_2
X_5662_ _5506_/X _5661_/X _5662_/S VGND VGND VPWR VPWR _5662_/X sky130_fd_sc_hd__mux2_2
X_5593_ _5604_/A _5477_/A _5658_/C _5647_/A _5592_/Y VGND VGND VPWR VPWR _5593_/X
+ sky130_fd_sc_hd__a221o_2
X_4613_ _6232_/A _6192_/A _6221_/B _4489_/B _4487_/X VGND VGND VPWR VPWR _4613_/X
+ sky130_fd_sc_hd__a221o_2
X_4544_ _4544_/A _5534_/D VGND VGND VPWR VPWR _4545_/B sky130_fd_sc_hd__or2_2
X_6214_ _6162_/A _6156_/A _6156_/B _4259_/A VGND VGND VPWR VPWR _6214_/X sky130_fd_sc_hd__a31o_2
X_4475_ _5228_/A _5732_/B _4474_/X _5012_/C VGND VGND VPWR VPWR _4475_/X sky130_fd_sc_hd__a22o_2
X_3426_ _3348_/Y _3425_/X _3469_/S VGND VGND VPWR VPWR _3427_/B sky130_fd_sc_hd__mux2_2
X_6145_ _6464_/A1 input8/X _6151_/A _6131_/X VGND VGND VPWR VPWR _6145_/X sky130_fd_sc_hd__o211a_2
X_3357_ _6012_/B _3357_/B VGND VGND VPWR VPWR _3357_/Y sky130_fd_sc_hd__nand2_2
X_6076_ _5109_/B _6075_/X _6270_/C _4999_/B VGND VGND VPWR VPWR _6076_/X sky130_fd_sc_hd__a2bb2o_2
X_5027_ _6275_/A _6274_/A VGND VGND VPWR VPWR _5085_/A sky130_fd_sc_hd__and2b_2
X_3288_ _3276_/X _3279_/X _3284_/X _3287_/X _3572_/S _3803_/S VGND VGND VPWR VPWR
+ _3296_/A sky130_fd_sc_hd__mux4_2
XFILLER_57_169 VGND VGND VPWR VPWR sky130_fd_sc_hd__decap_3
XFILLER_38_361 VGND VGND VPWR VPWR sky130_fd_sc_hd__decap_3
XFILLER_53_320 VGND VGND VPWR VPWR sky130_fd_sc_hd__decap_3
XTAP_TAPCELL_ROW_71_819 VGND VPWR sky130_fd_sc_hd__tapvpwrvgnd_1
XTAP_TAPCELL_ROW_0_176 VGND VPWR sky130_fd_sc_hd__tapvpwrvgnd_1
XFILLER_53_386 VGND VGND VPWR VPWR sky130_fd_sc_hd__decap_3
X_5929_ _6497_/C VGND VGND VPWR VPWR _5929_/Y sky130_fd_sc_hd__inv_2
XTAP_TAPCELL_ROW_8_254 VGND VPWR sky130_fd_sc_hd__tapvpwrvgnd_1
XFILLER_48_136 VGND VGND VPWR VPWR sky130_fd_sc_hd__decap_3
XFILLER_48_147 VGND VGND VPWR VPWR sky130_fd_sc_hd__decap_3
XFILLER_29_361 VGND VGND VPWR VPWR sky130_fd_sc_hd__decap_3
XFILLER_32_515 VGND VGND VPWR VPWR sky130_fd_sc_hd__fill_1
XFILLER_44_342 VGND VGND VPWR VPWR sky130_fd_sc_hd__fill_2
XFILLER_44_71 VGND VGND VPWR VPWR sky130_fd_sc_hd__decap_3
XFILLER_71_194 VGND VGND VPWR VPWR sky130_fd_sc_hd__decap_3
XTAP_TAPCELL_ROW_42_554 VGND VPWR sky130_fd_sc_hd__tapvpwrvgnd_1
XFILLER_12_250 VGND VGND VPWR VPWR sky130_fd_sc_hd__fill_2
XFILLER_12_283 VGND VGND VPWR VPWR sky130_fd_sc_hd__decap_3
XFILLER_8_287 VGND VGND VPWR VPWR sky130_fd_sc_hd__decap_3
XFILLER_8_265 VGND VGND VPWR VPWR sky130_fd_sc_hd__fill_2
XFILLER_5_54 VGND VGND VPWR VPWR sky130_fd_sc_hd__fill_2
X_4260_ _4259_/A _4249_/A _4258_/Y _4259_/Y VGND VGND VPWR VPWR _4260_/X sky130_fd_sc_hd__a31o_2
X_4191_ _4461_/S VGND VGND VPWR VPWR _4191_/X sky130_fd_sc_hd__clkbuf_1
XFILLER_79_250 VGND VGND VPWR VPWR sky130_fd_sc_hd__decap_3
XFILLER_54_128 VGND VGND VPWR VPWR sky130_fd_sc_hd__decap_3
XFILLER_50_312 VGND VGND VPWR VPWR sky130_fd_sc_hd__decap_3
XFILLER_50_345 VGND VGND VPWR VPWR sky130_fd_sc_hd__decap_3
X_3975_ _3972_/X _3973_/X _5010_/S VGND VGND VPWR VPWR _3975_/X sky130_fd_sc_hd__mux2_2
XFILLER_62_194 VGND VGND VPWR VPWR sky130_fd_sc_hd__fill_2
XFILLER_50_389 VGND VGND VPWR VPWR sky130_fd_sc_hd__decap_3
X_5714_ _5714_/A _5714_/B VGND VGND VPWR VPWR _5714_/Y sky130_fd_sc_hd__nand2_2
X_5645_ _5643_/Y _5644_/Y _5604_/B VGND VGND VPWR VPWR _5646_/B sky130_fd_sc_hd__a21bo_2
X_5576_ _5712_/A _6333_/A _5503_/X _6330_/B _5575_/X VGND VGND VPWR VPWR _5576_/X
+ sky130_fd_sc_hd__a221o_2
X_4527_ _4527_/A VGND VGND VPWR VPWR _4527_/X sky130_fd_sc_hd__clkbuf_1
X_4458_ _4220_/X _4277_/X _4460_/S VGND VGND VPWR VPWR _4458_/X sky130_fd_sc_hd__mux2_2
X_3409_ _3410_/B _3371_/A VGND VGND VPWR VPWR _3409_/X sky130_fd_sc_hd__or2b_2
X_6128_ _6131_/A _6144_/C VGND VGND VPWR VPWR _6128_/Y sky130_fd_sc_hd__nor2_2
X_4389_ _4449_/A _4389_/B VGND VGND VPWR VPWR _4390_/B sky130_fd_sc_hd__xnor2_2
XTAP_TAPCELL_ROW_5_224 VGND VPWR sky130_fd_sc_hd__tapvpwrvgnd_1
XFILLER_58_401 VGND VGND VPWR VPWR sky130_fd_sc_hd__decap_3
X_6059_ _6059_/A _6059_/B _6059_/C VGND VGND VPWR VPWR _6061_/C sky130_fd_sc_hd__and3_2
XFILLER_38_180 VGND VGND VPWR VPWR sky130_fd_sc_hd__decap_3
XFILLER_45_128 VGND VGND VPWR VPWR sky130_fd_sc_hd__fill_2
XFILLER_45_139 VGND VGND VPWR VPWR sky130_fd_sc_hd__decap_3
XTAP_TAPCELL_ROW_56_679 VGND VPWR sky130_fd_sc_hd__tapvpwrvgnd_1
XFILLER_26_397 VGND VGND VPWR VPWR sky130_fd_sc_hd__decap_3
XFILLER_41_323 VGND VGND VPWR VPWR sky130_fd_sc_hd__decap_3
XFILLER_53_194 VGND VGND VPWR VPWR sky130_fd_sc_hd__decap_3
XFILLER_30_95 VGND VGND VPWR VPWR sky130_fd_sc_hd__decap_3
XFILLER_49_467 VGND VGND VPWR VPWR sky130_fd_sc_hd__fill_2
XFILLER_76_220 VGND VGND VPWR VPWR sky130_fd_sc_hd__decap_3
XTAP_TAPCELL_ROW_47_602 VGND VPWR sky130_fd_sc_hd__tapvpwrvgnd_1
XFILLER_76_253 VGND VGND VPWR VPWR sky130_fd_sc_hd__decap_3
XFILLER_36_128 VGND VGND VPWR VPWR sky130_fd_sc_hd__fill_2
XFILLER_36_139 VGND VGND VPWR VPWR sky130_fd_sc_hd__fill_1
XFILLER_76_297 VGND VGND VPWR VPWR sky130_fd_sc_hd__decap_3
XFILLER_17_364 VGND VGND VPWR VPWR sky130_fd_sc_hd__decap_3
XTAP_TAPCELL_ROW_19_348 VGND VPWR sky130_fd_sc_hd__tapvpwrvgnd_1
X_3760_ _3760_/A _6426_/A VGND VGND VPWR VPWR _3760_/Y sky130_fd_sc_hd__nor2_2
X_5430_ _5278_/Y _5429_/X _5423_/B VGND VGND VPWR VPWR _5434_/B sky130_fd_sc_hd__a21o_2
X_3691_ _3691_/A _3691_/B VGND VGND VPWR VPWR _3856_/C sky130_fd_sc_hd__xnor2_2
XTAP_TAPCELL_ROW_10_270 VGND VPWR sky130_fd_sc_hd__tapvpwrvgnd_1
XFILLER_65_3 VGND VGND VPWR VPWR sky130_fd_sc_hd__decap_3
X_5361_ _5628_/A _5361_/B VGND VGND VPWR VPWR _5361_/Y sky130_fd_sc_hd__nor2_2
X_5292_ _3933_/X _4841_/Y _5291_/X _5263_/A _5061_/A VGND VGND VPWR VPWR _5294_/A
+ sky130_fd_sc_hd__o221a_2
X_4312_ _4312_/A VGND VGND VPWR VPWR _4312_/X sky130_fd_sc_hd__clkbuf_1
X_4243_ _4606_/A _4237_/X _4242_/X _4339_/A VGND VGND VPWR VPWR _4243_/X sky130_fd_sc_hd__a2bb2o_2
X_4174_ _6167_/B _4174_/B VGND VGND VPWR VPWR _4174_/Y sky130_fd_sc_hd__xnor2_2
XFILLER_27_106 VGND VGND VPWR VPWR sky130_fd_sc_hd__decap_3
XFILLER_67_253 VGND VGND VPWR VPWR sky130_fd_sc_hd__decap_3
XFILLER_82_278 VGND VGND VPWR VPWR sky130_fd_sc_hd__fill_2
XFILLER_82_256 VGND VGND VPWR VPWR sky130_fd_sc_hd__fill_1
XFILLER_35_183 VGND VGND VPWR VPWR sky130_fd_sc_hd__decap_3
X_3958_ _6151_/B _3912_/B _3957_/X VGND VGND VPWR VPWR _3959_/B sky130_fd_sc_hd__o21ai_2
X_3889_ _4019_/A _4156_/A _3908_/A VGND VGND VPWR VPWR _3889_/X sky130_fd_sc_hd__mux2_2
X_5628_ _5628_/A _5628_/B _5628_/C VGND VGND VPWR VPWR _5628_/X sky130_fd_sc_hd__or3_2
X_5559_ _5609_/A _5555_/X _5558_/Y wire230/X VGND VGND VPWR VPWR _5559_/X sky130_fd_sc_hd__a211o_2
Xfanout520 input41/X VGND VGND VPWR VPWR _5281_/A3 sky130_fd_sc_hd__clkdlybuf4s25_1
Xfanout531 input38/X VGND VGND VPWR VPWR _5096_/A sky130_fd_sc_hd__clkdlybuf4s25_1
Xfanout542 _6447_/A3 VGND VGND VPWR VPWR _4923_/B sky130_fd_sc_hd__clkdlybuf4s25_1
Xfanout553 _6460_/A1 VGND VGND VPWR VPWR _4734_/A sky130_fd_sc_hd__clkdlybuf4s25_1
Xfanout564 input24/X VGND VGND VPWR VPWR _6193_/S sky130_fd_sc_hd__clkdlybuf4s25_1
Xfanout586 _3638_/A VGND VGND VPWR VPWR _3292_/A sky130_fd_sc_hd__clkdlybuf4s25_1
Xfanout597 input15/X VGND VGND VPWR VPWR _6458_/A1 sky130_fd_sc_hd__clkdlybuf4s25_1
XFILLER_58_253 VGND VGND VPWR VPWR sky130_fd_sc_hd__decap_3
XFILLER_73_234 VGND VGND VPWR VPWR sky130_fd_sc_hd__decap_3
XFILLER_61_407 VGND VGND VPWR VPWR sky130_fd_sc_hd__decap_3
XFILLER_14_312 VGND VGND VPWR VPWR sky130_fd_sc_hd__fill_1
XFILLER_26_183 VGND VGND VPWR VPWR sky130_fd_sc_hd__decap_3
XFILLER_14_378 VGND VGND VPWR VPWR sky130_fd_sc_hd__decap_3
XFILLER_41_175 VGND VGND VPWR VPWR sky130_fd_sc_hd__decap_3
XTAP_TAPCELL_ROW_24_395 VGND VPWR sky130_fd_sc_hd__tapvpwrvgnd_1
XFILLER_2_66 VGND VGND VPWR VPWR sky130_fd_sc_hd__decap_3
XFILLER_37_415 VGND VGND VPWR VPWR sky130_fd_sc_hd__fill_1
XFILLER_49_275 VGND VGND VPWR VPWR sky130_fd_sc_hd__decap_3
XFILLER_37_437 VGND VGND VPWR VPWR sky130_fd_sc_hd__decap_3
XFILLER_64_212 VGND VGND VPWR VPWR sky130_fd_sc_hd__decap_3
XFILLER_17_172 VGND VGND VPWR VPWR sky130_fd_sc_hd__fill_2
X_4930_ _5509_/B _3901_/B _3455_/X _4842_/B VGND VGND VPWR VPWR _4930_/X sky130_fd_sc_hd__a22o_2
X_4861_ _4900_/A _6077_/A VGND VGND VPWR VPWR _4919_/B sky130_fd_sc_hd__and2b_2
X_3812_ _3812_/A _6088_/A VGND VGND VPWR VPWR _3812_/X sky130_fd_sc_hd__or2b_2
XANTENNA_16 _5352_/C VGND VGND VPWR VPWR sky130_fd_sc_hd__diode_2
XANTENNA_27 _6148_/B VGND VGND VPWR VPWR sky130_fd_sc_hd__diode_2
XANTENNA_38 _3638_/A VGND VGND VPWR VPWR sky130_fd_sc_hd__diode_2
XFILLER_32_186 VGND VGND VPWR VPWR sky130_fd_sc_hd__fill_1
XFILLER_32_197 VGND VGND VPWR VPWR sky130_fd_sc_hd__decap_3
X_4792_ _5859_/A _5136_/A VGND VGND VPWR VPWR _5740_/A sky130_fd_sc_hd__nand2_2
XFILLER_60_484 VGND VGND VPWR VPWR sky130_fd_sc_hd__fill_1
X_3743_ _3467_/B _3666_/C _6106_/B _3566_/X _3742_/X VGND VGND VPWR VPWR _3743_/Y
+ sky130_fd_sc_hd__o311ai_2
X_6462_ _6460_/X _6461_/X _6469_/S VGND VGND VPWR VPWR _6462_/X sky130_fd_sc_hd__mux2_2
X_3674_ _6090_/A _3670_/X _3671_/X _3672_/X _3673_/X VGND VGND VPWR VPWR _3674_/X
+ sky130_fd_sc_hd__a311o_2
XFILLER_9_393 VGND VGND VPWR VPWR sky130_fd_sc_hd__fill_1
X_6393_ _6393_/A _6393_/B _6393_/C VGND VGND VPWR VPWR _6393_/X sky130_fd_sc_hd__and3_2
X_5413_ _6363_/A _5416_/A _5418_/B VGND VGND VPWR VPWR _6290_/A sky130_fd_sc_hd__or3_2
Xoutput134 _6489_/X VGND VGND VPWR VPWR carry_out sky130_fd_sc_hd__clkdlybuf4s25_1
X_5344_ _5278_/Y _5422_/B _5425_/B VGND VGND VPWR VPWR _5416_/C sky130_fd_sc_hd__o21a_2
Xoutput145 _5985_/A VGND VGND VPWR VPWR result[17] sky130_fd_sc_hd__clkdlybuf4s25_1
Xoutput156 _5995_/B VGND VGND VPWR VPWR result[27] sky130_fd_sc_hd__clkdlybuf4s25_1
Xoutput167 _5985_/B VGND VGND VPWR VPWR result[37] sky130_fd_sc_hd__clkdlybuf4s25_1
Xoutput178 _6002_/A VGND VGND VPWR VPWR result[47] sky130_fd_sc_hd__clkdlybuf4s25_1
Xoutput189 _6003_/B VGND VGND VPWR VPWR result[57] sky130_fd_sc_hd__clkdlybuf4s25_1
X_5275_ _6391_/A _5144_/B _5160_/A _5159_/A _5223_/X VGND VGND VPWR VPWR _5277_/C
+ sky130_fd_sc_hd__a311o_2
X_4226_ _6427_/A _4219_/X _5552_/B VGND VGND VPWR VPWR _4226_/X sky130_fd_sc_hd__a21bo_2
X_4157_ _4681_/A0 _4681_/A1 _4181_/A VGND VGND VPWR VPWR _4157_/X sky130_fd_sc_hd__mux2_2
XFILLER_55_234 VGND VGND VPWR VPWR sky130_fd_sc_hd__decap_3
XFILLER_55_245 VGND VGND VPWR VPWR sky130_fd_sc_hd__fill_1
X_4088_ _4120_/A _4120_/B _4120_/C _4120_/D VGND VGND VPWR VPWR _4174_/B sky130_fd_sc_hd__nor4_4
XTAP_TAPCELL_ROW_66_774 VGND VPWR sky130_fd_sc_hd__tapvpwrvgnd_1
XFILLER_70_215 VGND VGND VPWR VPWR sky130_fd_sc_hd__decap_3
XFILLER_70_259 VGND VGND VPWR VPWR sky130_fd_sc_hd__decap_3
XFILLER_70_248 VGND VGND VPWR VPWR sky130_fd_sc_hd__decap_3
XFILLER_62_27 VGND VGND VPWR VPWR sky130_fd_sc_hd__fill_1
XFILLER_62_38 VGND VGND VPWR VPWR sky130_fd_sc_hd__fill_1
XFILLER_11_359 VGND VGND VPWR VPWR sky130_fd_sc_hd__decap_3
Xwire217 _4971_/S VGND VGND VPWR VPWR _5662_/S sky130_fd_sc_hd__clkbuf_4
Xwire239 _4513_/B VGND VGND VPWR VPWR _5038_/A sky130_fd_sc_hd__buf_2
XTAP_TAPCELL_ROW_21_365 VGND VPWR sky130_fd_sc_hd__tapvpwrvgnd_1
Xfanout350 _6100_/B VGND VGND VPWR VPWR _3394_/B sky130_fd_sc_hd__clkdlybuf4s25_1
Xfanout361 _6233_/A VGND VGND VPWR VPWR _6192_/A sky130_fd_sc_hd__clkdlybuf4s25_1
XFILLER_46_223 VGND VGND VPWR VPWR sky130_fd_sc_hd__decap_3
Xfanout394 _3791_/S VGND VGND VPWR VPWR _3327_/S sky130_fd_sc_hd__clkdlybuf4s25_1
XFILLER_46_256 VGND VGND VPWR VPWR sky130_fd_sc_hd__decap_3
XTAP_TAPCELL_ROW_29_443 VGND VPWR sky130_fd_sc_hd__tapvpwrvgnd_1
XFILLER_46_289 VGND VGND VPWR VPWR sky130_fd_sc_hd__decap_3
XFILLER_14_131 VGND VGND VPWR VPWR sky130_fd_sc_hd__fill_1
XFILLER_36_83 VGND VGND VPWR VPWR sky130_fd_sc_hd__fill_1
XFILLER_61_237 VGND VGND VPWR VPWR sky130_fd_sc_hd__decap_3
XFILLER_14_153 VGND VGND VPWR VPWR sky130_fd_sc_hd__fill_2
XFILLER_14_197 VGND VGND VPWR VPWR sky130_fd_sc_hd__decap_3
Xinput36 operand_a[37] VGND VGND VPWR VPWR input36/X sky130_fd_sc_hd__clkdlybuf4s25_1
Xinput25 operand_a[27] VGND VGND VPWR VPWR input25/X sky130_fd_sc_hd__clkdlybuf4s25_1
Xinput14 operand_a[17] VGND VGND VPWR VPWR input14/X sky130_fd_sc_hd__clkdlybuf4s25_1
Xinput69 operand_a[9] VGND VGND VPWR VPWR input69/X sky130_fd_sc_hd__clkdlybuf4s25_1
Xinput58 operand_a[57] VGND VGND VPWR VPWR input58/X sky130_fd_sc_hd__clkdlybuf4s25_1
Xinput47 operand_a[47] VGND VGND VPWR VPWR input47/X sky130_fd_sc_hd__clkdlybuf4s25_1
X_3390_ _5712_/A _6440_/A3 _6440_/A2 _6431_/A0 _3499_/S1 _3631_/S1 VGND VGND VPWR
+ VPWR _3459_/B sky130_fd_sc_hd__mux4_2
XFILLER_69_326 VGND VGND VPWR VPWR sky130_fd_sc_hd__decap_3
X_5060_ _5007_/A _5052_/X _5059_/X _4926_/A VGND VGND VPWR VPWR _5061_/C sky130_fd_sc_hd__o22a_2
XFILLER_69_337 VGND VGND VPWR VPWR sky130_fd_sc_hd__decap_3
X_4011_ _5962_/A _6476_/A _6453_/B VGND VGND VPWR VPWR _4011_/X sky130_fd_sc_hd__mux2_2
XFILLER_37_212 VGND VGND VPWR VPWR sky130_fd_sc_hd__fill_1
XFILLER_37_223 VGND VGND VPWR VPWR sky130_fd_sc_hd__fill_1
XFILLER_37_245 VGND VGND VPWR VPWR sky130_fd_sc_hd__decap_3
XFILLER_52_215 VGND VGND VPWR VPWR sky130_fd_sc_hd__decap_3
X_5962_ _5962_/A _5962_/B VGND VGND VPWR VPWR _5975_/C sky130_fd_sc_hd__nand2_2
X_4913_ _4440_/X _4442_/X _4784_/X VGND VGND VPWR VPWR _4913_/Y sky130_fd_sc_hd__a21oi_2
XTAP_TAPCELL_ROW_63_744 VGND VPWR sky130_fd_sc_hd__tapvpwrvgnd_1
XFILLER_33_440 VGND VGND VPWR VPWR sky130_fd_sc_hd__fill_1
X_5893_ _5853_/B _6496_/C VGND VGND VPWR VPWR _5894_/B sky130_fd_sc_hd__and2b_2
XFILLER_20_112 VGND VGND VPWR VPWR sky130_fd_sc_hd__decap_3
X_4844_ _4819_/B _4916_/C _4975_/B VGND VGND VPWR VPWR _4844_/X sky130_fd_sc_hd__mux2_2
XFILLER_60_281 VGND VGND VPWR VPWR sky130_fd_sc_hd__decap_3
X_4775_ _4454_/A _4454_/B _4774_/X VGND VGND VPWR VPWR _4776_/B sky130_fd_sc_hd__a21o_2
X_3726_ _3860_/B _3745_/A VGND VGND VPWR VPWR _3727_/C sky130_fd_sc_hd__nor2_2
X_6445_ _6437_/X _6441_/X _6469_/S VGND VGND VPWR VPWR _6445_/X sky130_fd_sc_hd__mux2_2
X_3657_ _3650_/X _3656_/X _3803_/S VGND VGND VPWR VPWR _3658_/B sky130_fd_sc_hd__mux2_2
X_6376_ _6376_/A _6376_/B VGND VGND VPWR VPWR _6376_/X sky130_fd_sc_hd__and2_2
X_3588_ _3625_/B _3587_/X _3596_/S VGND VGND VPWR VPWR _3588_/X sky130_fd_sc_hd__mux2_2
X_5327_ wire227/X _3980_/X _5326_/X _4761_/X _4726_/S VGND VGND VPWR VPWR _5327_/X
+ sky130_fd_sc_hd__a221o_2
X_5258_ _5258_/A _5258_/B _5258_/C VGND VGND VPWR VPWR _5259_/B sky130_fd_sc_hd__nand3_2
XFILLER_28_212 VGND VGND VPWR VPWR sky130_fd_sc_hd__decap_3
X_5189_ _4848_/A _5172_/B _5188_/X _4849_/C input4/X VGND VGND VPWR VPWR _5189_/X
+ sky130_fd_sc_hd__a2111o_2
X_4209_ _4497_/A _4187_/Y _4195_/X _4295_/A1 _4208_/X VGND VGND VPWR VPWR _4209_/Y
+ sky130_fd_sc_hd__o221ai_2
XFILLER_28_234 VGND VGND VPWR VPWR sky130_fd_sc_hd__decap_3
XFILLER_16_407 VGND VGND VPWR VPWR sky130_fd_sc_hd__fill_1
XTAP_TAPCELL_ROW_26_413 VGND VPWR sky130_fd_sc_hd__tapvpwrvgnd_1
XFILLER_43_259 VGND VGND VPWR VPWR sky130_fd_sc_hd__decap_3
XFILLER_51_270 VGND VGND VPWR VPWR sky130_fd_sc_hd__decap_3
XFILLER_66_318 VGND VGND VPWR VPWR sky130_fd_sc_hd__fill_1
XFILLER_66_307 VGND VGND VPWR VPWR sky130_fd_sc_hd__fill_1
XTAP_TAPCELL_ROW_77_869 VGND VPWR sky130_fd_sc_hd__tapvpwrvgnd_1
XFILLER_74_351 VGND VGND VPWR VPWR sky130_fd_sc_hd__fill_1
XFILLER_19_267 VGND VGND VPWR VPWR sky130_fd_sc_hd__fill_1
XFILLER_34_237 VGND VGND VPWR VPWR sky130_fd_sc_hd__decap_3
XFILLER_34_259 VGND VGND VPWR VPWR sky130_fd_sc_hd__decap_3
X_4560_ _4560_/A VGND VGND VPWR VPWR _4560_/Y sky130_fd_sc_hd__inv_2
Xmax_cap325 _6152_/B VGND VGND VPWR VPWR _6154_/B sky130_fd_sc_hd__buf_2
Xmax_cap314 _3784_/A VGND VGND VPWR VPWR _3803_/S sky130_fd_sc_hd__buf_2
Xmax_cap303 _4515_/A VGND VGND VPWR VPWR _4681_/A1 sky130_fd_sc_hd__clkbuf_2
X_4491_ _4546_/A _6189_/B VGND VGND VPWR VPWR _4540_/C sky130_fd_sc_hd__xor2_2
X_3511_ _3679_/A _3479_/A _3479_/C _6113_/B VGND VGND VPWR VPWR _3547_/C sky130_fd_sc_hd__a31o_2
X_6230_ _6192_/A _6229_/X _6228_/X VGND VGND VPWR VPWR _6230_/X sky130_fd_sc_hd__o21a_2
X_3442_ _3376_/X _3441_/X _6100_/A VGND VGND VPWR VPWR _3442_/X sky130_fd_sc_hd__mux2_2
X_6161_ _6161_/A _6161_/B VGND VGND VPWR VPWR _6161_/Y sky130_fd_sc_hd__xnor2_2
X_3373_ _3363_/Y _3366_/X _3370_/X _3372_/X VGND VGND VPWR VPWR _3373_/X sky130_fd_sc_hd__a2bb2o_2
X_5112_ _4485_/A _4485_/B _4784_/X _5162_/B VGND VGND VPWR VPWR _5117_/B sky130_fd_sc_hd__a211o_2
X_6092_ _3637_/Y _3728_/A _6090_/X VGND VGND VPWR VPWR _6092_/Y sky130_fd_sc_hd__a21oi_2
XFILLER_69_167 VGND VGND VPWR VPWR sky130_fd_sc_hd__fill_1
XFILLER_57_318 VGND VGND VPWR VPWR sky130_fd_sc_hd__decap_3
X_5043_ _5042_/A _5051_/A _5123_/B _5042_/Y VGND VGND VPWR VPWR _5043_/X sky130_fd_sc_hd__o31a_2
XFILLER_25_204 VGND VGND VPWR VPWR sky130_fd_sc_hd__decap_3
XFILLER_65_362 VGND VGND VPWR VPWR sky130_fd_sc_hd__decap_3
XFILLER_25_259 VGND VGND VPWR VPWR sky130_fd_sc_hd__decap_3
X_5945_ _4712_/X _4885_/X _5940_/X _6486_/C _5944_/X VGND VGND VPWR VPWR _5945_/X
+ sky130_fd_sc_hd__a221o_2
XFILLER_80_365 VGND VGND VPWR VPWR sky130_fd_sc_hd__fill_2
XFILLER_33_270 VGND VGND VPWR VPWR sky130_fd_sc_hd__fill_1
XFILLER_33_281 VGND VGND VPWR VPWR sky130_fd_sc_hd__decap_3
XFILLER_40_218 VGND VGND VPWR VPWR sky130_fd_sc_hd__decap_3
X_5876_ _5847_/B _5849_/Y _5874_/B VGND VGND VPWR VPWR _5923_/D sky130_fd_sc_hd__a21o_2
X_4827_ _4854_/A _4854_/B _4826_/Y VGND VGND VPWR VPWR _4828_/B sky130_fd_sc_hd__a21oi_2
XTAP_TAPCELL_ROW_31_460 VGND VPWR sky130_fd_sc_hd__tapvpwrvgnd_1
X_4758_ _4751_/A _4734_/A _6460_/A3 _4679_/A _5008_/S0 wire372/X VGND VGND VPWR VPWR
+ _4758_/X sky130_fd_sc_hd__mux4_2
X_4689_ wire227/X _4673_/X _4678_/X _4761_/A _4688_/X VGND VGND VPWR VPWR _4689_/Y
+ sky130_fd_sc_hd__a221oi_2
X_3709_ _4150_/A _3748_/B _3704_/Y _3708_/Y VGND VGND VPWR VPWR _3710_/C sky130_fd_sc_hd__a31o_2
X_6428_ _6428_/A0 input60/X _6428_/A2 _4422_/A _6438_/A _6463_/S VGND VGND VPWR VPWR
+ _6428_/X sky130_fd_sc_hd__mux4_2
X_6359_ _6359_/A _6359_/B VGND VGND VPWR VPWR _6359_/X sky130_fd_sc_hd__or2_2
XFILLER_68_59 VGND VGND VPWR VPWR sky130_fd_sc_hd__fill_2
XFILLER_48_318 VGND VGND VPWR VPWR sky130_fd_sc_hd__decap_3
XFILLER_24_281 VGND VGND VPWR VPWR sky130_fd_sc_hd__decap_3
XFILLER_12_443 VGND VGND VPWR VPWR sky130_fd_sc_hd__fill_1
XFILLER_47_340 VGND VGND VPWR VPWR sky130_fd_sc_hd__decap_3
XTAP_TAPCELL_ROW_37_508 VGND VPWR sky130_fd_sc_hd__tapvpwrvgnd_1
XFILLER_47_384 VGND VGND VPWR VPWR sky130_fd_sc_hd__decap_3
XFILLER_62_321 VGND VGND VPWR VPWR sky130_fd_sc_hd__decap_3
X_3991_ _4611_/A _3969_/X _3990_/Y VGND VGND VPWR VPWR _3991_/X sky130_fd_sc_hd__o21a_2
XFILLER_62_365 VGND VGND VPWR VPWR sky130_fd_sc_hd__decap_3
X_5730_ _6374_/C _5727_/X _5729_/X _5693_/X VGND VGND VPWR VPWR _5753_/A sky130_fd_sc_hd__a22o_2
XTAP_TAPCELL_ROW_45_585 VGND VPWR sky130_fd_sc_hd__tapvpwrvgnd_1
XFILLER_15_281 VGND VGND VPWR VPWR sky130_fd_sc_hd__fill_1
XFILLER_30_273 VGND VGND VPWR VPWR sky130_fd_sc_hd__decap_3
X_5661_ _6440_/A1 _6440_/A3 _6440_/A0 _6439_/A2 _5801_/S0 _5801_/S1 VGND VGND VPWR
+ VPWR _5661_/X sky130_fd_sc_hd__mux4_2
X_5592_ _5906_/A1 _5566_/B _5591_/X VGND VGND VPWR VPWR _5592_/Y sky130_fd_sc_hd__a21oi_2
X_4612_ _4743_/A _5534_/B _4612_/C _4743_/C VGND VGND VPWR VPWR _4623_/A sky130_fd_sc_hd__or4_2
X_4543_ _4586_/A _4586_/B _4707_/C VGND VGND VPWR VPWR _5534_/D sky130_fd_sc_hd__or3b_2
X_6213_ _6213_/A _6213_/B VGND VGND VPWR VPWR _6213_/Y sky130_fd_sc_hd__nor2_2
X_4474_ _4513_/A _5099_/B _4469_/X _4471_/X _4473_/Y VGND VGND VPWR VPWR _4474_/X
+ sky130_fd_sc_hd__a221o_2
X_3425_ _3464_/A _3264_/A _3520_/S VGND VGND VPWR VPWR _3425_/X sky130_fd_sc_hd__mux2_2
X_6144_ _6151_/A _6144_/B _6144_/C VGND VGND VPWR VPWR _6144_/Y sky130_fd_sc_hd__nor3_2
X_3356_ _3369_/B _3343_/X _3346_/Y _3351_/X _3355_/X VGND VGND VPWR VPWR _3356_/X
+ sky130_fd_sc_hd__a311o_2
X_6075_ _4943_/S _6270_/C _6056_/Y VGND VGND VPWR VPWR _6075_/X sky130_fd_sc_hd__o21ba_2
Xload_slew383 _3590_/B VGND VGND VPWR VPWR _6439_/S0 sky130_fd_sc_hd__buf_4
X_3287_ _3285_/X _3286_/X _3529_/S VGND VGND VPWR VPWR _3287_/X sky130_fd_sc_hd__mux2_2
X_5026_ _6274_/A _6275_/A VGND VGND VPWR VPWR _5087_/A sky130_fd_sc_hd__and2b_2
XFILLER_53_332 VGND VGND VPWR VPWR sky130_fd_sc_hd__decap_3
XFILLER_65_181 VGND VGND VPWR VPWR sky130_fd_sc_hd__decap_3
XFILLER_41_505 VGND VGND VPWR VPWR sky130_fd_sc_hd__fill_1
XFILLER_53_343 VGND VGND VPWR VPWR sky130_fd_sc_hd__fill_1
XFILLER_53_365 VGND VGND VPWR VPWR sky130_fd_sc_hd__decap_3
XTAP_TAPCELL_ROW_0_177 VGND VPWR sky130_fd_sc_hd__tapvpwrvgnd_1
XTAP_TAPCELL_ROW_0_166 VGND VPWR sky130_fd_sc_hd__tapvpwrvgnd_1
X_5928_ _6419_/B _5890_/Y _5921_/Y _5924_/X _5927_/Y VGND VGND VPWR VPWR _6497_/C
+ sky130_fd_sc_hd__o311a_2
XFILLER_80_195 VGND VGND VPWR VPWR sky130_fd_sc_hd__fill_1
X_5859_ _5859_/A _5859_/B VGND VGND VPWR VPWR _5859_/Y sky130_fd_sc_hd__nand2_2
XFILLER_21_284 VGND VGND VPWR VPWR sky130_fd_sc_hd__decap_3
XFILLER_0_144 VGND VGND VPWR VPWR sky130_fd_sc_hd__fill_1
XTAP_TAPCELL_ROW_8_255 VGND VPWR sky130_fd_sc_hd__tapvpwrvgnd_1
XFILLER_48_159 VGND VGND VPWR VPWR sky130_fd_sc_hd__decap_3
XFILLER_29_373 VGND VGND VPWR VPWR sky130_fd_sc_hd__decap_3
XFILLER_44_321 VGND VGND VPWR VPWR sky130_fd_sc_hd__decap_3
XFILLER_32_505 VGND VGND VPWR VPWR sky130_fd_sc_hd__fill_2
XFILLER_44_354 VGND VGND VPWR VPWR sky130_fd_sc_hd__decap_3
XFILLER_44_365 VGND VGND VPWR VPWR sky130_fd_sc_hd__decap_3
XTAP_TAPCELL_ROW_42_555 VGND VPWR sky130_fd_sc_hd__tapvpwrvgnd_1
XFILLER_5_66 VGND VGND VPWR VPWR sky130_fd_sc_hd__fill_1
X_4190_ _4138_/X _4189_/X _4460_/S VGND VGND VPWR VPWR _4190_/X sky130_fd_sc_hd__mux2_2
XFILLER_79_262 VGND VGND VPWR VPWR sky130_fd_sc_hd__decap_3
XFILLER_10_3 VGND VGND VPWR VPWR sky130_fd_sc_hd__decap_3
XFILLER_39_137 VGND VGND VPWR VPWR sky130_fd_sc_hd__decap_3
XFILLER_35_310 VGND VGND VPWR VPWR sky130_fd_sc_hd__decap_3
XFILLER_47_181 VGND VGND VPWR VPWR sky130_fd_sc_hd__decap_3
XFILLER_35_365 VGND VGND VPWR VPWR sky130_fd_sc_hd__decap_3
XFILLER_62_151 VGND VGND VPWR VPWR sky130_fd_sc_hd__decap_3
XFILLER_50_324 VGND VGND VPWR VPWR sky130_fd_sc_hd__decap_3
XFILLER_50_357 VGND VGND VPWR VPWR sky130_fd_sc_hd__decap_3
X_3974_ _4102_/A VGND VGND VPWR VPWR _5010_/S sky130_fd_sc_hd__clkbuf_2
XFILLER_50_368 VGND VGND VPWR VPWR sky130_fd_sc_hd__decap_3
X_5713_ _5532_/A _5532_/B _5532_/C _5712_/Y VGND VGND VPWR VPWR _5713_/X sky130_fd_sc_hd__a31o_2
X_5644_ _5647_/A _5712_/C VGND VGND VPWR VPWR _5644_/Y sky130_fd_sc_hd__nand2_2
X_5575_ _6330_/B _5503_/X _6317_/S VGND VGND VPWR VPWR _5575_/X sky130_fd_sc_hd__o21a_2
X_4526_ _4526_/A VGND VGND VPWR VPWR _4527_/A sky130_fd_sc_hd__clkbuf_1
X_4457_ _4457_/A VGND VGND VPWR VPWR _4457_/Y sky130_fd_sc_hd__inv_2
X_3408_ _6012_/B _3412_/A VGND VGND VPWR VPWR _3408_/Y sky130_fd_sc_hd__nand2b_2
X_6127_ _6127_/A VGND VGND VPWR VPWR _6144_/C sky130_fd_sc_hd__buf_1
X_4388_ _4385_/X _4386_/X _4449_/B _4315_/Y VGND VGND VPWR VPWR _4389_/B sky130_fd_sc_hd__a22o_2
XTAP_TAPCELL_ROW_5_225 VGND VPWR sky130_fd_sc_hd__tapvpwrvgnd_1
XFILLER_58_413 VGND VGND VPWR VPWR sky130_fd_sc_hd__decap_3
X_3339_ _3515_/B _3417_/A VGND VGND VPWR VPWR _3339_/Y sky130_fd_sc_hd__nor2_2
X_6058_ _4900_/A _6053_/Y _6057_/X VGND VGND VPWR VPWR _6262_/A sky130_fd_sc_hd__a21o_2
XFILLER_65_38 VGND VGND VPWR VPWR sky130_fd_sc_hd__fill_2
X_5009_ _4674_/X _4675_/X _4832_/X _5008_/X _4721_/S _4140_/A VGND VGND VPWR VPWR
+ _5009_/X sky130_fd_sc_hd__mux4_2
XFILLER_73_449 VGND VGND VPWR VPWR sky130_fd_sc_hd__fill_2
XFILLER_26_365 VGND VGND VPWR VPWR sky130_fd_sc_hd__decap_3
XFILLER_41_302 VGND VGND VPWR VPWR sky130_fd_sc_hd__decap_3
XFILLER_53_151 VGND VGND VPWR VPWR sky130_fd_sc_hd__decap_3
XFILLER_41_335 VGND VGND VPWR VPWR sky130_fd_sc_hd__fill_1
XFILLER_41_357 VGND VGND VPWR VPWR sky130_fd_sc_hd__decap_3
XFILLER_14_42 VGND VGND VPWR VPWR sky130_fd_sc_hd__fill_1
XFILLER_14_97 VGND VGND VPWR VPWR sky130_fd_sc_hd__decap_3
XFILLER_5_269 VGND VGND VPWR VPWR sky130_fd_sc_hd__fill_2
XFILLER_49_402 VGND VGND VPWR VPWR sky130_fd_sc_hd__decap_3
XFILLER_76_232 VGND VGND VPWR VPWR sky130_fd_sc_hd__decap_3
XTAP_TAPCELL_ROW_47_603 VGND VPWR sky130_fd_sc_hd__tapvpwrvgnd_1
XFILLER_29_181 VGND VGND VPWR VPWR sky130_fd_sc_hd__decap_3
XFILLER_55_60 VGND VGND VPWR VPWR sky130_fd_sc_hd__fill_1
XTAP_TAPCELL_ROW_19_349 VGND VPWR sky130_fd_sc_hd__tapvpwrvgnd_1
XFILLER_44_162 VGND VGND VPWR VPWR sky130_fd_sc_hd__decap_3
X_3690_ _3855_/A _3855_/B VGND VGND VPWR VPWR _3777_/C sky130_fd_sc_hd__nor2_2
X_5360_ _5360_/A _5360_/B VGND VGND VPWR VPWR _5361_/B sky130_fd_sc_hd__xnor2_2
XTAP_TAPCELL_ROW_10_271 VGND VPWR sky130_fd_sc_hd__tapvpwrvgnd_1
XFILLER_58_3 VGND VGND VPWR VPWR sky130_fd_sc_hd__fill_2
X_5291_ _5939_/A _5286_/Y _5287_/Y _5289_/X _5290_/Y VGND VGND VPWR VPWR _5291_/X
+ sky130_fd_sc_hd__o221a_2
X_4311_ _4352_/A _4357_/S _4355_/C VGND VGND VPWR VPWR _4311_/X sky130_fd_sc_hd__o21a_2
X_4242_ _4238_/B _4111_/A _4238_/X _4240_/X _4241_/X VGND VGND VPWR VPWR _4242_/X
+ sky130_fd_sc_hd__a221o_2
X_4173_ _4267_/A _4263_/B VGND VGND VPWR VPWR _4211_/B sky130_fd_sc_hd__xnor2_2
XFILLER_67_243 VGND VGND VPWR VPWR sky130_fd_sc_hd__fill_2
XFILLER_67_221 VGND VGND VPWR VPWR sky130_fd_sc_hd__decap_3
XFILLER_55_405 VGND VGND VPWR VPWR sky130_fd_sc_hd__decap_3
XFILLER_67_265 VGND VGND VPWR VPWR sky130_fd_sc_hd__decap_3
XFILLER_55_427 VGND VGND VPWR VPWR sky130_fd_sc_hd__decap_3
XFILLER_35_19 VGND VGND VPWR VPWR sky130_fd_sc_hd__fill_2
XTAP_TAPCELL_ROW_81_904 VGND VPWR sky130_fd_sc_hd__tapvpwrvgnd_1
XFILLER_35_151 VGND VGND VPWR VPWR sky130_fd_sc_hd__decap_3
XFILLER_35_195 VGND VGND VPWR VPWR sky130_fd_sc_hd__decap_3
XFILLER_50_121 VGND VGND VPWR VPWR sky130_fd_sc_hd__decap_3
XFILLER_23_379 VGND VGND VPWR VPWR sky130_fd_sc_hd__decap_3
X_3957_ _6151_/B _3912_/B _3965_/A VGND VGND VPWR VPWR _3957_/X sky130_fd_sc_hd__a21o_2
X_3888_ _3907_/C _3885_/Y _3886_/Y _3887_/Y _3993_/A VGND VGND VPWR VPWR _3888_/X
+ sky130_fd_sc_hd__o311a_2
X_5627_ _5627_/A _5628_/B _5628_/C VGND VGND VPWR VPWR _5629_/B sky130_fd_sc_hd__and3_2
X_5558_ _5556_/X _5557_/X _5696_/A VGND VGND VPWR VPWR _5558_/Y sky130_fd_sc_hd__a21oi_2
X_4509_ _5014_/A _4503_/Y _4508_/Y _4840_/B VGND VGND VPWR VPWR _4509_/X sky130_fd_sc_hd__a211o_2
X_5489_ _5951_/A1 _5499_/D _5470_/Y _5669_/B2 _5488_/Y VGND VGND VPWR VPWR _5982_/A
+ sky130_fd_sc_hd__a221o_2
Xfanout510 input46/X VGND VGND VPWR VPWR _6449_/A1 sky130_fd_sc_hd__clkdlybuf4s25_1
Xfanout521 _6446_/A0 VGND VGND VPWR VPWR _6391_/A sky130_fd_sc_hd__clkdlybuf4s25_1
Xfanout532 _5054_/A VGND VGND VPWR VPWR _6275_/A sky130_fd_sc_hd__clkdlybuf4s25_1
Xfanout543 _6447_/A3 VGND VGND VPWR VPWR _4849_/A sky130_fd_sc_hd__clkdlybuf4s25_1
Xfanout554 input29/X VGND VGND VPWR VPWR _6460_/A1 sky130_fd_sc_hd__clkdlybuf4s25_1
Xfanout565 input24/X VGND VGND VPWR VPWR _6457_/A1 sky130_fd_sc_hd__clkdlybuf4s25_1
Xfanout576 fanout580/A VGND VGND VPWR VPWR _5098_/A1 sky130_fd_sc_hd__clkdlybuf4s25_1
Xfanout587 input2/X VGND VGND VPWR VPWR _3638_/A sky130_fd_sc_hd__clkdlybuf4s25_1
Xfanout598 input14/X VGND VGND VPWR VPWR _4181_/A sky130_fd_sc_hd__clkdlybuf4s25_1
XFILLER_58_265 VGND VGND VPWR VPWR sky130_fd_sc_hd__decap_3
XFILLER_58_243 VGND VGND VPWR VPWR sky130_fd_sc_hd__fill_1
XFILLER_46_427 VGND VGND VPWR VPWR sky130_fd_sc_hd__fill_2
XTAP_TAPCELL_ROW_16_319 VGND VPWR sky130_fd_sc_hd__tapvpwrvgnd_1
XFILLER_73_279 VGND VGND VPWR VPWR sky130_fd_sc_hd__fill_1
XFILLER_41_121 VGND VGND VPWR VPWR sky130_fd_sc_hd__decap_3
XFILLER_41_143 VGND VGND VPWR VPWR sky130_fd_sc_hd__decap_3
XFILLER_41_165 VGND VGND VPWR VPWR sky130_fd_sc_hd__decap_3
XTAP_TAPCELL_ROW_52_650 VGND VPWR sky130_fd_sc_hd__tapvpwrvgnd_1
XTAP_TAPCELL_ROW_24_396 VGND VPWR sky130_fd_sc_hd__tapvpwrvgnd_1
XFILLER_41_62 VGND VGND VPWR VPWR sky130_fd_sc_hd__decap_3
XFILLER_41_73 VGND VGND VPWR VPWR sky130_fd_sc_hd__fill_2
XFILLER_1_261 VGND VGND VPWR VPWR sky130_fd_sc_hd__fill_2
XFILLER_49_210 VGND VGND VPWR VPWR sky130_fd_sc_hd__decap_3
XFILLER_37_449 VGND VGND VPWR VPWR sky130_fd_sc_hd__fill_1
XFILLER_49_287 VGND VGND VPWR VPWR sky130_fd_sc_hd__decap_3
XFILLER_66_70 VGND VGND VPWR VPWR sky130_fd_sc_hd__fill_1
XFILLER_64_224 VGND VGND VPWR VPWR sky130_fd_sc_hd__decap_3
X_4860_ _6077_/A _4900_/A VGND VGND VPWR VPWR _4919_/A sky130_fd_sc_hd__and2b_2
XFILLER_20_305 VGND VGND VPWR VPWR sky130_fd_sc_hd__decap_3
XFILLER_32_154 VGND VGND VPWR VPWR sky130_fd_sc_hd__decap_3
X_3811_ _6130_/S _6062_/C VGND VGND VPWR VPWR _3921_/A sky130_fd_sc_hd__xnor2_2
XANTENNA_17 _3872_/A VGND VGND VPWR VPWR sky130_fd_sc_hd__diode_2
XANTENNA_28 _3464_/C VGND VGND VPWR VPWR sky130_fd_sc_hd__diode_2
XFILLER_20_327 VGND VGND VPWR VPWR sky130_fd_sc_hd__decap_3
X_4791_ _4791_/A _4791_/B VGND VGND VPWR VPWR _4791_/Y sky130_fd_sc_hd__xnor2_2
XFILLER_13_390 VGND VGND VPWR VPWR sky130_fd_sc_hd__fill_2
X_3742_ _6090_/A _6122_/A1 _3742_/B1 _3670_/X VGND VGND VPWR VPWR _3742_/X sky130_fd_sc_hd__o211a_2
X_6461_ input18/X input20/X _6461_/A2 _6461_/A3 _6461_/S0 _6438_/X VGND VGND VPWR
+ VPWR _6461_/X sky130_fd_sc_hd__mux4_2
X_3673_ _3681_/A _6014_/B VGND VGND VPWR VPWR _3673_/X sky130_fd_sc_hd__and2_2
X_6392_ _6393_/A _6392_/B _6392_/C VGND VGND VPWR VPWR _6392_/X sky130_fd_sc_hd__and3_2
X_5412_ _5501_/A _5412_/B VGND VGND VPWR VPWR _5412_/X sky130_fd_sc_hd__xor2_2
X_5343_ _5286_/Y _5309_/B _5309_/A VGND VGND VPWR VPWR _5425_/B sky130_fd_sc_hd__o21ba_2
Xoutput146 _5996_/A VGND VGND VPWR VPWR result[18] sky130_fd_sc_hd__clkdlybuf4s25_1
Xoutput157 _4653_/Y VGND VGND VPWR VPWR result[28] sky130_fd_sc_hd__clkdlybuf4s25_1
Xoutput168 _5999_/D VGND VGND VPWR VPWR result[38] sky130_fd_sc_hd__clkdlybuf4s25_1
Xoutput135 _6501_/A VGND VGND VPWR VPWR negative_flag sky130_fd_sc_hd__clkdlybuf4s25_1
Xoutput179 _5981_/C VGND VGND VPWR VPWR result[48] sky130_fd_sc_hd__clkdlybuf4s25_1
X_5274_ _5274_/A _5274_/B _5274_/C _5274_/D VGND VGND VPWR VPWR _5423_/A sky130_fd_sc_hd__nand4_2
X_4225_ _5014_/A _3470_/Y _4224_/Y _4840_/B VGND VGND VPWR VPWR _5552_/B sky130_fd_sc_hd__a211o_2
X_4156_ _4156_/A VGND VGND VPWR VPWR _4515_/A sky130_fd_sc_hd__clkbuf_1
XFILLER_46_29 VGND VGND VPWR VPWR sky130_fd_sc_hd__decap_3
XFILLER_55_257 VGND VGND VPWR VPWR sky130_fd_sc_hd__decap_3
X_4087_ _6120_/B _3686_/B _3686_/C _3686_/D _4086_/X VGND VGND VPWR VPWR _4120_/D
+ sky130_fd_sc_hd__o41a_2
XFILLER_43_419 VGND VGND VPWR VPWR sky130_fd_sc_hd__fill_1
XFILLER_55_279 VGND VGND VPWR VPWR sky130_fd_sc_hd__fill_1
XTAP_TAPCELL_ROW_66_775 VGND VPWR sky130_fd_sc_hd__tapvpwrvgnd_1
XFILLER_70_227 VGND VGND VPWR VPWR sky130_fd_sc_hd__decap_3
XFILLER_23_154 VGND VGND VPWR VPWR sky130_fd_sc_hd__decap_3
XFILLER_51_452 VGND VGND VPWR VPWR sky130_fd_sc_hd__fill_1
XFILLER_51_463 VGND VGND VPWR VPWR sky130_fd_sc_hd__decap_3
X_4989_ _3524_/X _4841_/Y _4988_/X _4926_/A _5061_/A VGND VGND VPWR VPWR _4989_/X
+ sky130_fd_sc_hd__o221a_2
XTAP_TAPCELL_ROW_21_366 VGND VPWR sky130_fd_sc_hd__tapvpwrvgnd_1
Xfanout340 _3648_/S1 VGND VGND VPWR VPWR _3895_/A2 sky130_fd_sc_hd__clkdlybuf4s25_1
Xfanout351 _6100_/B VGND VGND VPWR VPWR _3554_/A sky130_fd_sc_hd__clkdlybuf4s25_1
Xfanout362 input88/X VGND VGND VPWR VPWR _6233_/A sky130_fd_sc_hd__clkdlybuf4s25_1
Xfanout373 fanout406/X VGND VGND VPWR VPWR wire374/A sky130_fd_sc_hd__clkdlybuf4s25_1
Xfanout384 fanout387/X VGND VGND VPWR VPWR _6437_/S sky130_fd_sc_hd__clkdlybuf4s25_1
XFILLER_46_235 VGND VGND VPWR VPWR sky130_fd_sc_hd__decap_3
XTAP_TAPCELL_ROW_29_444 VGND VPWR sky130_fd_sc_hd__tapvpwrvgnd_1
XFILLER_61_216 VGND VGND VPWR VPWR sky130_fd_sc_hd__decap_3
XFILLER_61_205 VGND VGND VPWR VPWR sky130_fd_sc_hd__fill_1
XFILLER_14_121 VGND VGND VPWR VPWR sky130_fd_sc_hd__fill_2
XFILLER_61_249 VGND VGND VPWR VPWR sky130_fd_sc_hd__decap_3
Xinput37 operand_a[38] VGND VGND VPWR VPWR input37/X sky130_fd_sc_hd__clkdlybuf4s25_1
Xinput26 operand_a[28] VGND VGND VPWR VPWR input26/X sky130_fd_sc_hd__clkdlybuf4s25_1
Xinput15 operand_a[18] VGND VGND VPWR VPWR input15/X sky130_fd_sc_hd__clkdlybuf4s25_1
Xinput59 operand_a[58] VGND VGND VPWR VPWR input59/X sky130_fd_sc_hd__clkdlybuf4s25_1
Xinput48 operand_a[48] VGND VGND VPWR VPWR input48/X sky130_fd_sc_hd__clkdlybuf4s25_1
X_4010_ _4379_/S _4010_/B _4010_/C VGND VGND VPWR VPWR _4010_/X sky130_fd_sc_hd__and3_2
XFILLER_25_408 VGND VGND VPWR VPWR sky130_fd_sc_hd__fill_1
XFILLER_37_268 VGND VGND VPWR VPWR sky130_fd_sc_hd__decap_3
X_5961_ _5961_/A _5961_/B VGND VGND VPWR VPWR _5961_/X sky130_fd_sc_hd__xor2_2
XFILLER_52_238 VGND VGND VPWR VPWR sky130_fd_sc_hd__decap_3
X_4912_ _5162_/A _4825_/B _4817_/A _4819_/B VGND VGND VPWR VPWR _4912_/X sky130_fd_sc_hd__a211o_2
XTAP_TAPCELL_ROW_63_745 VGND VPWR sky130_fd_sc_hd__tapvpwrvgnd_1
X_5892_ _5877_/X _5884_/Y _5889_/X _5890_/Y _5891_/Y VGND VGND VPWR VPWR _6496_/D
+ sky130_fd_sc_hd__a221o_2
XFILLER_20_102 VGND VGND VPWR VPWR sky130_fd_sc_hd__fill_2
X_4843_ _4286_/A _4151_/Y _4837_/X VGND VGND VPWR VPWR _4843_/Y sky130_fd_sc_hd__a21oi_2
XFILLER_20_146 VGND VGND VPWR VPWR sky130_fd_sc_hd__fill_1
X_4774_ _4774_/A _4768_/X VGND VGND VPWR VPWR _4774_/X sky130_fd_sc_hd__or2b_2
XFILLER_20_179 VGND VGND VPWR VPWR sky130_fd_sc_hd__decap_3
X_3725_ _3754_/A _6126_/A VGND VGND VPWR VPWR _4077_/B sky130_fd_sc_hd__xnor2_2
X_6444_ _6472_/S _6444_/B VGND VGND VPWR VPWR _6469_/S sky130_fd_sc_hd__xnor2_4
X_3656_ _3653_/X _3655_/X _4507_/S VGND VGND VPWR VPWR _3656_/X sky130_fd_sc_hd__mux2_2
X_6375_ _5658_/A _6349_/A _6354_/B VGND VGND VPWR VPWR _6376_/B sky130_fd_sc_hd__o21ai_2
X_3587_ _6440_/A3 _6440_/A2 _6431_/A0 _5946_/A3 _6439_/S0 _3631_/S1 VGND VGND VPWR
+ VPWR _3587_/X sky130_fd_sc_hd__mux4_2
X_5326_ _4832_/X _5008_/X _5173_/X _5325_/X _5616_/A _5175_/S VGND VGND VPWR VPWR
+ _5326_/X sky130_fd_sc_hd__mux4_2
X_5257_ _5258_/B _5258_/C _5258_/A VGND VGND VPWR VPWR _5259_/A sky130_fd_sc_hd__a21o_2
X_4208_ _5510_/A _4598_/B _4204_/X _4211_/A _4207_/Y VGND VGND VPWR VPWR _4208_/X
+ sky130_fd_sc_hd__o221a_2
X_5188_ _5182_/X _5183_/Y _5188_/S VGND VGND VPWR VPWR _5188_/X sky130_fd_sc_hd__mux2_2
X_4139_ _3977_/X _4138_/X _4139_/S VGND VGND VPWR VPWR _4139_/X sky130_fd_sc_hd__mux2_2
XFILLER_43_205 VGND VGND VPWR VPWR sky130_fd_sc_hd__decap_3
XFILLER_43_238 VGND VGND VPWR VPWR sky130_fd_sc_hd__decap_3
XTAP_TAPCELL_ROW_26_414 VGND VPWR sky130_fd_sc_hd__tapvpwrvgnd_1
XFILLER_24_452 VGND VGND VPWR VPWR sky130_fd_sc_hd__fill_1
XFILLER_11_113 VGND VGND VPWR VPWR sky130_fd_sc_hd__decap_3
XFILLER_24_474 VGND VGND VPWR VPWR sky130_fd_sc_hd__fill_2
XFILLER_7_139 VGND VGND VPWR VPWR sky130_fd_sc_hd__fill_1
XFILLER_3_389 VGND VGND VPWR VPWR sky130_fd_sc_hd__decap_3
XFILLER_59_382 VGND VGND VPWR VPWR sky130_fd_sc_hd__decap_3
XFILLER_59_393 VGND VGND VPWR VPWR sky130_fd_sc_hd__decap_3
XFILLER_34_249 VGND VGND VPWR VPWR sky130_fd_sc_hd__decap_3
XTAP_TAPCELL_ROW_60_715 VGND VPWR sky130_fd_sc_hd__tapvpwrvgnd_1
X_3510_ _3479_/A _3479_/C _3679_/A VGND VGND VPWR VPWR _3559_/C sky130_fd_sc_hd__a21o_2
Xmax_cap326 _4076_/A VGND VGND VPWR VPWR _4001_/A sky130_fd_sc_hd__buf_2
Xmax_cap315 _5274_/C VGND VGND VPWR VPWR _5214_/A sky130_fd_sc_hd__clkbuf_2
Xmax_cap304 _4076_/Y VGND VGND VPWR VPWR _4086_/D sky130_fd_sc_hd__buf_1
X_4490_ _4482_/X _4539_/A _4538_/B _4539_/B _4312_/A VGND VGND VPWR VPWR _4490_/X
+ sky130_fd_sc_hd__o311a_2
X_3441_ input9/X _6467_/A1 _4175_/A _6458_/A1 _3654_/S0 _3653_/S VGND VGND VPWR VPWR
+ _3441_/X sky130_fd_sc_hd__mux4_2
X_6160_ _6150_/X _6153_/X _6155_/X _6159_/X VGND VGND VPWR VPWR _6198_/A sky130_fd_sc_hd__a211o_2
X_3372_ _3372_/A _3486_/C VGND VGND VPWR VPWR _3372_/X sky130_fd_sc_hd__xor2_2
X_5111_ _5162_/A _5162_/B VGND VGND VPWR VPWR _5117_/A sky130_fd_sc_hd__or2_2
XFILLER_69_113 VGND VGND VPWR VPWR sky130_fd_sc_hd__decap_3
X_6091_ _3664_/A _6015_/A _4086_/A VGND VGND VPWR VPWR _6091_/X sky130_fd_sc_hd__a21o_2
X_5042_ _5042_/A _5051_/A _5052_/S VGND VGND VPWR VPWR _5042_/Y sky130_fd_sc_hd__nand3_2
XFILLER_65_374 VGND VGND VPWR VPWR sky130_fd_sc_hd__decap_3
XFILLER_65_396 VGND VGND VPWR VPWR sky130_fd_sc_hd__decap_3
X_5944_ _5975_/A _5942_/X _5943_/X VGND VGND VPWR VPWR _5944_/X sky130_fd_sc_hd__a21o_2
XFILLER_21_411 VGND VGND VPWR VPWR sky130_fd_sc_hd__fill_2
X_5875_ _5816_/A _5816_/B _5874_/X VGND VGND VPWR VPWR _5923_/C sky130_fd_sc_hd__a21o_2
XFILLER_21_433 VGND VGND VPWR VPWR sky130_fd_sc_hd__fill_2
XFILLER_33_293 VGND VGND VPWR VPWR sky130_fd_sc_hd__decap_3
X_4826_ _4922_/A _4825_/Y _4818_/A VGND VGND VPWR VPWR _4826_/Y sky130_fd_sc_hd__a21oi_2
XTAP_TAPCELL_ROW_31_461 VGND VPWR sky130_fd_sc_hd__tapvpwrvgnd_1
X_4757_ _4056_/X _4060_/X _4757_/S VGND VGND VPWR VPWR _4757_/X sky130_fd_sc_hd__mux2_2
X_4688_ _3985_/X _4154_/Y _4686_/X _4687_/X VGND VGND VPWR VPWR _4688_/X sky130_fd_sc_hd__a211o_2
X_3708_ _5138_/A _3708_/B VGND VGND VPWR VPWR _3708_/Y sky130_fd_sc_hd__nand2_2
X_6427_ _6427_/A _6427_/B VGND VGND VPWR VPWR _6470_/S sky130_fd_sc_hd__xnor2_2
X_3639_ _4199_/A _4200_/A _4086_/A VGND VGND VPWR VPWR _3639_/X sky130_fd_sc_hd__mux2_2
X_6358_ _6358_/A _6358_/B VGND VGND VPWR VPWR _6358_/Y sky130_fd_sc_hd__nand2_2
X_5309_ _5309_/A _5309_/B VGND VGND VPWR VPWR _5310_/A sky130_fd_sc_hd__or2_2
X_6289_ _6358_/B VGND VGND VPWR VPWR _6290_/B sky130_fd_sc_hd__inv_2
XFILLER_56_330 VGND VGND VPWR VPWR sky130_fd_sc_hd__decap_3
XFILLER_44_514 VGND VGND VPWR VPWR sky130_fd_sc_hd__fill_2
XFILLER_16_216 VGND VGND VPWR VPWR sky130_fd_sc_hd__decap_3
XFILLER_56_385 VGND VGND VPWR VPWR sky130_fd_sc_hd__decap_3
XFILLER_71_333 VGND VGND VPWR VPWR sky130_fd_sc_hd__decap_3
XFILLER_31_208 VGND VGND VPWR VPWR sky130_fd_sc_hd__decap_3
XFILLER_71_355 VGND VGND VPWR VPWR sky130_fd_sc_hd__decap_3
XFILLER_47_330 VGND VGND VPWR VPWR sky130_fd_sc_hd__decap_3
XFILLER_59_190 VGND VGND VPWR VPWR sky130_fd_sc_hd__decap_3
XFILLER_35_514 VGND VGND VPWR VPWR sky130_fd_sc_hd__fill_2
XFILLER_47_352 VGND VGND VPWR VPWR sky130_fd_sc_hd__decap_3
XTAP_TAPCELL_ROW_37_509 VGND VPWR sky130_fd_sc_hd__tapvpwrvgnd_1
XFILLER_47_396 VGND VGND VPWR VPWR sky130_fd_sc_hd__decap_3
XFILLER_62_333 VGND VGND VPWR VPWR sky130_fd_sc_hd__decap_3
X_3990_ _4168_/A _4708_/A _3975_/X _3976_/X _3989_/X VGND VGND VPWR VPWR _3990_/Y
+ sky130_fd_sc_hd__a221oi_2
XTAP_TAPCELL_ROW_73_840 VGND VPWR sky130_fd_sc_hd__tapvpwrvgnd_1
XTAP_TAPCELL_ROW_45_586 VGND VPWR sky130_fd_sc_hd__tapvpwrvgnd_1
XFILLER_62_399 VGND VGND VPWR VPWR sky130_fd_sc_hd__decap_3
X_5660_ _3594_/B _3629_/X _5375_/X VGND VGND VPWR VPWR _5660_/X sky130_fd_sc_hd__a21o_2
XFILLER_30_241 VGND VGND VPWR VPWR sky130_fd_sc_hd__decap_3
X_4611_ _4611_/A VGND VGND VPWR VPWR _5628_/A sky130_fd_sc_hd__clkbuf_2
XFILLER_30_285 VGND VGND VPWR VPWR sky130_fd_sc_hd__decap_3
X_5591_ wire282/X wire281/X _5591_/S VGND VGND VPWR VPWR _5591_/X sky130_fd_sc_hd__mux2_2
X_4542_ _4484_/A _4540_/C _4538_/Y _4541_/X VGND VGND VPWR VPWR _4707_/C sky130_fd_sc_hd__o31ai_2
X_4473_ _4473_/A _6221_/B VGND VGND VPWR VPWR _4473_/Y sky130_fd_sc_hd__nor2_2
X_6212_ _4181_/A input78/X _6167_/A VGND VGND VPWR VPWR _6213_/B sky130_fd_sc_hd__o21a_2
X_3424_ _4507_/S _3424_/B VGND VGND VPWR VPWR _3896_/A sky130_fd_sc_hd__nor2_2
X_6143_ _6062_/D _6131_/X _6142_/Y _6464_/A1 VGND VGND VPWR VPWR _6143_/X sky130_fd_sc_hd__a2bb2o_2
X_3355_ _3292_/A _3348_/A _3354_/X VGND VGND VPWR VPWR _3355_/X sky130_fd_sc_hd__o21a_2
X_6074_ _6055_/B _6070_/X _6073_/X _6053_/Y _4900_/A VGND VGND VPWR VPWR _6074_/X
+ sky130_fd_sc_hd__o32a_2
X_3286_ _3264_/A _3357_/B _3464_/A _3556_/A _3262_/A _3520_/S VGND VGND VPWR VPWR
+ _3286_/X sky130_fd_sc_hd__mux4_2
XFILLER_57_116 VGND VGND VPWR VPWR sky130_fd_sc_hd__decap_3
Xload_slew395 _3327_/S VGND VGND VPWR VPWR _4014_/S sky130_fd_sc_hd__clkbuf_4
X_5025_ _4312_/A _5001_/Y _5007_/Y _5024_/Y VGND VGND VPWR VPWR _5985_/B sky130_fd_sc_hd__a211o_2
XFILLER_38_352 VGND VGND VPWR VPWR sky130_fd_sc_hd__decap_3
XFILLER_38_374 VGND VGND VPWR VPWR sky130_fd_sc_hd__fill_2
XFILLER_38_385 VGND VGND VPWR VPWR sky130_fd_sc_hd__decap_3
XFILLER_53_311 VGND VGND VPWR VPWR sky130_fd_sc_hd__decap_3
XTAP_TAPCELL_ROW_0_178 VGND VPWR sky130_fd_sc_hd__tapvpwrvgnd_1
XTAP_TAPCELL_ROW_0_167 VGND VPWR sky130_fd_sc_hd__tapvpwrvgnd_1
XFILLER_80_141 VGND VGND VPWR VPWR sky130_fd_sc_hd__decap_3
XFILLER_53_377 VGND VGND VPWR VPWR sky130_fd_sc_hd__decap_3
X_5927_ _5925_/Y _5924_/B _5942_/S _5926_/X VGND VGND VPWR VPWR _5927_/Y sky130_fd_sc_hd__a31oi_2
XFILLER_80_185 VGND VGND VPWR VPWR sky130_fd_sc_hd__fill_2
XFILLER_21_230 VGND VGND VPWR VPWR sky130_fd_sc_hd__fill_1
X_5858_ _5283_/X _5739_/Y _5856_/X _4840_/Y _5857_/Y VGND VGND VPWR VPWR _5858_/X
+ sky130_fd_sc_hd__a221o_2
X_5789_ _5787_/A _5787_/B _5762_/B _6495_/B _5760_/Y VGND VGND VPWR VPWR _5825_/A
+ sky130_fd_sc_hd__o2111a_2
X_4809_ _5177_/A _4809_/B VGND VGND VPWR VPWR _4809_/Y sky130_fd_sc_hd__nand2_2
XPHY_EDGE_ROW_17_Right_17 VGND VGND VPWR VPWR sky130_fd_sc_hd__decap_3
XPHY_EDGE_ROW_26_Right_26 VGND VGND VPWR VPWR sky130_fd_sc_hd__decap_3
XFILLER_17_514 VGND VGND VPWR VPWR sky130_fd_sc_hd__fill_2
XFILLER_29_385 VGND VGND VPWR VPWR sky130_fd_sc_hd__decap_3
XFILLER_29_396 VGND VGND VPWR VPWR sky130_fd_sc_hd__decap_3
XFILLER_56_182 VGND VGND VPWR VPWR sky130_fd_sc_hd__fill_1
XFILLER_44_333 VGND VGND VPWR VPWR sky130_fd_sc_hd__decap_3
XTAP_TAPCELL_ROW_70_810 VGND VPWR sky130_fd_sc_hd__tapvpwrvgnd_1
XFILLER_71_185 VGND VGND VPWR VPWR sky130_fd_sc_hd__decap_3
XTAP_TAPCELL_ROW_42_556 VGND VPWR sky130_fd_sc_hd__tapvpwrvgnd_1
XPHY_EDGE_ROW_35_Right_35 VGND VGND VPWR VPWR sky130_fd_sc_hd__decap_3
XFILLER_8_234 VGND VGND VPWR VPWR sky130_fd_sc_hd__decap_3
XFILLER_60_83 VGND VGND VPWR VPWR sky130_fd_sc_hd__fill_1
XPHY_EDGE_ROW_44_Right_44 VGND VGND VPWR VPWR sky130_fd_sc_hd__decap_3
XFILLER_79_274 VGND VGND VPWR VPWR sky130_fd_sc_hd__fill_1
XFILLER_39_127 VGND VGND VPWR VPWR sky130_fd_sc_hd__fill_1
XFILLER_35_322 VGND VGND VPWR VPWR sky130_fd_sc_hd__decap_3
XFILLER_54_119 VGND VGND VPWR VPWR sky130_fd_sc_hd__decap_3
XFILLER_35_355 VGND VGND VPWR VPWR sky130_fd_sc_hd__fill_2
XFILLER_47_193 VGND VGND VPWR VPWR sky130_fd_sc_hd__fill_2
XFILLER_35_399 VGND VGND VPWR VPWR sky130_fd_sc_hd__decap_3
XFILLER_50_336 VGND VGND VPWR VPWR sky130_fd_sc_hd__decap_3
X_5712_ _5712_/A _5712_/B _5712_/C _5712_/D VGND VGND VPWR VPWR _5712_/Y sky130_fd_sc_hd__nand4_2
X_3973_ _3530_/X _3576_/X _3569_/X _3574_/X _4061_/S1 _3800_/A VGND VGND VPWR VPWR
+ _3973_/X sky130_fd_sc_hd__mux4_2
XPHY_EDGE_ROW_53_Right_53 VGND VGND VPWR VPWR sky130_fd_sc_hd__decap_3
X_5643_ _5648_/A _5647_/B _5567_/B VGND VGND VPWR VPWR _5643_/Y sky130_fd_sc_hd__o21ai_2
X_5574_ _5574_/A _5574_/B VGND VGND VPWR VPWR _5574_/X sky130_fd_sc_hd__xor2_2
X_4525_ _6221_/B _4483_/Y _4490_/X _4524_/X VGND VGND VPWR VPWR _5986_/A sky130_fd_sc_hd__a31o_2
X_4456_ _5704_/A _6442_/A VGND VGND VPWR VPWR _4456_/Y sky130_fd_sc_hd__nor2_2
XPHY_EDGE_ROW_62_Right_62 VGND VGND VPWR VPWR sky130_fd_sc_hd__decap_3
X_4387_ _4430_/A _4430_/B VGND VGND VPWR VPWR _4449_/B sky130_fd_sc_hd__and2_2
X_3407_ _3417_/A _3694_/B VGND VGND VPWR VPWR _4094_/A sky130_fd_sc_hd__nor2_2
X_6126_ _6126_/A _6126_/B _6151_/C VGND VGND VPWR VPWR _6127_/A sky130_fd_sc_hd__and3_2
X_3338_ _3371_/A _3515_/A VGND VGND VPWR VPWR _3344_/C sky130_fd_sc_hd__xor2_2
XTAP_TAPCELL_ROW_5_226 VGND VPWR sky130_fd_sc_hd__tapvpwrvgnd_1
X_6057_ _6270_/C _6056_/Y _4942_/A VGND VGND VPWR VPWR _6057_/X sky130_fd_sc_hd__o21a_2
X_3269_ _3269_/A VGND VGND VPWR VPWR _6443_/A sky130_fd_sc_hd__clkbuf_1
XFILLER_45_119 VGND VGND VPWR VPWR sky130_fd_sc_hd__decap_3
X_5008_ _6265_/B _6265_/A _4942_/A _6447_/A1 _5008_/S0 wire372/X VGND VGND VPWR VPWR
+ _5008_/X sky130_fd_sc_hd__mux4_2
XFILLER_53_141 VGND VGND VPWR VPWR sky130_fd_sc_hd__fill_1
XFILLER_41_314 VGND VGND VPWR VPWR sky130_fd_sc_hd__decap_3
XPHY_EDGE_ROW_71_Right_71 VGND VGND VPWR VPWR sky130_fd_sc_hd__decap_3
XFILLER_53_185 VGND VGND VPWR VPWR sky130_fd_sc_hd__decap_3
XFILLER_41_369 VGND VGND VPWR VPWR sky130_fd_sc_hd__decap_3
XFILLER_30_64 VGND VGND VPWR VPWR sky130_fd_sc_hd__fill_1
XPHY_EDGE_ROW_80_Right_80 VGND VGND VPWR VPWR sky130_fd_sc_hd__decap_3
XFILLER_49_414 VGND VGND VPWR VPWR sky130_fd_sc_hd__decap_3
XFILLER_39_62 VGND VGND VPWR VPWR sky130_fd_sc_hd__decap_3
XFILLER_39_84 VGND VGND VPWR VPWR sky130_fd_sc_hd__decap_3
XFILLER_49_447 VGND VGND VPWR VPWR sky130_fd_sc_hd__fill_1
XFILLER_76_211 VGND VGND VPWR VPWR sky130_fd_sc_hd__decap_3
XFILLER_36_108 VGND VGND VPWR VPWR sky130_fd_sc_hd__decap_3
XTAP_TAPCELL_ROW_47_604 VGND VPWR sky130_fd_sc_hd__tapvpwrvgnd_1
XFILLER_76_244 VGND VGND VPWR VPWR sky130_fd_sc_hd__decap_3
XFILLER_36_119 VGND VGND VPWR VPWR sky130_fd_sc_hd__decap_3
XFILLER_76_288 VGND VGND VPWR VPWR sky130_fd_sc_hd__decap_3
XFILLER_17_333 VGND VGND VPWR VPWR sky130_fd_sc_hd__decap_3
XFILLER_44_174 VGND VGND VPWR VPWR sky130_fd_sc_hd__fill_1
XFILLER_55_94 VGND VGND VPWR VPWR sky130_fd_sc_hd__fill_1
XTAP_TAPCELL_ROW_55_670 VGND VPWR sky130_fd_sc_hd__tapvpwrvgnd_1
XFILLER_40_380 VGND VGND VPWR VPWR sky130_fd_sc_hd__decap_3
XTAP_TAPCELL_ROW_10_272 VGND VPWR sky130_fd_sc_hd__tapvpwrvgnd_1
X_5290_ _6292_/A _5290_/B VGND VGND VPWR VPWR _5290_/Y sky130_fd_sc_hd__nand2_2
X_4310_ _4355_/A _4355_/B VGND VGND VPWR VPWR _4352_/A sky130_fd_sc_hd__or2b_2
X_4241_ _4238_/B _4241_/B _4241_/C VGND VGND VPWR VPWR _4241_/X sky130_fd_sc_hd__and3b_2
X_4172_ _4302_/A1 _4249_/A _4259_/A VGND VGND VPWR VPWR _4263_/B sky130_fd_sc_hd__o21a_2
XFILLER_55_439 VGND VGND VPWR VPWR sky130_fd_sc_hd__decap_3
XFILLER_82_225 VGND VGND VPWR VPWR sky130_fd_sc_hd__decap_3
XFILLER_67_299 VGND VGND VPWR VPWR sky130_fd_sc_hd__fill_2
XFILLER_67_277 VGND VGND VPWR VPWR sky130_fd_sc_hd__decap_3
XTAP_TAPCELL_ROW_81_905 VGND VPWR sky130_fd_sc_hd__tapvpwrvgnd_1
XFILLER_35_163 VGND VGND VPWR VPWR sky130_fd_sc_hd__decap_3
XFILLER_63_483 VGND VGND VPWR VPWR sky130_fd_sc_hd__fill_1
XFILLER_23_325 VGND VGND VPWR VPWR sky130_fd_sc_hd__decap_3
XFILLER_50_133 VGND VGND VPWR VPWR sky130_fd_sc_hd__decap_3
X_3956_ _3956_/A _3955_/X VGND VGND VPWR VPWR _3966_/S sky130_fd_sc_hd__nor2b_2
XFILLER_50_177 VGND VGND VPWR VPWR sky130_fd_sc_hd__decap_3
X_5626_ _5591_/S _5623_/X _5606_/A _5625_/Y VGND VGND VPWR VPWR _5628_/B sky130_fd_sc_hd__o22a_2
X_3887_ _3885_/Y _3875_/B _3907_/C VGND VGND VPWR VPWR _3887_/Y sky130_fd_sc_hd__o21ai_2
X_5557_ _6317_/S _6330_/B _6318_/S VGND VGND VPWR VPWR _5557_/X sky130_fd_sc_hd__or3_2
X_5488_ _5215_/X _5473_/Y _5487_/X VGND VGND VPWR VPWR _5488_/Y sky130_fd_sc_hd__o21ai_2
X_4508_ _5014_/A _4508_/B VGND VGND VPWR VPWR _4508_/Y sky130_fd_sc_hd__nor2_2
X_4439_ _4120_/C _4431_/Y _4438_/X VGND VGND VPWR VPWR _4485_/A sky130_fd_sc_hd__a21boi_2
Xfanout511 input45/X VGND VGND VPWR VPWR _6358_/A sky130_fd_sc_hd__clkdlybuf4s25_1
Xfanout522 _6446_/A0 VGND VGND VPWR VPWR _5191_/A sky130_fd_sc_hd__clkdlybuf4s25_1
Xfanout533 _6450_/A1 VGND VGND VPWR VPWR _5054_/A sky130_fd_sc_hd__clkdlybuf4s25_1
Xfanout544 input32/X VGND VGND VPWR VPWR _6447_/A3 sky130_fd_sc_hd__clkdlybuf4s25_1
Xfanout555 input28/X VGND VGND VPWR VPWR _3464_/A sky130_fd_sc_hd__clkdlybuf4s25_1
Xfanout566 input23/X VGND VGND VPWR VPWR _4546_/A sky130_fd_sc_hd__clkdlybuf4s25_1
X_6109_ _6109_/A _6109_/B _6108_/B VGND VGND VPWR VPWR _6109_/X sky130_fd_sc_hd__or3b_2
Xfanout599 _6088_/A VGND VGND VPWR VPWR _6126_/B sky130_fd_sc_hd__clkdlybuf4s25_1
XFILLER_46_417 VGND VGND VPWR VPWR sky130_fd_sc_hd__decap_3
XFILLER_73_214 VGND VGND VPWR VPWR sky130_fd_sc_hd__fill_1
XFILLER_58_277 VGND VGND VPWR VPWR sky130_fd_sc_hd__decap_3
XFILLER_73_269 VGND VGND VPWR VPWR sky130_fd_sc_hd__fill_2
XFILLER_73_258 VGND VGND VPWR VPWR sky130_fd_sc_hd__decap_3
XFILLER_14_325 VGND VGND VPWR VPWR sky130_fd_sc_hd__decap_3
XFILLER_25_53 VGND VGND VPWR VPWR sky130_fd_sc_hd__decap_3
XFILLER_41_155 VGND VGND VPWR VPWR sky130_fd_sc_hd__fill_1
XTAP_TAPCELL_ROW_52_651 VGND VPWR sky130_fd_sc_hd__tapvpwrvgnd_1
XFILLER_41_199 VGND VGND VPWR VPWR sky130_fd_sc_hd__decap_3
XTAP_TAPCELL_ROW_24_397 VGND VPWR sky130_fd_sc_hd__tapvpwrvgnd_1
XFILLER_49_222 VGND VGND VPWR VPWR sky130_fd_sc_hd__fill_2
XFILLER_64_203 VGND VGND VPWR VPWR sky130_fd_sc_hd__decap_3
XFILLER_66_82 VGND VGND VPWR VPWR sky130_fd_sc_hd__fill_2
XFILLER_17_152 VGND VGND VPWR VPWR sky130_fd_sc_hd__fill_1
XFILLER_52_409 VGND VGND VPWR VPWR sky130_fd_sc_hd__fill_1
XFILLER_72_280 VGND VGND VPWR VPWR sky130_fd_sc_hd__decap_3
X_4790_ _4790_/A _4927_/C VGND VGND VPWR VPWR _4791_/B sky130_fd_sc_hd__and2_2
X_3810_ _3563_/X _3769_/Y _3778_/Y _4094_/A _3809_/Y VGND VGND VPWR VPWR _5991_/B
+ sky130_fd_sc_hd__a221o_2
XPHY_EDGE_ROW_25_Left_108 VGND VGND VPWR VPWR sky130_fd_sc_hd__decap_3
XANTENNA_18 _6198_/B VGND VGND VPWR VPWR sky130_fd_sc_hd__diode_2
XANTENNA_29 _3524_/X VGND VGND VPWR VPWR sky130_fd_sc_hd__diode_2
XFILLER_32_166 VGND VGND VPWR VPWR sky130_fd_sc_hd__fill_2
XFILLER_32_177 VGND VGND VPWR VPWR sky130_fd_sc_hd__decap_3
X_3741_ input67/X _3666_/X _3667_/X _3669_/X _3740_/X VGND VGND VPWR VPWR _3744_/A
+ sky130_fd_sc_hd__a41oi_2
X_6460_ _6460_/A0 _6460_/A1 _6460_/A2 _6460_/A3 _6461_/S0 _6438_/X VGND VGND VPWR
+ VPWR _6460_/X sky130_fd_sc_hd__mux4_2
X_3672_ _3681_/A _6014_/B _3672_/B1 _6108_/B _6122_/A1 VGND VGND VPWR VPWR _3672_/X
+ sky130_fd_sc_hd__o2111a_2
XFILLER_9_362 VGND VGND VPWR VPWR sky130_fd_sc_hd__fill_1
XFILLER_70_3 VGND VGND VPWR VPWR sky130_fd_sc_hd__fill_1
X_6391_ _6391_/A _6391_/B _6391_/C _6391_/D VGND VGND VPWR VPWR _6392_/C sky130_fd_sc_hd__or4_2
X_5411_ _5688_/A1 _5579_/A _5579_/B _5580_/A VGND VGND VPWR VPWR _5412_/B sky130_fd_sc_hd__a31o_2
X_5342_ _5117_/A _5117_/B _5117_/C _5423_/A _5422_/B VGND VGND VPWR VPWR _5416_/B
+ sky130_fd_sc_hd__a311o_2
Xoutput147 _5994_/B VGND VGND VPWR VPWR result[19] sky130_fd_sc_hd__clkdlybuf4s25_1
Xoutput158 _4691_/X VGND VGND VPWR VPWR result[29] sky130_fd_sc_hd__clkdlybuf4s25_1
Xoutput136 _6500_/Y VGND VGND VPWR VPWR overflow_flag sky130_fd_sc_hd__clkdlybuf4s25_1
Xoutput169 _5996_/D VGND VGND VPWR VPWR result[39] sky130_fd_sc_hd__clkdlybuf4s25_1
X_5273_ _4726_/S _3945_/Y _3947_/B VGND VGND VPWR VPWR _5273_/Y sky130_fd_sc_hd__a21oi_2
XPHY_EDGE_ROW_34_Left_117 VGND VGND VPWR VPWR sky130_fd_sc_hd__decap_3
X_4224_ _5014_/A _4224_/B VGND VGND VPWR VPWR _4224_/Y sky130_fd_sc_hd__nor2_2
X_4155_ _3317_/X _4837_/B _4382_/S VGND VGND VPWR VPWR _4155_/X sky130_fd_sc_hd__mux2_2
XFILLER_28_439 VGND VGND VPWR VPWR sky130_fd_sc_hd__decap_3
XFILLER_55_225 VGND VGND VPWR VPWR sky130_fd_sc_hd__decap_3
X_4086_ _4086_/A _4086_/B _4086_/C _4086_/D VGND VGND VPWR VPWR _4086_/X sky130_fd_sc_hd__and4_2
XTAP_TAPCELL_ROW_66_776 VGND VPWR sky130_fd_sc_hd__tapvpwrvgnd_1
XFILLER_70_206 VGND VGND VPWR VPWR sky130_fd_sc_hd__decap_3
XFILLER_23_111 VGND VGND VPWR VPWR sky130_fd_sc_hd__fill_1
XPHY_EDGE_ROW_43_Left_126 VGND VGND VPWR VPWR sky130_fd_sc_hd__decap_3
XFILLER_70_239 VGND VGND VPWR VPWR sky130_fd_sc_hd__fill_2
XFILLER_11_328 VGND VGND VPWR VPWR sky130_fd_sc_hd__decap_3
XFILLER_23_166 VGND VGND VPWR VPWR sky130_fd_sc_hd__fill_2
XFILLER_51_486 VGND VGND VPWR VPWR sky130_fd_sc_hd__fill_2
X_4988_ _4797_/X _6270_/B _4984_/Y _4986_/X _4987_/Y VGND VGND VPWR VPWR _4988_/X
+ sky130_fd_sc_hd__o221a_2
X_3939_ _6151_/B _4111_/A _4241_/B _3934_/X _3938_/Y VGND VGND VPWR VPWR _3939_/X
+ sky130_fd_sc_hd__a221o_2
XTAP_TAPCELL_ROW_21_367 VGND VPWR sky130_fd_sc_hd__tapvpwrvgnd_1
X_5609_ _5609_/A VGND VGND VPWR VPWR _5609_/X sky130_fd_sc_hd__clkbuf_1
XPHY_EDGE_ROW_52_Left_135 VGND VGND VPWR VPWR sky130_fd_sc_hd__decap_3
XFILLER_11_99 VGND VGND VPWR VPWR sky130_fd_sc_hd__fill_1
XFILLER_78_328 VGND VGND VPWR VPWR sky130_fd_sc_hd__fill_1
Xfanout363 _6221_/A VGND VGND VPWR VPWR _6189_/B sky130_fd_sc_hd__clkdlybuf4s25_1
XFILLER_46_214 VGND VGND VPWR VPWR sky130_fd_sc_hd__decap_3
Xfanout385 fanout387/X VGND VGND VPWR VPWR _3499_/S1 sky130_fd_sc_hd__clkdlybuf4s25_1
Xfanout396 _3376_/S0 VGND VGND VPWR VPWR _3758_/S sky130_fd_sc_hd__clkdlybuf4s25_1
XFILLER_34_409 VGND VGND VPWR VPWR sky130_fd_sc_hd__decap_3
XPHY_EDGE_ROW_61_Left_144 VGND VGND VPWR VPWR sky130_fd_sc_hd__decap_3
XFILLER_14_100 VGND VGND VPWR VPWR sky130_fd_sc_hd__decap_3
XFILLER_36_85 VGND VGND VPWR VPWR sky130_fd_sc_hd__decap_3
XFILLER_14_144 VGND VGND VPWR VPWR sky130_fd_sc_hd__decap_3
XFILLER_10_361 VGND VGND VPWR VPWR sky130_fd_sc_hd__decap_3
Xinput27 operand_a[29] VGND VGND VPWR VPWR input27/X sky130_fd_sc_hd__clkdlybuf4s25_1
Xinput16 operand_a[19] VGND VGND VPWR VPWR input16/X sky130_fd_sc_hd__clkdlybuf4s25_1
Xinput49 operand_a[49] VGND VGND VPWR VPWR input49/X sky130_fd_sc_hd__clkdlybuf4s25_1
Xinput38 operand_a[39] VGND VGND VPWR VPWR input38/X sky130_fd_sc_hd__clkdlybuf4s25_1
XPHY_EDGE_ROW_70_Left_153 VGND VGND VPWR VPWR sky130_fd_sc_hd__decap_3
XFILLER_6_365 VGND VGND VPWR VPWR sky130_fd_sc_hd__fill_2
XFILLER_37_203 VGND VGND VPWR VPWR sky130_fd_sc_hd__decap_3
XFILLER_37_225 VGND VGND VPWR VPWR sky130_fd_sc_hd__decap_3
XFILLER_37_236 VGND VGND VPWR VPWR sky130_fd_sc_hd__decap_3
XFILLER_52_206 VGND VGND VPWR VPWR sky130_fd_sc_hd__decap_3
X_5960_ _5960_/A _6497_/C VGND VGND VPWR VPWR _5961_/B sky130_fd_sc_hd__nand2_2
XFILLER_18_472 VGND VGND VPWR VPWR sky130_fd_sc_hd__decap_3
X_5891_ _5922_/A _5922_/B _5909_/A VGND VGND VPWR VPWR _5891_/Y sky130_fd_sc_hd__a21oi_2
X_4911_ _5162_/A _4825_/B _4916_/B _4819_/B VGND VGND VPWR VPWR _4911_/X sky130_fd_sc_hd__a211o_2
XTAP_TAPCELL_ROW_63_746 VGND VPWR sky130_fd_sc_hd__tapvpwrvgnd_1
X_4842_ _4842_/A _4842_/B VGND VGND VPWR VPWR _5090_/B sky130_fd_sc_hd__nand2_2
XFILLER_60_272 VGND VGND VPWR VPWR sky130_fd_sc_hd__decap_3
X_4773_ _4687_/C _4768_/X _4771_/Y _4772_/Y VGND VGND VPWR VPWR _5193_/A sky130_fd_sc_hd__o2bb2a_2
X_3724_ _3664_/A _6015_/A VGND VGND VPWR VPWR _3860_/B sky130_fd_sc_hd__and2b_2
X_6443_ _6443_/A _6443_/B VGND VGND VPWR VPWR _6444_/B sky130_fd_sc_hd__nand2_2
X_3655_ _3569_/X _3654_/X _3800_/A VGND VGND VPWR VPWR _3655_/X sky130_fd_sc_hd__mux2_2
X_6374_ _6374_/A _6374_/B _6374_/C _6374_/D VGND VGND VPWR VPWR _6376_/A sky130_fd_sc_hd__or4_2
X_3586_ _6440_/A1 _6428_/A0 _6429_/B _6428_/A2 _6439_/S0 _3780_/A VGND VGND VPWR VPWR
+ _3625_/B sky130_fd_sc_hd__mux4_2
X_5325_ _6358_/A _5316_/A _5338_/A3 _5225_/S wire423/X wire374/X VGND VGND VPWR VPWR
+ _5325_/X sky130_fd_sc_hd__mux4_2
X_5256_ _5256_/A _5256_/B VGND VGND VPWR VPWR _5258_/A sky130_fd_sc_hd__nand2_2
X_4207_ _4207_/A _4207_/B VGND VGND VPWR VPWR _4207_/Y sky130_fd_sc_hd__nand2_2
XFILLER_28_203 VGND VGND VPWR VPWR sky130_fd_sc_hd__decap_3
X_5187_ _5587_/A _5242_/B _3806_/X _5177_/Y _5186_/X VGND VGND VPWR VPWR _5187_/X
+ sky130_fd_sc_hd__o311a_2
XFILLER_28_225 VGND VGND VPWR VPWR sky130_fd_sc_hd__decap_3
X_4138_ input14/X _6467_/A2 _4189_/S VGND VGND VPWR VPWR _4138_/X sky130_fd_sc_hd__mux2_2
XTAP_TAPCELL_ROW_79_890 VGND VPWR sky130_fd_sc_hd__tapvpwrvgnd_1
X_4069_ _3907_/X _4069_/B VGND VGND VPWR VPWR _4447_/B sky130_fd_sc_hd__and2b_2
XFILLER_43_217 VGND VGND VPWR VPWR sky130_fd_sc_hd__decap_3
XTAP_TAPCELL_ROW_26_415 VGND VPWR sky130_fd_sc_hd__tapvpwrvgnd_1
XFILLER_11_125 VGND VGND VPWR VPWR sky130_fd_sc_hd__decap_3
XTAP_TAPCELL_ROW_34_481 VGND VPWR sky130_fd_sc_hd__tapvpwrvgnd_1
XFILLER_11_169 VGND VGND VPWR VPWR sky130_fd_sc_hd__decap_3
XFILLER_0_3 VGND VGND VPWR VPWR sky130_fd_sc_hd__decap_3
XPHY_EDGE_ROW_5_Left_88 VGND VGND VPWR VPWR sky130_fd_sc_hd__decap_3
XFILLER_66_309 VGND VGND VPWR VPWR sky130_fd_sc_hd__decap_3
XFILLER_59_361 VGND VGND VPWR VPWR sky130_fd_sc_hd__decap_3
XFILLER_19_225 VGND VGND VPWR VPWR sky130_fd_sc_hd__fill_1
XFILLER_74_342 VGND VGND VPWR VPWR sky130_fd_sc_hd__decap_3
XFILLER_34_228 VGND VGND VPWR VPWR sky130_fd_sc_hd__decap_3
XFILLER_30_401 VGND VGND VPWR VPWR sky130_fd_sc_hd__decap_3
XTAP_TAPCELL_ROW_60_716 VGND VPWR sky130_fd_sc_hd__tapvpwrvgnd_1
XFILLER_63_83 VGND VGND VPWR VPWR sky130_fd_sc_hd__decap_3
XFILLER_42_294 VGND VGND VPWR VPWR sky130_fd_sc_hd__decap_3
Xmax_cap316 _5274_/A VGND VGND VPWR VPWR _5131_/A sky130_fd_sc_hd__clkbuf_2
Xmax_cap305 _4288_/A VGND VGND VPWR VPWR _4681_/A0 sky130_fd_sc_hd__buf_2
Xmax_cap327 _3921_/A VGND VGND VPWR VPWR _3840_/S sky130_fd_sc_hd__clkbuf_2
X_3440_ _3383_/X _3384_/X _3438_/X _3439_/X _3495_/A _4506_/S VGND VGND VPWR VPWR
+ _3440_/X sky130_fd_sc_hd__mux4_2
X_3371_ _3371_/A _3411_/A1 VGND VGND VPWR VPWR _3372_/A sky130_fd_sc_hd__nor2b_4
X_6090_ _6090_/A _6098_/B _6090_/C VGND VGND VPWR VPWR _6090_/X sky130_fd_sc_hd__and3_2
X_5110_ _5110_/A _5110_/B _5429_/C VGND VGND VPWR VPWR _5162_/B sky130_fd_sc_hd__or3_2
X_5041_ _6265_/B _6270_/A _5040_/X VGND VGND VPWR VPWR _5052_/S sky130_fd_sc_hd__o21ai_2
XFILLER_57_309 VGND VGND VPWR VPWR sky130_fd_sc_hd__decap_3
Xload_slew577 _5098_/A1 VGND VGND VPWR VPWR _5348_/A sky130_fd_sc_hd__clkbuf_4
XTAP_TAPCELL_ROW_76_860 VGND VPWR sky130_fd_sc_hd__tapvpwrvgnd_1
XFILLER_25_228 VGND VGND VPWR VPWR sky130_fd_sc_hd__decap_3
XFILLER_65_386 VGND VGND VPWR VPWR sky130_fd_sc_hd__decap_3
X_5943_ _4010_/B _4010_/C _4456_/Y _5242_/Y _5228_/X VGND VGND VPWR VPWR _5943_/X
+ sky130_fd_sc_hd__a41o_2
XFILLER_80_356 VGND VGND VPWR VPWR sky130_fd_sc_hd__fill_1
XFILLER_33_261 VGND VGND VPWR VPWR sky130_fd_sc_hd__decap_3
XFILLER_40_209 VGND VGND VPWR VPWR sky130_fd_sc_hd__decap_3
X_5874_ _5874_/A _5874_/B _5874_/C VGND VGND VPWR VPWR _5874_/X sky130_fd_sc_hd__or3_2
X_4825_ _5162_/A _4825_/B VGND VGND VPWR VPWR _4825_/Y sky130_fd_sc_hd__nand2_2
XTAP_TAPCELL_ROW_31_462 VGND VPWR sky130_fd_sc_hd__tapvpwrvgnd_1
X_4756_ _4800_/A _4747_/X _4752_/X _4848_/A _4755_/Y VGND VGND VPWR VPWR _4763_/A
+ sky130_fd_sc_hd__a221o_2
X_4687_ _4670_/Y _6243_/C _4687_/C _4687_/D VGND VGND VPWR VPWR _4687_/X sky130_fd_sc_hd__and4b_2
X_3707_ _3750_/A _3707_/B VGND VGND VPWR VPWR _3708_/B sky130_fd_sc_hd__nand2_2
X_6426_ _6426_/A _6426_/B VGND VGND VPWR VPWR _6427_/B sky130_fd_sc_hd__nand2_2
X_3638_ _3638_/A _6014_/B VGND VGND VPWR VPWR _3638_/Y sky130_fd_sc_hd__nor2_2
X_6357_ _6294_/A _6356_/X _6359_/B _6359_/A VGND VGND VPWR VPWR _6357_/X sky130_fd_sc_hd__a22o_2
X_3569_ _4044_/A _4175_/A _6458_/A1 _4355_/A _3654_/S0 _3654_/S1 VGND VGND VPWR VPWR
+ _3569_/X sky130_fd_sc_hd__mux4_2
X_5308_ _6358_/A _5308_/B VGND VGND VPWR VPWR _5309_/B sky130_fd_sc_hd__nor2_2
X_6288_ _6363_/A _6285_/Y _6287_/Y _5422_/C VGND VGND VPWR VPWR _6288_/X sky130_fd_sc_hd__a211o_2
XFILLER_48_309 VGND VGND VPWR VPWR sky130_fd_sc_hd__decap_3
X_5239_ _5548_/S VGND VGND VPWR VPWR _5239_/X sky130_fd_sc_hd__clkbuf_1
XFILLER_56_342 VGND VGND VPWR VPWR sky130_fd_sc_hd__fill_1
XFILLER_17_54 VGND VGND VPWR VPWR sky130_fd_sc_hd__fill_2
XFILLER_71_367 VGND VGND VPWR VPWR sky130_fd_sc_hd__decap_3
XFILLER_33_75 VGND VGND VPWR VPWR sky130_fd_sc_hd__fill_1
XFILLER_58_83 VGND VGND VPWR VPWR sky130_fd_sc_hd__fill_1
XFILLER_74_161 VGND VGND VPWR VPWR sky130_fd_sc_hd__fill_1
XFILLER_62_312 VGND VGND VPWR VPWR sky130_fd_sc_hd__decap_3
XFILLER_62_345 VGND VGND VPWR VPWR sky130_fd_sc_hd__decap_3
XTAP_TAPCELL_ROW_45_587 VGND VPWR sky130_fd_sc_hd__tapvpwrvgnd_1
XFILLER_30_253 VGND VGND VPWR VPWR sky130_fd_sc_hd__decap_3
X_4610_ _4320_/A _4612_/C _4588_/X _4498_/B _4609_/X VGND VGND VPWR VPWR _5995_/B
+ sky130_fd_sc_hd__a221o_2
X_5590_ _5590_/A1 _4285_/X _4286_/Y VGND VGND VPWR VPWR _5590_/X sky130_fd_sc_hd__a21o_2
X_4541_ _4539_/X _4540_/X _4541_/S VGND VGND VPWR VPWR _4541_/X sky130_fd_sc_hd__mux2_2
X_4472_ _6189_/A _6224_/A VGND VGND VPWR VPWR _6221_/B sky130_fd_sc_hd__nand2b_2
X_6211_ _6221_/C _6199_/X _6210_/Y VGND VGND VPWR VPWR _6211_/X sky130_fd_sc_hd__a21o_2
X_3423_ _3486_/D _3423_/B VGND VGND VPWR VPWR _3423_/Y sky130_fd_sc_hd__xnor2_2
X_6142_ _6131_/A _6144_/C _6062_/D VGND VGND VPWR VPWR _6142_/Y sky130_fd_sc_hd__o21ai_2
X_3354_ _4156_/A _3353_/Y _3354_/S VGND VGND VPWR VPWR _3354_/X sky130_fd_sc_hd__mux2_2
X_6073_ _4923_/B _6258_/B _6072_/Y _4922_/B VGND VGND VPWR VPWR _6073_/X sky130_fd_sc_hd__o31a_2
Xload_slew352 _3554_/A VGND VGND VPWR VPWR _6098_/A sky130_fd_sc_hd__buf_4
Xload_slew341 _3895_/A2 VGND VGND VPWR VPWR _3575_/S1 sky130_fd_sc_hd__clkbuf_2
X_3285_ _3548_/B _3612_/A _3681_/A _3664_/A _6100_/A _3711_/S VGND VGND VPWR VPWR
+ _3285_/X sky130_fd_sc_hd__mux4_2
X_5024_ _5038_/A _5120_/C _5023_/X VGND VGND VPWR VPWR _5024_/Y sky130_fd_sc_hd__o21bai_2
XFILLER_53_323 VGND VGND VPWR VPWR sky130_fd_sc_hd__decap_3
XTAP_TAPCELL_ROW_0_179 VGND VPWR sky130_fd_sc_hd__tapvpwrvgnd_1
XTAP_TAPCELL_ROW_0_168 VGND VPWR sky130_fd_sc_hd__tapvpwrvgnd_1
XFILLER_53_389 VGND VGND VPWR VPWR sky130_fd_sc_hd__decap_3
X_5926_ _6419_/B _6420_/A _5942_/S VGND VGND VPWR VPWR _5926_/X sky130_fd_sc_hd__mux2_2
XFILLER_80_164 VGND VGND VPWR VPWR sky130_fd_sc_hd__decap_3
X_5857_ _3945_/Y _5510_/B _5740_/A VGND VGND VPWR VPWR _5857_/Y sky130_fd_sc_hd__o21ai_2
XFILLER_70_29 VGND VGND VPWR VPWR sky130_fd_sc_hd__fill_2
X_5788_ _5762_/B _6495_/B _6495_/C _6495_/D VGND VGND VPWR VPWR _5790_/A sky130_fd_sc_hd__a31oi_2
X_4808_ _3759_/X _4100_/X _4461_/X _4804_/X _5548_/S _5739_/A VGND VGND VPWR VPWR
+ _4809_/B sky130_fd_sc_hd__mux4_2
X_4739_ input93/X _4702_/Y _4701_/X _4715_/S VGND VGND VPWR VPWR _4739_/X sky130_fd_sc_hd__a31o_2
X_6409_ _5918_/A _6408_/Y _6476_/A VGND VGND VPWR VPWR _6409_/X sky130_fd_sc_hd__o21a_2
XFILLER_48_106 VGND VGND VPWR VPWR sky130_fd_sc_hd__decap_3
XFILLER_48_139 VGND VGND VPWR VPWR sky130_fd_sc_hd__fill_1
XFILLER_29_331 VGND VGND VPWR VPWR sky130_fd_sc_hd__decap_3
XFILLER_29_364 VGND VGND VPWR VPWR sky130_fd_sc_hd__decap_3
XFILLER_44_312 VGND VGND VPWR VPWR sky130_fd_sc_hd__decap_3
XFILLER_56_150 VGND VGND VPWR VPWR sky130_fd_sc_hd__decap_3
XTAP_TAPCELL_ROW_70_811 VGND VPWR sky130_fd_sc_hd__tapvpwrvgnd_1
XFILLER_44_85 VGND VGND VPWR VPWR sky130_fd_sc_hd__decap_3
XFILLER_71_197 VGND VGND VPWR VPWR sky130_fd_sc_hd__fill_1
XTAP_TAPCELL_ROW_42_557 VGND VPWR sky130_fd_sc_hd__tapvpwrvgnd_1
XFILLER_12_286 VGND VGND VPWR VPWR sky130_fd_sc_hd__decap_3
XFILLER_4_430 VGND VGND VPWR VPWR sky130_fd_sc_hd__fill_1
XFILLER_5_46 VGND VGND VPWR VPWR sky130_fd_sc_hd__fill_1
XPHY_EDGE_ROW_8_Left_91 VGND VGND VPWR VPWR sky130_fd_sc_hd__decap_3
XFILLER_79_253 VGND VGND VPWR VPWR sky130_fd_sc_hd__decap_3
XFILLER_47_161 VGND VGND VPWR VPWR sky130_fd_sc_hd__decap_3
XFILLER_47_172 VGND VGND VPWR VPWR sky130_fd_sc_hd__decap_3
XFILLER_35_389 VGND VGND VPWR VPWR sky130_fd_sc_hd__decap_3
XFILLER_50_315 VGND VGND VPWR VPWR sky130_fd_sc_hd__decap_3
XFILLER_50_348 VGND VGND VPWR VPWR sky130_fd_sc_hd__decap_3
X_5711_ _5532_/A _5532_/B _5532_/C _5710_/X VGND VGND VPWR VPWR _5711_/X sky130_fd_sc_hd__a31o_2
X_3972_ _3573_/X _3575_/X _3582_/X _3584_/X _4674_/S _4025_/S0 VGND VGND VPWR VPWR
+ _3972_/X sky130_fd_sc_hd__mux4_2
XFILLER_62_197 VGND VGND VPWR VPWR sky130_fd_sc_hd__decap_3
X_5642_ _5570_/A _5570_/B _5710_/A VGND VGND VPWR VPWR _5649_/B sky130_fd_sc_hd__a21o_2
X_5573_ _5573_/A _5573_/B _5573_/C _5573_/D VGND VGND VPWR VPWR _5574_/A sky130_fd_sc_hd__and4_2
XTAP_TAPCELL_ROW_13_292 VGND VPWR sky130_fd_sc_hd__tapvpwrvgnd_1
X_4524_ _4312_/A _4482_/X _4493_/X _4497_/Y _4523_/X VGND VGND VPWR VPWR _4524_/X
+ sky130_fd_sc_hd__a311o_2
X_4455_ _4627_/A _4455_/B VGND VGND VPWR VPWR _4455_/X sky130_fd_sc_hd__xor2_2
X_4386_ _6199_/A _6173_/A _6021_/D _6199_/B VGND VGND VPWR VPWR _4386_/X sky130_fd_sc_hd__a22o_2
X_3406_ _3464_/B _3464_/C _3357_/Y VGND VGND VPWR VPWR _3667_/C sky130_fd_sc_hd__a21bo_2
X_6125_ _3826_/A _6088_/X _6094_/X _6124_/Y VGND VGND VPWR VPWR _6125_/X sky130_fd_sc_hd__a211o_2
X_3337_ _6113_/A _3337_/B VGND VGND VPWR VPWR _3337_/Y sky130_fd_sc_hd__nor2_2
XTAP_TAPCELL_ROW_5_227 VGND VPWR sky130_fd_sc_hd__tapvpwrvgnd_1
XFILLER_58_404 VGND VGND VPWR VPWR sky130_fd_sc_hd__decap_3
X_6056_ _6077_/B _6056_/B VGND VGND VPWR VPWR _6056_/Y sky130_fd_sc_hd__nor2_2
X_3268_ _4150_/A _6442_/B VGND VGND VPWR VPWR _3269_/A sky130_fd_sc_hd__or2_2
X_5007_ _5007_/A _5007_/B VGND VGND VPWR VPWR _5007_/Y sky130_fd_sc_hd__nor2_2
XFILLER_26_356 VGND VGND VPWR VPWR sky130_fd_sc_hd__decap_3
XFILLER_38_183 VGND VGND VPWR VPWR sky130_fd_sc_hd__decap_3
XFILLER_41_326 VGND VGND VPWR VPWR sky130_fd_sc_hd__decap_3
XFILLER_41_337 VGND VGND VPWR VPWR sky130_fd_sc_hd__decap_3
XFILLER_41_348 VGND VGND VPWR VPWR sky130_fd_sc_hd__decap_3
XFILLER_53_197 VGND VGND VPWR VPWR sky130_fd_sc_hd__fill_2
X_5909_ _5909_/A _5935_/B VGND VGND VPWR VPWR _5909_/X sky130_fd_sc_hd__and2_2
XFILLER_76_223 VGND VGND VPWR VPWR sky130_fd_sc_hd__decap_3
XFILLER_76_256 VGND VGND VPWR VPWR sky130_fd_sc_hd__decap_3
XFILLER_29_172 VGND VGND VPWR VPWR sky130_fd_sc_hd__decap_3
XTAP_TAPCELL_ROW_47_605 VGND VPWR sky130_fd_sc_hd__tapvpwrvgnd_1
XFILLER_57_481 VGND VGND VPWR VPWR sky130_fd_sc_hd__fill_1
XFILLER_44_120 VGND VGND VPWR VPWR sky130_fd_sc_hd__decap_3
XFILLER_44_197 VGND VGND VPWR VPWR sky130_fd_sc_hd__decap_3
XTAP_TAPCELL_ROW_55_671 VGND VPWR sky130_fd_sc_hd__tapvpwrvgnd_1
XFILLER_40_392 VGND VGND VPWR VPWR sky130_fd_sc_hd__decap_3
XFILLER_65_6 VGND VGND VPWR VPWR sky130_fd_sc_hd__fill_1
XTAP_TAPCELL_ROW_10_273 VGND VPWR sky130_fd_sc_hd__tapvpwrvgnd_1
X_4240_ _4681_/A1 _4681_/A0 _4240_/S VGND VGND VPWR VPWR _4240_/X sky130_fd_sc_hd__mux2_2
X_4171_ _4251_/B _4251_/C _4252_/A VGND VGND VPWR VPWR _4259_/A sky130_fd_sc_hd__a21boi_2
XFILLER_67_234 VGND VGND VPWR VPWR sky130_fd_sc_hd__decap_3
XFILLER_67_212 VGND VGND VPWR VPWR sky130_fd_sc_hd__fill_1
XFILLER_67_256 VGND VGND VPWR VPWR sky130_fd_sc_hd__decap_3
XFILLER_27_109 VGND VGND VPWR VPWR sky130_fd_sc_hd__decap_3
XTAP_TAPCELL_ROW_81_906 VGND VPWR sky130_fd_sc_hd__tapvpwrvgnd_1
XFILLER_82_248 VGND VGND VPWR VPWR sky130_fd_sc_hd__decap_3
XFILLER_35_142 VGND VGND VPWR VPWR sky130_fd_sc_hd__decap_3
XTAP_TAPCELL_ROW_18_340 VGND VPWR sky130_fd_sc_hd__tapvpwrvgnd_1
XFILLER_35_186 VGND VGND VPWR VPWR sky130_fd_sc_hd__decap_3
XFILLER_50_112 VGND VGND VPWR VPWR sky130_fd_sc_hd__decap_3
X_3955_ _3982_/S _6152_/A VGND VGND VPWR VPWR _3955_/X sky130_fd_sc_hd__or2b_2
XFILLER_31_370 VGND VGND VPWR VPWR sky130_fd_sc_hd__decap_3
X_5625_ _5625_/A _5625_/B VGND VGND VPWR VPWR _5625_/Y sky130_fd_sc_hd__nor2_2
X_3886_ _6130_/S _6062_/C _3825_/B VGND VGND VPWR VPWR _3886_/Y sky130_fd_sc_hd__a21oi_2
X_5556_ _6330_/A _5556_/B _5675_/B _5530_/A VGND VGND VPWR VPWR _5556_/X sky130_fd_sc_hd__or4b_2
X_5487_ _5853_/A _5479_/X _5480_/Y _4884_/B _5486_/X VGND VGND VPWR VPWR _5487_/X
+ sky130_fd_sc_hd__o221a_2
X_4507_ _4505_/X _4506_/X _4507_/S VGND VGND VPWR VPWR _4508_/B sky130_fd_sc_hd__mux2_2
X_4438_ _4255_/B _4431_/B _4432_/X _4437_/X VGND VGND VPWR VPWR _4438_/X sky130_fd_sc_hd__o211a_2
Xfanout501 input5/X VGND VGND VPWR VPWR _3872_/A sky130_fd_sc_hd__clkdlybuf4s25_1
Xfanout512 input45/X VGND VGND VPWR VPWR _6449_/A3 sky130_fd_sc_hd__clkdlybuf4s25_1
Xfanout523 input40/X VGND VGND VPWR VPWR _6446_/A0 sky130_fd_sc_hd__clkdlybuf4s25_1
Xfanout534 input37/X VGND VGND VPWR VPWR _6450_/A1 sky130_fd_sc_hd__clkdlybuf4s25_1
Xfanout545 _4923_/A VGND VGND VPWR VPWR _4818_/A sky130_fd_sc_hd__clkdlybuf4s25_1
Xfanout556 input28/X VGND VGND VPWR VPWR _3667_/A sky130_fd_sc_hd__clkdlybuf4s25_1
X_4369_ _6176_/A _6174_/A VGND VGND VPWR VPWR _4370_/B sky130_fd_sc_hd__nand2_2
XFILLER_58_212 VGND VGND VPWR VPWR sky130_fd_sc_hd__decap_3
X_6108_ _6108_/A _6108_/B _6113_/C VGND VGND VPWR VPWR _6108_/X sky130_fd_sc_hd__or3b_2
Xfanout567 input23/X VGND VGND VPWR VPWR _6457_/A3 sky130_fd_sc_hd__clkdlybuf4s25_1
Xfanout578 _4365_/A VGND VGND VPWR VPWR _4018_/A sky130_fd_sc_hd__clkdlybuf4s25_1
Xfanout589 input19/X VGND VGND VPWR VPWR _6199_/B sky130_fd_sc_hd__clkdlybuf4s25_1
XFILLER_58_256 VGND VGND VPWR VPWR sky130_fd_sc_hd__decap_3
XFILLER_58_234 VGND VGND VPWR VPWR sky130_fd_sc_hd__decap_3
X_6039_ _5923_/A _6037_/X _6038_/X VGND VGND VPWR VPWR _6039_/X sky130_fd_sc_hd__a21bo_2
XTAP_TAPCELL_ROW_69_796 VGND VPWR sky130_fd_sc_hd__tapvpwrvgnd_1
XFILLER_73_237 VGND VGND VPWR VPWR sky130_fd_sc_hd__fill_1
XFILLER_26_153 VGND VGND VPWR VPWR sky130_fd_sc_hd__decap_3
XFILLER_26_197 VGND VGND VPWR VPWR sky130_fd_sc_hd__decap_3
XFILLER_22_392 VGND VGND VPWR VPWR sky130_fd_sc_hd__decap_3
XTAP_TAPCELL_ROW_24_398 VGND VPWR sky130_fd_sc_hd__tapvpwrvgnd_1
XFILLER_49_201 VGND VGND VPWR VPWR sky130_fd_sc_hd__decap_3
XFILLER_49_234 VGND VGND VPWR VPWR sky130_fd_sc_hd__decap_3
XFILLER_49_278 VGND VGND VPWR VPWR sky130_fd_sc_hd__fill_2
XFILLER_64_215 VGND VGND VPWR VPWR sky130_fd_sc_hd__decap_3
XFILLER_64_237 VGND VGND VPWR VPWR sky130_fd_sc_hd__decap_3
XTAP_TAPCELL_ROW_15_310 VGND VPWR sky130_fd_sc_hd__tapvpwrvgnd_1
XFILLER_72_292 VGND VGND VPWR VPWR sky130_fd_sc_hd__fill_2
XFILLER_60_410 VGND VGND VPWR VPWR sky130_fd_sc_hd__fill_1
XANTENNA_19 input43/X VGND VGND VPWR VPWR sky130_fd_sc_hd__diode_2
X_3740_ _3742_/B1 _3674_/X _3739_/X VGND VGND VPWR VPWR _3740_/X sky130_fd_sc_hd__o21a_2
XFILLER_9_330 VGND VGND VPWR VPWR sky130_fd_sc_hd__decap_3
X_3671_ _3672_/B1 _6108_/B _6122_/A1 VGND VGND VPWR VPWR _3671_/X sky130_fd_sc_hd__a21o_2
XFILLER_9_385 VGND VGND VPWR VPWR sky130_fd_sc_hd__fill_2
X_6390_ _6393_/A _6392_/B _6388_/B _6389_/X VGND VGND VPWR VPWR _6390_/X sky130_fd_sc_hd__a211o_2
X_5410_ _5408_/Y _5409_/Y _5579_/B _5270_/X VGND VGND VPWR VPWR _5580_/A sky130_fd_sc_hd__a2bb2o_2
X_5341_ _5341_/A _5341_/B VGND VGND VPWR VPWR _5422_/B sky130_fd_sc_hd__nand2_2
Xoutput148 _3375_/X VGND VGND VPWR VPWR result[1] sky130_fd_sc_hd__clkdlybuf4s25_1
Xoutput159 _3436_/X VGND VGND VPWR VPWR result[2] sky130_fd_sc_hd__clkdlybuf4s25_1
Xoutput137 _3297_/Y VGND VGND VPWR VPWR result[0] sky130_fd_sc_hd__clkdlybuf4s25_1
X_5272_ _5341_/A _5272_/B VGND VGND VPWR VPWR _5272_/Y sky130_fd_sc_hd__xnor2_2
X_4223_ _3879_/X _4222_/X _4462_/S VGND VGND VPWR VPWR _4224_/B sky130_fd_sc_hd__mux2_2
X_4154_ _4382_/S _4154_/B VGND VGND VPWR VPWR _4154_/Y sky130_fd_sc_hd__nor2_2
X_4085_ _3917_/A _4076_/Y _4084_/X VGND VGND VPWR VPWR _4120_/C sky130_fd_sc_hd__a21o_2
XFILLER_55_237 VGND VGND VPWR VPWR sky130_fd_sc_hd__fill_2
XFILLER_36_462 VGND VGND VPWR VPWR sky130_fd_sc_hd__fill_1
XTAP_TAPCELL_ROW_66_777 VGND VPWR sky130_fd_sc_hd__tapvpwrvgnd_1
XFILLER_70_218 VGND VGND VPWR VPWR sky130_fd_sc_hd__decap_3
XFILLER_63_281 VGND VGND VPWR VPWR sky130_fd_sc_hd__fill_1
XFILLER_63_270 VGND VGND VPWR VPWR sky130_fd_sc_hd__fill_2
X_4987_ _6077_/C _4987_/B VGND VGND VPWR VPWR _4987_/Y sky130_fd_sc_hd__nand2_2
X_3938_ _3432_/A _6086_/A _3937_/X VGND VGND VPWR VPWR _3938_/Y sky130_fd_sc_hd__a21oi_2
X_3869_ _3868_/X _6144_/B _3907_/C VGND VGND VPWR VPWR _3869_/X sky130_fd_sc_hd__mux2_2
XTAP_TAPCELL_ROW_21_368 VGND VPWR sky130_fd_sc_hd__tapvpwrvgnd_1
X_5608_ _6497_/A _5608_/B VGND VGND VPWR VPWR _5608_/Y sky130_fd_sc_hd__nor2_2
X_5539_ _5624_/B _5539_/B _5625_/A _5538_/Y VGND VGND VPWR VPWR _6494_/A sky130_fd_sc_hd__nor4b_2
Xfanout342 _3424_/B VGND VGND VPWR VPWR _3648_/S1 sky130_fd_sc_hd__clkdlybuf4s25_1
Xfanout353 _3798_/A VGND VGND VPWR VPWR _6013_/C sky130_fd_sc_hd__clkdlybuf4s25_1
Xfanout364 _4513_/A VGND VGND VPWR VPWR _6189_/A sky130_fd_sc_hd__clkdlybuf4s25_1
Xfanout375 _6450_/S0 VGND VGND VPWR VPWR _3584_/S0 sky130_fd_sc_hd__clkdlybuf4s25_1
XFILLER_46_226 VGND VGND VPWR VPWR sky130_fd_sc_hd__decap_3
XFILLER_36_64 VGND VGND VPWR VPWR sky130_fd_sc_hd__decap_3
XFILLER_46_259 VGND VGND VPWR VPWR sky130_fd_sc_hd__decap_3
XFILLER_14_112 VGND VGND VPWR VPWR sky130_fd_sc_hd__fill_1
XFILLER_42_421 VGND VGND VPWR VPWR sky130_fd_sc_hd__fill_2
XFILLER_54_281 VGND VGND VPWR VPWR sky130_fd_sc_hd__decap_3
XFILLER_52_85 VGND VGND VPWR VPWR sky130_fd_sc_hd__fill_1
Xinput28 operand_a[2] VGND VGND VPWR VPWR input28/X sky130_fd_sc_hd__clkdlybuf4s25_1
Xinput17 operand_a[1] VGND VGND VPWR VPWR _3412_/A sky130_fd_sc_hd__clkdlybuf4s25_1
Xinput39 operand_a[3] VGND VGND VPWR VPWR input39/X sky130_fd_sc_hd__clkdlybuf4s25_1
XFILLER_6_344 VGND VGND VPWR VPWR sky130_fd_sc_hd__fill_2
XFILLER_69_329 VGND VGND VPWR VPWR sky130_fd_sc_hd__decap_3
XFILLER_28_6 VGND VGND VPWR VPWR sky130_fd_sc_hd__decap_3
XFILLER_37_248 VGND VGND VPWR VPWR sky130_fd_sc_hd__fill_2
XFILLER_33_410 VGND VGND VPWR VPWR sky130_fd_sc_hd__decap_3
XFILLER_45_281 VGND VGND VPWR VPWR sky130_fd_sc_hd__decap_3
XFILLER_52_218 VGND VGND VPWR VPWR sky130_fd_sc_hd__decap_3
X_5890_ _5923_/A _5923_/B _5923_/C _5923_/D VGND VGND VPWR VPWR _5890_/Y sky130_fd_sc_hd__nand4_2
X_4910_ _4910_/A _4910_/B VGND VGND VPWR VPWR _4910_/X sky130_fd_sc_hd__or2_2
XTAP_TAPCELL_ROW_63_747 VGND VPWR sky130_fd_sc_hd__tapvpwrvgnd_1
X_4841_ _5440_/A _5618_/A VGND VGND VPWR VPWR _4841_/Y sky130_fd_sc_hd__nand2_2
XFILLER_60_251 VGND VGND VPWR VPWR sky130_fd_sc_hd__fill_1
X_4772_ _6244_/A _4772_/B VGND VGND VPWR VPWR _4772_/Y sky130_fd_sc_hd__nor2_2
XFILLER_60_284 VGND VGND VPWR VPWR sky130_fd_sc_hd__decap_3
X_3723_ _3723_/A VGND VGND VPWR VPWR _5685_/A sky130_fd_sc_hd__clkbuf_2
XFILLER_9_160 VGND VGND VPWR VPWR sky130_fd_sc_hd__fill_1
X_6442_ _6442_/A _6442_/B VGND VGND VPWR VPWR _6443_/B sky130_fd_sc_hd__nand2_2
X_3654_ _6467_/A2 input14/X _4241_/C _6461_/A3 _3654_/S0 _3654_/S1 VGND VGND VPWR
+ VPWR _3654_/X sky130_fd_sc_hd__mux4_2
X_6373_ _6319_/A _6357_/X _6372_/X _5328_/S _6319_/B VGND VGND VPWR VPWR _6373_/X
+ sky130_fd_sc_hd__a221o_2
X_3585_ _3581_/X _3582_/X _3583_/X _3584_/X _3495_/A _3469_/S VGND VGND VPWR VPWR
+ _5013_/B sky130_fd_sc_hd__mux4_2
X_5324_ _4761_/X _4677_/X _5323_/X VGND VGND VPWR VPWR _5324_/X sky130_fd_sc_hd__a21o_2
X_5255_ _6391_/D _6392_/B VGND VGND VPWR VPWR _5256_/B sky130_fd_sc_hd__or2b_2
X_4206_ _3703_/A _5510_/A _4205_/X _5590_/A1 VGND VGND VPWR VPWR _4207_/B sky130_fd_sc_hd__a2bb2o_2
X_5186_ _4503_/Y _4841_/Y _5090_/B _3785_/Y _5185_/X VGND VGND VPWR VPWR _5186_/X
+ sky130_fd_sc_hd__o221a_2
XFILLER_68_362 VGND VGND VPWR VPWR sky130_fd_sc_hd__fill_2
XFILLER_28_215 VGND VGND VPWR VPWR sky130_fd_sc_hd__fill_1
XFILLER_28_237 VGND VGND VPWR VPWR sky130_fd_sc_hd__decap_3
X_4137_ _3930_/X _4099_/X _4139_/S VGND VGND VPWR VPWR _4137_/X sky130_fd_sc_hd__mux2_2
XTAP_TAPCELL_ROW_79_891 VGND VPWR sky130_fd_sc_hd__tapvpwrvgnd_1
X_4068_ _4076_/A _4076_/B _6154_/B _4076_/D VGND VGND VPWR VPWR _4069_/B sky130_fd_sc_hd__and4_2
XTAP_TAPCELL_ROW_26_416 VGND VPWR sky130_fd_sc_hd__tapvpwrvgnd_1
XFILLER_36_281 VGND VGND VPWR VPWR sky130_fd_sc_hd__decap_3
XFILLER_51_240 VGND VGND VPWR VPWR sky130_fd_sc_hd__decap_3
XFILLER_51_273 VGND VGND VPWR VPWR sky130_fd_sc_hd__decap_3
XTAP_TAPCELL_ROW_34_482 VGND VPWR sky130_fd_sc_hd__tapvpwrvgnd_1
XFILLER_59_340 VGND VGND VPWR VPWR sky130_fd_sc_hd__decap_3
XFILLER_59_373 VGND VGND VPWR VPWR sky130_fd_sc_hd__decap_3
XFILLER_27_281 VGND VGND VPWR VPWR sky130_fd_sc_hd__decap_3
XFILLER_42_262 VGND VGND VPWR VPWR sky130_fd_sc_hd__decap_3
XTAP_TAPCELL_ROW_60_717 VGND VPWR sky130_fd_sc_hd__tapvpwrvgnd_1
Xmax_cap317 _5039_/B VGND VGND VPWR VPWR _5108_/B sky130_fd_sc_hd__clkbuf_2
Xmax_cap306 _3981_/X VGND VGND VPWR VPWR _5352_/C sky130_fd_sc_hd__buf_2
Xmax_cap328 _4077_/B VGND VGND VPWR VPWR _3745_/A sky130_fd_sc_hd__clkbuf_2
X_3370_ _3370_/A VGND VGND VPWR VPWR _3370_/X sky130_fd_sc_hd__clkbuf_1
X_5040_ _6265_/A _5002_/A _6270_/A _6265_/B VGND VGND VPWR VPWR _5040_/X sky130_fd_sc_hd__a22o_2
XFILLER_26_3 VGND VGND VPWR VPWR sky130_fd_sc_hd__fill_1
XTAP_TAPCELL_ROW_76_861 VGND VPWR sky130_fd_sc_hd__tapvpwrvgnd_1
XFILLER_65_365 VGND VGND VPWR VPWR sky130_fd_sc_hd__fill_2
XFILLER_25_207 VGND VGND VPWR VPWR sky130_fd_sc_hd__decap_3
X_5942_ _5934_/A _5941_/X _5942_/S VGND VGND VPWR VPWR _5942_/X sky130_fd_sc_hd__mux2_2
XFILLER_21_402 VGND VGND VPWR VPWR sky130_fd_sc_hd__decap_3
X_5873_ _5816_/A _5816_/B _5874_/C _5872_/Y VGND VGND VPWR VPWR _5923_/B sky130_fd_sc_hd__a211o_2
XFILLER_33_284 VGND VGND VPWR VPWR sky130_fd_sc_hd__decap_3
X_4824_ _4819_/X _4954_/B _4824_/S VGND VGND VPWR VPWR _4824_/X sky130_fd_sc_hd__mux2_2
X_4755_ _5007_/A _4755_/B VGND VGND VPWR VPWR _4755_/Y sky130_fd_sc_hd__nor2_2
X_3706_ _3624_/X _3705_/X _3706_/S VGND VGND VPWR VPWR _3707_/B sky130_fd_sc_hd__mux2_2
X_4686_ _3993_/A _4680_/X _4683_/X _4339_/A _4685_/X VGND VGND VPWR VPWR _4686_/X
+ sky130_fd_sc_hd__a221o_2
X_6425_ _4506_/S _3451_/S _6098_/A VGND VGND VPWR VPWR _6426_/B sky130_fd_sc_hd__o21ai_2
X_3637_ _4086_/A _6120_/B VGND VGND VPWR VPWR _3637_/Y sky130_fd_sc_hd__nand2_2
X_6356_ _6008_/B _6337_/B _6359_/A VGND VGND VPWR VPWR _6356_/X sky130_fd_sc_hd__a21o_2
X_3568_ _3679_/D _3568_/B VGND VGND VPWR VPWR _3568_/X sky130_fd_sc_hd__xor2_2
X_5307_ _6359_/A VGND VGND VPWR VPWR _5308_/B sky130_fd_sc_hd__inv_2
X_6287_ _6363_/A _6287_/B VGND VGND VPWR VPWR _6287_/Y sky130_fd_sc_hd__nor2_2
X_3499_ _6440_/A0 _6440_/A3 _6440_/A1 _6440_/A2 _3625_/A _3499_/S1 VGND VGND VPWR
+ VPWR _3499_/X sky130_fd_sc_hd__mux4_2
X_5238_ _5082_/X _5237_/X _5616_/A VGND VGND VPWR VPWR _5238_/X sky130_fd_sc_hd__mux2_2
XFILLER_56_321 VGND VGND VPWR VPWR sky130_fd_sc_hd__decap_3
X_5169_ _5628_/A _5168_/B _5167_/X _5168_/Y _5172_/B VGND VGND VPWR VPWR _5169_/X
+ sky130_fd_sc_hd__o32a_2
XFILLER_56_365 VGND VGND VPWR VPWR sky130_fd_sc_hd__decap_3
XTAP_TAPCELL_ROW_39_530 VGND VPWR sky130_fd_sc_hd__tapvpwrvgnd_1
XFILLER_24_262 VGND VGND VPWR VPWR sky130_fd_sc_hd__decap_3
XFILLER_24_284 VGND VGND VPWR VPWR sky130_fd_sc_hd__decap_3
XFILLER_33_32 VGND VGND VPWR VPWR sky130_fd_sc_hd__fill_1
XFILLER_58_73 VGND VGND VPWR VPWR sky130_fd_sc_hd__fill_2
XFILLER_59_181 VGND VGND VPWR VPWR sky130_fd_sc_hd__decap_3
XFILLER_47_343 VGND VGND VPWR VPWR sky130_fd_sc_hd__decap_3
XFILLER_47_387 VGND VGND VPWR VPWR sky130_fd_sc_hd__decap_3
XFILLER_62_324 VGND VGND VPWR VPWR sky130_fd_sc_hd__decap_3
XTAP_TAPCELL_ROW_45_588 VGND VPWR sky130_fd_sc_hd__tapvpwrvgnd_1
XFILLER_62_368 VGND VGND VPWR VPWR sky130_fd_sc_hd__decap_3
XFILLER_30_232 VGND VGND VPWR VPWR sky130_fd_sc_hd__decap_3
XFILLER_30_276 VGND VGND VPWR VPWR sky130_fd_sc_hd__decap_3
X_4540_ _6224_/A _6189_/A _4540_/C VGND VGND VPWR VPWR _4540_/X sky130_fd_sc_hd__or3_2
X_4471_ _4515_/A _4681_/A0 _4484_/A VGND VGND VPWR VPWR _4471_/X sky130_fd_sc_hd__mux2_2
X_6210_ _6210_/A _6210_/B VGND VGND VPWR VPWR _6210_/Y sky130_fd_sc_hd__nand2_2
X_3422_ _3408_/Y _3372_/A _3412_/Y VGND VGND VPWR VPWR _3423_/B sky130_fd_sc_hd__a21o_2
X_6141_ _3826_/A _6088_/X _6132_/X _6140_/X VGND VGND VPWR VPWR _6141_/X sky130_fd_sc_hd__o211a_2
X_3353_ _3515_/B _3420_/A VGND VGND VPWR VPWR _3353_/Y sky130_fd_sc_hd__nor2b_2
X_6072_ _6072_/A _6258_/A VGND VGND VPWR VPWR _6072_/Y sky130_fd_sc_hd__nor2_2
X_3284_ _3280_/X _3281_/X _3282_/X _3283_/X _3571_/S _3800_/A VGND VGND VPWR VPWR
+ _3284_/X sky130_fd_sc_hd__mux4_2
Xload_slew397 _3758_/S VGND VGND VPWR VPWR _3791_/S sky130_fd_sc_hd__buf_2
Xload_slew386 _3499_/S1 VGND VGND VPWR VPWR _3631_/S0 sky130_fd_sc_hd__clkbuf_4
X_5023_ _5228_/A _5023_/B _5023_/C _5023_/D VGND VGND VPWR VPWR _5023_/X sky130_fd_sc_hd__or4_2
XFILLER_38_365 VGND VGND VPWR VPWR sky130_fd_sc_hd__decap_3
XTAP_TAPCELL_ROW_36_500 VGND VPWR sky130_fd_sc_hd__tapvpwrvgnd_1
XFILLER_53_335 VGND VGND VPWR VPWR sky130_fd_sc_hd__fill_1
XTAP_TAPCELL_ROW_0_169 VGND VPWR sky130_fd_sc_hd__tapvpwrvgnd_1
XFILLER_65_184 VGND VGND VPWR VPWR sky130_fd_sc_hd__decap_3
XFILLER_53_368 VGND VGND VPWR VPWR sky130_fd_sc_hd__decap_3
X_5925_ _5925_/A _6040_/B VGND VGND VPWR VPWR _5925_/Y sky130_fd_sc_hd__nand2_2
X_5856_ _5441_/X _5584_/X _5737_/X _5855_/X _5947_/S _5239_/X VGND VGND VPWR VPWR
+ _5856_/X sky130_fd_sc_hd__mux4_2
X_4807_ _5176_/S VGND VGND VPWR VPWR _5739_/A sky130_fd_sc_hd__clkbuf_1
XPHY_EDGE_ROW_3_Right_3 VGND VGND VPWR VPWR sky130_fd_sc_hd__decap_3
XFILLER_21_287 VGND VGND VPWR VPWR sky130_fd_sc_hd__decap_3
X_5787_ _5787_/A _5787_/B VGND VGND VPWR VPWR _6495_/D sky130_fd_sc_hd__or2_2
X_4738_ _4702_/Y _4701_/X input93/X VGND VGND VPWR VPWR _4738_/X sky130_fd_sc_hd__a21o_2
X_4669_ _4967_/B _4669_/B VGND VGND VPWR VPWR _4669_/X sky130_fd_sc_hd__xor2_2
X_6408_ _6410_/A _6479_/A VGND VGND VPWR VPWR _6408_/Y sky130_fd_sc_hd__nor2_2
X_6339_ _6339_/A _6339_/B VGND VGND VPWR VPWR _6339_/X sky130_fd_sc_hd__or2_2
XTAP_TAPCELL_ROW_8_247 VGND VPWR sky130_fd_sc_hd__tapvpwrvgnd_1
XFILLER_28_98 VGND VGND VPWR VPWR sky130_fd_sc_hd__decap_3
XFILLER_29_376 VGND VGND VPWR VPWR sky130_fd_sc_hd__decap_3
XFILLER_44_324 VGND VGND VPWR VPWR sky130_fd_sc_hd__decap_3
XFILLER_44_357 VGND VGND VPWR VPWR sky130_fd_sc_hd__decap_3
XFILLER_44_368 VGND VGND VPWR VPWR sky130_fd_sc_hd__decap_3
XTAP_TAPCELL_ROW_70_812 VGND VPWR sky130_fd_sc_hd__tapvpwrvgnd_1
XFILLER_12_210 VGND VGND VPWR VPWR sky130_fd_sc_hd__fill_1
XTAP_TAPCELL_ROW_42_558 VGND VPWR sky130_fd_sc_hd__tapvpwrvgnd_1
XFILLER_60_63 VGND VGND VPWR VPWR sky130_fd_sc_hd__fill_2
XFILLER_79_265 VGND VGND VPWR VPWR sky130_fd_sc_hd__decap_3
XFILLER_39_118 VGND VGND VPWR VPWR sky130_fd_sc_hd__decap_3
XFILLER_67_449 VGND VGND VPWR VPWR sky130_fd_sc_hd__fill_2
XFILLER_47_140 VGND VGND VPWR VPWR sky130_fd_sc_hd__decap_3
XFILLER_35_313 VGND VGND VPWR VPWR sky130_fd_sc_hd__decap_3
XFILLER_47_184 VGND VGND VPWR VPWR sky130_fd_sc_hd__decap_3
XFILLER_62_132 VGND VGND VPWR VPWR sky130_fd_sc_hd__decap_3
XFILLER_35_368 VGND VGND VPWR VPWR sky130_fd_sc_hd__decap_3
X_3971_ _4460_/S VGND VGND VPWR VPWR _4674_/S sky130_fd_sc_hd__clkbuf_2
XFILLER_62_154 VGND VGND VPWR VPWR sky130_fd_sc_hd__decap_3
XFILLER_50_327 VGND VGND VPWR VPWR sky130_fd_sc_hd__decap_3
X_5710_ _5710_/A _5710_/B _5712_/D VGND VGND VPWR VPWR _5710_/X sky130_fd_sc_hd__or3b_2
XFILLER_62_176 VGND VGND VPWR VPWR sky130_fd_sc_hd__decap_3
X_5641_ _5712_/B _5712_/C VGND VGND VPWR VPWR _5710_/A sky130_fd_sc_hd__nand2_2
X_5572_ _5538_/A _5538_/B _5572_/C _5572_/D VGND VGND VPWR VPWR _5573_/D sky130_fd_sc_hd__and4bb_2
XTAP_TAPCELL_ROW_13_293 VGND VPWR sky130_fd_sc_hd__tapvpwrvgnd_1
X_4523_ _6224_/A _4499_/X _4522_/Y VGND VGND VPWR VPWR _4523_/X sky130_fd_sc_hd__a21o_2
X_4454_ _4454_/A _4454_/B VGND VGND VPWR VPWR _4455_/B sky130_fd_sc_hd__nand2_2
X_4385_ _6199_/B _6021_/D VGND VGND VPWR VPWR _4385_/X sky130_fd_sc_hd__or2_2
X_3405_ _6012_/B _3357_/B _3410_/B _3371_/A VGND VGND VPWR VPWR _3464_/C sky130_fd_sc_hd__o22a_2
X_6124_ _6112_/Y _6118_/Y _6123_/Y VGND VGND VPWR VPWR _6124_/Y sky130_fd_sc_hd__a21oi_2
X_3336_ _3710_/A _4837_/B _3334_/X _3976_/A VGND VGND VPWR VPWR _3337_/B sky130_fd_sc_hd__a22oi_2
XTAP_TAPCELL_ROW_5_228 VGND VPWR sky130_fd_sc_hd__tapvpwrvgnd_1
XFILLER_58_416 VGND VGND VPWR VPWR sky130_fd_sc_hd__decap_3
X_6055_ _6077_/A _6055_/B VGND VGND VPWR VPWR _6056_/B sky130_fd_sc_hd__and2_2
X_5006_ _5039_/B _5006_/B VGND VGND VPWR VPWR _5007_/B sky130_fd_sc_hd__xnor2_2
X_3267_ _3267_/A VGND VGND VPWR VPWR _6426_/A sky130_fd_sc_hd__clkbuf_1
XFILLER_38_151 VGND VGND VPWR VPWR sky130_fd_sc_hd__decap_3
XFILLER_53_132 VGND VGND VPWR VPWR sky130_fd_sc_hd__decap_3
XFILLER_26_368 VGND VGND VPWR VPWR sky130_fd_sc_hd__decap_3
XFILLER_41_305 VGND VGND VPWR VPWR sky130_fd_sc_hd__decap_3
XFILLER_53_154 VGND VGND VPWR VPWR sky130_fd_sc_hd__decap_3
XFILLER_53_176 VGND VGND VPWR VPWR sky130_fd_sc_hd__decap_3
X_5908_ _5909_/A _5908_/B VGND VGND VPWR VPWR _5908_/Y sky130_fd_sc_hd__nor2_2
XFILLER_14_56 VGND VGND VPWR VPWR sky130_fd_sc_hd__fill_2
X_5839_ _6497_/A _6493_/B _5827_/X _5838_/X VGND VGND VPWR VPWR _6004_/B sky130_fd_sc_hd__o211ai_2
XFILLER_49_405 VGND VGND VPWR VPWR sky130_fd_sc_hd__decap_3
XFILLER_39_53 VGND VGND VPWR VPWR sky130_fd_sc_hd__decap_3
XFILLER_49_449 VGND VGND VPWR VPWR sky130_fd_sc_hd__fill_2
XFILLER_76_202 VGND VGND VPWR VPWR sky130_fd_sc_hd__decap_3
XFILLER_76_235 VGND VGND VPWR VPWR sky130_fd_sc_hd__decap_3
XFILLER_29_162 VGND VGND VPWR VPWR sky130_fd_sc_hd__decap_3
XTAP_TAPCELL_ROW_47_606 VGND VPWR sky130_fd_sc_hd__tapvpwrvgnd_1
XFILLER_29_184 VGND VGND VPWR VPWR sky130_fd_sc_hd__decap_3
XFILLER_44_110 VGND VGND VPWR VPWR sky130_fd_sc_hd__decap_3
XFILLER_17_379 VGND VGND VPWR VPWR sky130_fd_sc_hd__fill_1
XFILLER_44_132 VGND VGND VPWR VPWR sky130_fd_sc_hd__decap_3
XFILLER_44_165 VGND VGND VPWR VPWR sky130_fd_sc_hd__decap_3
XTAP_TAPCELL_ROW_55_672 VGND VPWR sky130_fd_sc_hd__tapvpwrvgnd_1
XFILLER_40_371 VGND VGND VPWR VPWR sky130_fd_sc_hd__decap_3
XFILLER_4_294 VGND VGND VPWR VPWR sky130_fd_sc_hd__fill_2
X_4170_ _4170_/A _6167_/C VGND VGND VPWR VPWR _4249_/A sky130_fd_sc_hd__nand2_2
XFILLER_55_408 VGND VGND VPWR VPWR sky130_fd_sc_hd__decap_3
XFILLER_67_268 VGND VGND VPWR VPWR sky130_fd_sc_hd__decap_3
XFILLER_35_110 VGND VGND VPWR VPWR sky130_fd_sc_hd__fill_2
XTAP_TAPCELL_ROW_81_907 VGND VPWR sky130_fd_sc_hd__tapvpwrvgnd_1
XTAP_TAPCELL_ROW_18_341 VGND VPWR sky130_fd_sc_hd__tapvpwrvgnd_1
XFILLER_35_198 VGND VGND VPWR VPWR sky130_fd_sc_hd__decap_3
XFILLER_50_124 VGND VGND VPWR VPWR sky130_fd_sc_hd__decap_3
X_3954_ _6152_/A _3982_/S VGND VGND VPWR VPWR _3956_/A sky130_fd_sc_hd__nor2b_2
X_3885_ _6130_/S _6062_/C VGND VGND VPWR VPWR _3885_/Y sky130_fd_sc_hd__nor2_2
XFILLER_31_393 VGND VGND VPWR VPWR sky130_fd_sc_hd__decap_3
X_5624_ _5624_/A _5624_/B _5624_/C _5538_/Y VGND VGND VPWR VPWR _5625_/B sky130_fd_sc_hd__or4b_4
X_5555_ _6333_/A _5477_/A _5658_/C _5556_/B _5554_/X VGND VGND VPWR VPWR _5555_/X
+ sky130_fd_sc_hd__a221o_2
X_5486_ _4884_/A _4145_/X _5484_/Y _5485_/Y VGND VGND VPWR VPWR _5486_/X sky130_fd_sc_hd__a22o_2
X_4506_ _4139_/X _4137_/X _4506_/S VGND VGND VPWR VPWR _4506_/X sky130_fd_sc_hd__mux2_2
X_4437_ _6178_/A _4408_/X _4434_/X _4435_/X _4436_/X VGND VGND VPWR VPWR _4437_/X
+ sky130_fd_sc_hd__a2111o_2
XFILLER_6_90 VGND VGND VPWR VPWR sky130_fd_sc_hd__fill_2
Xfanout502 _6439_/A3 VGND VGND VPWR VPWR _5476_/S sky130_fd_sc_hd__clkdlybuf4s25_1
Xfanout513 input44/X VGND VGND VPWR VPWR _5316_/A sky130_fd_sc_hd__clkdlybuf4s25_1
Xfanout524 _3420_/A VGND VGND VPWR VPWR _3361_/C sky130_fd_sc_hd__clkdlybuf4s25_1
X_6107_ _6109_/A _6113_/C _6106_/X _3679_/A VGND VGND VPWR VPWR _6107_/Y sky130_fd_sc_hd__o211ai_2
Xfanout535 _6450_/A3 VGND VGND VPWR VPWR _6265_/B sky130_fd_sc_hd__clkdlybuf4s25_1
Xfanout546 _6447_/A0 VGND VGND VPWR VPWR _4923_/A sky130_fd_sc_hd__clkdlybuf4s25_1
Xfanout557 _6460_/A3 VGND VGND VPWR VPWR _4695_/A sky130_fd_sc_hd__clkdlybuf4s25_1
X_4368_ _6059_/A VGND VGND VPWR VPWR _6174_/A sky130_fd_sc_hd__inv_2
Xfanout568 _6224_/A VGND VGND VPWR VPWR _4429_/A sky130_fd_sc_hd__clkdlybuf4s25_1
X_4299_ _6200_/B _6021_/D VGND VGND VPWR VPWR _4301_/A sky130_fd_sc_hd__nor2_2
X_3319_ _5615_/A3 _6440_/A0 _6440_/A1 _6428_/A0 _6439_/S0 _3780_/A VGND VGND VPWR
+ VPWR _3319_/X sky130_fd_sc_hd__mux4_2
X_6038_ _6400_/A _6040_/A _6417_/B _6040_/B VGND VGND VPWR VPWR _6038_/X sky130_fd_sc_hd__a31o_2
XTAP_TAPCELL_ROW_69_797 VGND VPWR sky130_fd_sc_hd__tapvpwrvgnd_1
XFILLER_58_268 VGND VGND VPWR VPWR sky130_fd_sc_hd__decap_3
XFILLER_54_474 VGND VGND VPWR VPWR sky130_fd_sc_hd__fill_2
XFILLER_41_124 VGND VGND VPWR VPWR sky130_fd_sc_hd__fill_1
XFILLER_41_146 VGND VGND VPWR VPWR sky130_fd_sc_hd__decap_3
XTAP_TAPCELL_ROW_24_399 VGND VPWR sky130_fd_sc_hd__tapvpwrvgnd_1
XFILLER_49_213 VGND VGND VPWR VPWR sky130_fd_sc_hd__decap_3
XFILLER_64_227 VGND VGND VPWR VPWR sky130_fd_sc_hd__decap_3
XTAP_TAPCELL_ROW_15_311 VGND VPWR sky130_fd_sc_hd__tapvpwrvgnd_1
XFILLER_32_157 VGND VGND VPWR VPWR sky130_fd_sc_hd__decap_3
XFILLER_13_393 VGND VGND VPWR VPWR sky130_fd_sc_hd__decap_3
X_3670_ _3681_/A _6014_/B VGND VGND VPWR VPWR _3670_/X sky130_fd_sc_hd__or2_2
X_5340_ _4378_/X _4721_/X _5046_/X _5339_/X _5548_/S _5284_/S VGND VGND VPWR VPWR
+ _5340_/X sky130_fd_sc_hd__mux4_2
Xoutput149 _5996_/B VGND VGND VPWR VPWR result[20] sky130_fd_sc_hd__clkdlybuf4s25_1
Xoutput138 _5991_/C VGND VGND VPWR VPWR result[10] sky130_fd_sc_hd__clkdlybuf4s25_1
X_5271_ _5688_/A1 _5579_/A _5270_/X VGND VGND VPWR VPWR _5272_/B sky130_fd_sc_hd__a21o_2
X_4222_ _4053_/X _4221_/X _4461_/S VGND VGND VPWR VPWR _4222_/X sky130_fd_sc_hd__mux2_2
X_4153_ _4150_/A _3805_/B _4150_/Y VGND VGND VPWR VPWR _5485_/A sky130_fd_sc_hd__a21oi_2
XFILLER_55_205 VGND VGND VPWR VPWR sky130_fd_sc_hd__decap_3
X_4084_ _4084_/A _4084_/B _4084_/C VGND VGND VPWR VPWR _4084_/X sky130_fd_sc_hd__and3_2
X_4986_ _4940_/X _4941_/X _4997_/A VGND VGND VPWR VPWR _4986_/X sky130_fd_sc_hd__mux2_2
XFILLER_23_157 VGND VGND VPWR VPWR sky130_fd_sc_hd__decap_3
X_3937_ _4200_/A _4199_/A _3937_/S VGND VGND VPWR VPWR _3937_/X sky130_fd_sc_hd__mux2_2
XFILLER_31_190 VGND VGND VPWR VPWR sky130_fd_sc_hd__decap_3
X_3868_ _6130_/S _6129_/A VGND VGND VPWR VPWR _3868_/X sky130_fd_sc_hd__or2_2
XTAP_TAPCELL_ROW_21_369 VGND VPWR sky130_fd_sc_hd__tapvpwrvgnd_1
X_5607_ _5628_/C _5607_/B VGND VGND VPWR VPWR _5608_/B sky130_fd_sc_hd__xnor2_2
X_3799_ _3799_/A _3799_/B VGND VGND VPWR VPWR _3799_/X sky130_fd_sc_hd__or2_2
X_5538_ _5538_/A _5538_/B _5572_/C VGND VGND VPWR VPWR _5538_/Y sky130_fd_sc_hd__nor3b_2
X_5469_ _5469_/A _5469_/B VGND VGND VPWR VPWR _5499_/D sky130_fd_sc_hd__nor2_2
Xfanout343 _3424_/B VGND VGND VPWR VPWR _3527_/S sky130_fd_sc_hd__clkdlybuf4s25_1
Xfanout365 input86/X VGND VGND VPWR VPWR _4513_/A sky130_fd_sc_hd__clkdlybuf4s25_1
XFILLER_46_205 VGND VGND VPWR VPWR sky130_fd_sc_hd__decap_3
Xfanout387 fanout406/X VGND VGND VPWR VPWR fanout387/X sky130_fd_sc_hd__clkdlybuf4s25_1
Xfanout398 fanout406/X VGND VGND VPWR VPWR _3376_/S0 sky130_fd_sc_hd__clkdlybuf4s25_1
XFILLER_46_238 VGND VGND VPWR VPWR sky130_fd_sc_hd__decap_3
XTAP_TAPCELL_ROW_29_436 VGND VPWR sky130_fd_sc_hd__tapvpwrvgnd_1
XFILLER_54_271 VGND VGND VPWR VPWR sky130_fd_sc_hd__fill_2
XFILLER_61_219 VGND VGND VPWR VPWR sky130_fd_sc_hd__decap_3
XFILLER_10_330 VGND VGND VPWR VPWR sky130_fd_sc_hd__decap_3
Xinput18 operand_a[20] VGND VGND VPWR VPWR input18/X sky130_fd_sc_hd__clkdlybuf4s25_1
Xinput29 operand_a[30] VGND VGND VPWR VPWR input29/X sky130_fd_sc_hd__clkdlybuf4s25_1
XFILLER_10_396 VGND VGND VPWR VPWR sky130_fd_sc_hd__decap_3
XFILLER_6_356 VGND VGND VPWR VPWR sky130_fd_sc_hd__decap_3
XFILLER_65_503 VGND VGND VPWR VPWR sky130_fd_sc_hd__fill_1
XFILLER_45_271 VGND VGND VPWR VPWR sky130_fd_sc_hd__decap_3
XFILLER_45_293 VGND VGND VPWR VPWR sky130_fd_sc_hd__decap_3
X_4840_ _5138_/A _4840_/B VGND VGND VPWR VPWR _4840_/Y sky130_fd_sc_hd__nor2_2
XTAP_TAPCELL_ROW_63_748 VGND VPWR sky130_fd_sc_hd__tapvpwrvgnd_1
XFILLER_60_230 VGND VGND VPWR VPWR sky130_fd_sc_hd__decap_3
XFILLER_20_138 VGND VGND VPWR VPWR sky130_fd_sc_hd__fill_2
X_4771_ _6244_/A _4772_/B _4751_/A VGND VGND VPWR VPWR _4771_/Y sky130_fd_sc_hd__a21oi_2
X_3722_ _3722_/A VGND VGND VPWR VPWR _3722_/Y sky130_fd_sc_hd__inv_2
X_6441_ _6439_/X _6440_/X _6463_/S VGND VGND VPWR VPWR _6441_/X sky130_fd_sc_hd__mux2_2
X_3653_ _3379_/X _3652_/X _3653_/S VGND VGND VPWR VPWR _3653_/X sky130_fd_sc_hd__mux2_2
X_6372_ _5316_/A _6287_/B _6359_/X _6319_/A VGND VGND VPWR VPWR _6372_/X sky130_fd_sc_hd__a2bb2o_2
X_5323_ _3986_/X _4885_/A _5904_/A3 _3985_/X _4879_/S VGND VGND VPWR VPWR _5323_/X
+ sky130_fd_sc_hd__a221o_2
X_3584_ _6450_/A3 _5096_/A _5281_/A3 _5338_/A3 _3584_/S0 _3895_/A2 VGND VGND VPWR
+ VPWR _3584_/X sky130_fd_sc_hd__mux4_2
X_5254_ _5159_/A _5277_/B _5223_/X VGND VGND VPWR VPWR _5258_/C sky130_fd_sc_hd__a21oi_2
X_5185_ _4926_/A _5181_/X _5184_/X _5007_/A _5061_/A VGND VGND VPWR VPWR _5185_/X
+ sky130_fd_sc_hd__o221a_2
X_4205_ _6100_/B _3451_/S _3398_/A _3703_/A VGND VGND VPWR VPWR _4205_/X sky130_fd_sc_hd__a31o_2
XFILLER_68_330 VGND VGND VPWR VPWR sky130_fd_sc_hd__decap_3
X_4136_ _4136_/A _4136_/B VGND VGND VPWR VPWR _4136_/Y sky130_fd_sc_hd__xnor2_2
XTAP_TAPCELL_ROW_79_892 VGND VPWR sky130_fd_sc_hd__tapvpwrvgnd_1
X_4067_ _6138_/A _6089_/A VGND VGND VPWR VPWR _4447_/A sky130_fd_sc_hd__or2_2
XFILLER_24_411 VGND VGND VPWR VPWR sky130_fd_sc_hd__decap_3
XFILLER_43_208 VGND VGND VPWR VPWR sky130_fd_sc_hd__decap_3
XTAP_TAPCELL_ROW_26_417 VGND VPWR sky130_fd_sc_hd__tapvpwrvgnd_1
XFILLER_51_252 VGND VGND VPWR VPWR sky130_fd_sc_hd__decap_3
XFILLER_11_116 VGND VGND VPWR VPWR sky130_fd_sc_hd__decap_3
XFILLER_24_499 VGND VGND VPWR VPWR sky130_fd_sc_hd__fill_1
X_4969_ _4969_/A VGND VGND VPWR VPWR _4969_/X sky130_fd_sc_hd__clkbuf_1
XTAP_TAPCELL_ROW_34_483 VGND VPWR sky130_fd_sc_hd__tapvpwrvgnd_1
XFILLER_47_514 VGND VGND VPWR VPWR sky130_fd_sc_hd__fill_2
XFILLER_59_352 VGND VGND VPWR VPWR sky130_fd_sc_hd__decap_3
XFILLER_59_396 VGND VGND VPWR VPWR sky130_fd_sc_hd__decap_3
XFILLER_59_385 VGND VGND VPWR VPWR sky130_fd_sc_hd__decap_3
XFILLER_42_230 VGND VGND VPWR VPWR sky130_fd_sc_hd__decap_3
XTAP_TAPCELL_ROW_60_718 VGND VPWR sky130_fd_sc_hd__tapvpwrvgnd_1
XFILLER_8_36 VGND VGND VPWR VPWR sky130_fd_sc_hd__fill_2
Xmax_cap307 _3864_/B VGND VGND VPWR VPWR _3907_/C sky130_fd_sc_hd__clkbuf_2
Xmax_cap318 _4982_/A VGND VGND VPWR VPWR _5108_/A sky130_fd_sc_hd__buf_2
XFILLER_6_197 VGND VGND VPWR VPWR sky130_fd_sc_hd__decap_3
Xload_slew579 _4018_/A VGND VGND VPWR VPWR _4469_/A sky130_fd_sc_hd__buf_4
XTAP_TAPCELL_ROW_76_862 VGND VPWR sky130_fd_sc_hd__tapvpwrvgnd_1
XFILLER_77_193 VGND VGND VPWR VPWR sky130_fd_sc_hd__decap_3
XFILLER_18_260 VGND VGND VPWR VPWR sky130_fd_sc_hd__decap_3
X_5941_ _5935_/B _5932_/Y _5935_/C VGND VGND VPWR VPWR _5941_/X sky130_fd_sc_hd__a21o_2
XFILLER_65_399 VGND VGND VPWR VPWR sky130_fd_sc_hd__decap_3
XFILLER_65_377 VGND VGND VPWR VPWR sky130_fd_sc_hd__decap_3
XFILLER_33_252 VGND VGND VPWR VPWR sky130_fd_sc_hd__decap_3
X_5872_ _6042_/A _6040_/A VGND VGND VPWR VPWR _5872_/Y sky130_fd_sc_hd__nand2_2
XFILLER_33_296 VGND VGND VPWR VPWR sky130_fd_sc_hd__fill_2
X_4823_ _4823_/A _4910_/B VGND VGND VPWR VPWR _4954_/B sky130_fd_sc_hd__nand2_2
X_4754_ _4783_/B _4733_/B _4753_/Y VGND VGND VPWR VPWR _4755_/B sky130_fd_sc_hd__a21oi_2
X_3705_ _6428_/A0 _6429_/B _6428_/A2 _5962_/A _6437_/S _3780_/A VGND VGND VPWR VPWR
+ _3705_/X sky130_fd_sc_hd__mux4_2
X_4685_ _4800_/B _4685_/B VGND VGND VPWR VPWR _4685_/X sky130_fd_sc_hd__and2_2
X_6424_ _6424_/A _6472_/S VGND VGND VPWR VPWR _6438_/A sky130_fd_sc_hd__xnor2_2
X_3636_ _6014_/B VGND VGND VPWR VPWR _6120_/B sky130_fd_sc_hd__inv_2
X_6355_ _6396_/A _6355_/B _6355_/C _6355_/D VGND VGND VPWR VPWR _6355_/X sky130_fd_sc_hd__and4b_2
X_3567_ _3467_/B _3666_/C _6106_/B _3566_/X VGND VGND VPWR VPWR _3568_/B sky130_fd_sc_hd__o31a_2
X_6286_ _6319_/A _6358_/B VGND VGND VPWR VPWR _6287_/B sky130_fd_sc_hd__nor2_2
X_5306_ _5328_/S _6359_/A VGND VGND VPWR VPWR _5309_/A sky130_fd_sc_hd__nor2_2
XFILLER_0_329 VGND VGND VPWR VPWR sky130_fd_sc_hd__decap_3
X_5237_ _5338_/A3 _5225_/S _5281_/A3 _5191_/A wire423/X wire374/X VGND VGND VPWR VPWR
+ _5237_/X sky130_fd_sc_hd__mux4_2
X_3498_ _3668_/A _3498_/B VGND VGND VPWR VPWR _3498_/Y sky130_fd_sc_hd__xnor2_2
X_5168_ _5168_/A _5168_/B VGND VGND VPWR VPWR _5168_/Y sky130_fd_sc_hd__nand2_2
XFILLER_56_333 VGND VGND VPWR VPWR sky130_fd_sc_hd__decap_3
X_5099_ _5099_/A _5099_/B VGND VGND VPWR VPWR _5099_/Y sky130_fd_sc_hd__nand2_2
X_4119_ _4181_/A _6170_/A VGND VGND VPWR VPWR _6167_/C sky130_fd_sc_hd__xnor2_2
XTAP_TAPCELL_ROW_39_531 VGND VPWR sky130_fd_sc_hd__tapvpwrvgnd_1
XFILLER_56_388 VGND VGND VPWR VPWR sky130_fd_sc_hd__decap_3
XFILLER_71_358 VGND VGND VPWR VPWR sky130_fd_sc_hd__decap_3
XFILLER_12_458 VGND VGND VPWR VPWR sky130_fd_sc_hd__fill_2
XFILLER_33_55 VGND VGND VPWR VPWR sky130_fd_sc_hd__fill_1
XPHY_EDGE_ROW_49_Left_132 VGND VGND VPWR VPWR sky130_fd_sc_hd__decap_3
XPHY_EDGE_ROW_58_Left_141 VGND VGND VPWR VPWR sky130_fd_sc_hd__decap_3
XFILLER_47_333 VGND VGND VPWR VPWR sky130_fd_sc_hd__decap_3
XFILLER_47_355 VGND VGND VPWR VPWR sky130_fd_sc_hd__fill_2
XFILLER_59_193 VGND VGND VPWR VPWR sky130_fd_sc_hd__decap_3
XFILLER_47_399 VGND VGND VPWR VPWR sky130_fd_sc_hd__fill_2
XTAP_TAPCELL_ROW_73_832 VGND VPWR sky130_fd_sc_hd__tapvpwrvgnd_1
XFILLER_74_73 VGND VGND VPWR VPWR sky130_fd_sc_hd__fill_2
XFILLER_74_62 VGND VGND VPWR VPWR sky130_fd_sc_hd__fill_2
XFILLER_62_336 VGND VGND VPWR VPWR sky130_fd_sc_hd__decap_3
XFILLER_30_211 VGND VGND VPWR VPWR sky130_fd_sc_hd__decap_3
XPHY_EDGE_ROW_67_Left_150 VGND VGND VPWR VPWR sky130_fd_sc_hd__decap_3
XFILLER_30_244 VGND VGND VPWR VPWR sky130_fd_sc_hd__decap_3
XFILLER_30_288 VGND VGND VPWR VPWR sky130_fd_sc_hd__fill_2
X_4470_ _6224_/A VGND VGND VPWR VPWR _4484_/A sky130_fd_sc_hd__inv_2
X_3421_ _3421_/A VGND VGND VPWR VPWR _3480_/A sky130_fd_sc_hd__clkbuf_1
X_6140_ _6467_/A3 _6133_/Y _6136_/X _6139_/X VGND VGND VPWR VPWR _6140_/X sky130_fd_sc_hd__o2bb2a_2
X_3352_ _3420_/A _3515_/B VGND VGND VPWR VPWR _4156_/A sky130_fd_sc_hd__nor2b_2
X_6071_ _6244_/A _6071_/B _6244_/B VGND VGND VPWR VPWR _6258_/A sky130_fd_sc_hd__and3_2
Xload_slew354 _6013_/C VGND VGND VPWR VPWR _6100_/B sky130_fd_sc_hd__buf_2
X_3283_ _3812_/A _3908_/A _3791_/S VGND VGND VPWR VPWR _3283_/X sky130_fd_sc_hd__mux2_2
Xload_slew376 _3584_/S0 VGND VGND VPWR VPWR _6447_/S0 sky130_fd_sc_hd__buf_4
X_5022_ _5019_/Y _5021_/X _4926_/A VGND VGND VPWR VPWR _5023_/D sky130_fd_sc_hd__a21oi_2
XFILLER_57_119 VGND VGND VPWR VPWR sky130_fd_sc_hd__decap_3
XFILLER_38_355 VGND VGND VPWR VPWR sky130_fd_sc_hd__decap_3
XFILLER_38_388 VGND VGND VPWR VPWR sky130_fd_sc_hd__decap_3
XFILLER_53_314 VGND VGND VPWR VPWR sky130_fd_sc_hd__decap_3
XTAP_TAPCELL_ROW_36_501 VGND VPWR sky130_fd_sc_hd__tapvpwrvgnd_1
X_5924_ _6420_/A _5924_/B _5924_/C _5942_/S VGND VGND VPWR VPWR _5924_/X sky130_fd_sc_hd__or4_2
XFILLER_21_200 VGND VGND VPWR VPWR sky130_fd_sc_hd__decap_3
X_5855_ _5923_/A _5946_/A3 _5874_/A _6431_/A0 _5963_/S0 _5963_/S1 VGND VGND VPWR VPWR
+ _5855_/X sky130_fd_sc_hd__mux4_2
X_4806_ _5175_/S VGND VGND VPWR VPWR _5548_/S sky130_fd_sc_hd__clkbuf_2
XFILLER_61_391 VGND VGND VPWR VPWR sky130_fd_sc_hd__fill_1
X_5786_ _5816_/A _5816_/B _6404_/S VGND VGND VPWR VPWR _5787_/B sky130_fd_sc_hd__a21oi_2
XFILLER_21_299 VGND VGND VPWR VPWR sky130_fd_sc_hd__fill_2
X_4737_ _4715_/S _4621_/B _4702_/Y _4703_/X input93/X VGND VGND VPWR VPWR _4737_/X
+ sky130_fd_sc_hd__a32o_2
X_4668_ _4743_/A _5534_/B _4743_/C _4967_/A VGND VGND VPWR VPWR _4927_/B sky130_fd_sc_hd__nor4_2
X_6407_ _6407_/A _6407_/B VGND VGND VPWR VPWR _6479_/A sky130_fd_sc_hd__nor2_2
X_3619_ _3734_/A _3619_/B VGND VGND VPWR VPWR _3619_/Y sky130_fd_sc_hd__xnor2_2
X_4599_ _4599_/A VGND VGND VPWR VPWR _6232_/B sky130_fd_sc_hd__inv_2
X_6338_ _6339_/A _6339_/B VGND VGND VPWR VPWR _6338_/Y sky130_fd_sc_hd__nand2_2
XTAP_TAPCELL_ROW_8_248 VGND VPWR sky130_fd_sc_hd__tapvpwrvgnd_1
X_6269_ _6265_/A _6267_/Y _6268_/Y VGND VGND VPWR VPWR _6269_/X sky130_fd_sc_hd__a21o_2
XFILLER_29_322 VGND VGND VPWR VPWR sky130_fd_sc_hd__decap_3
XFILLER_29_355 VGND VGND VPWR VPWR sky130_fd_sc_hd__decap_3
XFILLER_29_388 VGND VGND VPWR VPWR sky130_fd_sc_hd__decap_3
XFILLER_56_141 VGND VGND VPWR VPWR sky130_fd_sc_hd__decap_3
XFILLER_29_399 VGND VGND VPWR VPWR sky130_fd_sc_hd__fill_1
XFILLER_44_336 VGND VGND VPWR VPWR sky130_fd_sc_hd__decap_3
XFILLER_44_65 VGND VGND VPWR VPWR sky130_fd_sc_hd__decap_3
XTAP_TAPCELL_ROW_70_813 VGND VPWR sky130_fd_sc_hd__tapvpwrvgnd_1
XFILLER_71_188 VGND VGND VPWR VPWR sky130_fd_sc_hd__decap_3
XTAP_TAPCELL_ROW_42_559 VGND VPWR sky130_fd_sc_hd__tapvpwrvgnd_1
XFILLER_12_277 VGND VGND VPWR VPWR sky130_fd_sc_hd__decap_3
XFILLER_8_204 VGND VGND VPWR VPWR sky130_fd_sc_hd__decap_3
XFILLER_4_421 VGND VGND VPWR VPWR sky130_fd_sc_hd__fill_1
XFILLER_79_211 VGND VGND VPWR VPWR sky130_fd_sc_hd__decap_3
XPHY_EDGE_ROW_13_Right_13 VGND VGND VPWR VPWR sky130_fd_sc_hd__decap_3
XFILLER_35_325 VGND VGND VPWR VPWR sky130_fd_sc_hd__fill_2
X_3970_ _3970_/A VGND VGND VPWR VPWR _4460_/S sky130_fd_sc_hd__clkbuf_2
XFILLER_50_339 VGND VGND VPWR VPWR sky130_fd_sc_hd__decap_3
XFILLER_43_391 VGND VGND VPWR VPWR sky130_fd_sc_hd__fill_1
X_5640_ _5712_/D _5640_/B VGND VGND VPWR VPWR _5640_/Y sky130_fd_sc_hd__xnor2_2
X_5571_ _5712_/B _5604_/B VGND VGND VPWR VPWR _5574_/B sky130_fd_sc_hd__xnor2_2
XPHY_EDGE_ROW_22_Right_22 VGND VGND VPWR VPWR sky130_fd_sc_hd__decap_3
X_4522_ _4500_/Y _4501_/X _4521_/X VGND VGND VPWR VPWR _4522_/Y sky130_fd_sc_hd__o21ai_2
XTAP_TAPCELL_ROW_13_294 VGND VPWR sky130_fd_sc_hd__tapvpwrvgnd_1
X_4453_ _4073_/X _4447_/C _4447_/D _4452_/Y VGND VGND VPWR VPWR _4454_/B sky130_fd_sc_hd__a31oi_2
XFILLER_7_292 VGND VGND VPWR VPWR sky130_fd_sc_hd__decap_3
X_3404_ _3371_/A _3410_/B _3411_/A1 VGND VGND VPWR VPWR _3464_/B sky130_fd_sc_hd__a21o_2
X_4384_ _4937_/A _4384_/B _4384_/C VGND VGND VPWR VPWR _4384_/Y sky130_fd_sc_hd__nand3_2
X_6123_ _4937_/A _6119_/X _6122_/X VGND VGND VPWR VPWR _6123_/Y sky130_fd_sc_hd__o21ai_2
X_3335_ _3535_/A VGND VGND VPWR VPWR _3335_/X sky130_fd_sc_hd__clkbuf_1
X_6054_ _6077_/A _6077_/B _6055_/B VGND VGND VPWR VPWR _6270_/C sky130_fd_sc_hd__and3_2
X_3266_ _6429_/A _6098_/A _3451_/S VGND VGND VPWR VPWR _3267_/A sky130_fd_sc_hd__or3_2
XPHY_EDGE_ROW_31_Right_31 VGND VGND VPWR VPWR sky130_fd_sc_hd__decap_3
XFILLER_38_130 VGND VGND VPWR VPWR sky130_fd_sc_hd__decap_3
X_5005_ _4997_/A _5003_/X _5004_/X VGND VGND VPWR VPWR _5006_/B sky130_fd_sc_hd__a21oi_2
XFILLER_53_122 VGND VGND VPWR VPWR sky130_fd_sc_hd__fill_2
XFILLER_81_420 VGND VGND VPWR VPWR sky130_fd_sc_hd__fill_2
XFILLER_41_317 VGND VGND VPWR VPWR sky130_fd_sc_hd__decap_3
XFILLER_53_188 VGND VGND VPWR VPWR sky130_fd_sc_hd__decap_3
X_5907_ _5932_/B _5970_/B wire261/X _6420_/A _5906_/Y VGND VGND VPWR VPWR _5907_/X
+ sky130_fd_sc_hd__a221o_2
X_5838_ _6497_/A _6493_/A _5837_/X VGND VGND VPWR VPWR _5838_/X sky130_fd_sc_hd__o21ba_2
XPHY_EDGE_ROW_40_Right_40 VGND VGND VPWR VPWR sky130_fd_sc_hd__decap_3
X_5769_ _4509_/X _5767_/X _5859_/A VGND VGND VPWR VPWR _5769_/X sky130_fd_sc_hd__o21a_2
XFILLER_39_65 VGND VGND VPWR VPWR sky130_fd_sc_hd__decap_3
XFILLER_49_417 VGND VGND VPWR VPWR sky130_fd_sc_hd__decap_3
XFILLER_76_214 VGND VGND VPWR VPWR sky130_fd_sc_hd__decap_3
XFILLER_29_130 VGND VGND VPWR VPWR sky130_fd_sc_hd__decap_3
XFILLER_39_87 VGND VGND VPWR VPWR sky130_fd_sc_hd__decap_3
XFILLER_17_325 VGND VGND VPWR VPWR sky130_fd_sc_hd__decap_3
XFILLER_55_53 VGND VGND VPWR VPWR sky130_fd_sc_hd__decap_3
XFILLER_17_358 VGND VGND VPWR VPWR sky130_fd_sc_hd__decap_3
XTAP_TAPCELL_ROW_55_673 VGND VPWR sky130_fd_sc_hd__tapvpwrvgnd_1
XFILLER_9_513 VGND VGND VPWR VPWR sky130_fd_sc_hd__decap_3
XFILLER_40_383 VGND VGND VPWR VPWR sky130_fd_sc_hd__decap_3
XFILLER_82_239 VGND VGND VPWR VPWR sky130_fd_sc_hd__decap_3
XFILLER_82_228 VGND VGND VPWR VPWR sky130_fd_sc_hd__decap_3
XTAP_TAPCELL_ROW_81_908 VGND VPWR sky130_fd_sc_hd__tapvpwrvgnd_1
XTAP_TAPCELL_ROW_18_342 VGND VPWR sky130_fd_sc_hd__tapvpwrvgnd_1
XFILLER_35_166 VGND VGND VPWR VPWR sky130_fd_sc_hd__fill_2
XFILLER_50_136 VGND VGND VPWR VPWR sky130_fd_sc_hd__decap_3
X_3953_ _3993_/A _3912_/X _3929_/Y _4094_/A _3952_/X VGND VGND VPWR VPWR _5992_/B
+ sky130_fd_sc_hd__a221o_2
X_3884_ _4233_/A _3881_/X _3883_/X _3976_/A VGND VGND VPWR VPWR _3884_/X sky130_fd_sc_hd__o211a_2
X_5623_ _5574_/A _5604_/B _5604_/A VGND VGND VPWR VPWR _5623_/X sky130_fd_sc_hd__o21a_2
X_5554_ _6485_/A _6333_/A _5553_/X VGND VGND VPWR VPWR _5554_/X sky130_fd_sc_hd__o21a_2
X_5485_ _5485_/A _5485_/B VGND VGND VPWR VPWR _5485_/Y sky130_fd_sc_hd__nand2_2
X_4505_ _4277_/X _4328_/X _4459_/X _4504_/X _4674_/S _4191_/X VGND VGND VPWR VPWR
+ _4505_/X sky130_fd_sc_hd__mux4_2
X_4436_ _6208_/A _6059_/B VGND VGND VPWR VPWR _4436_/X sky130_fd_sc_hd__and2b_2
XFILLER_6_80 VGND VGND VPWR VPWR sky130_fd_sc_hd__decap_3
Xfanout503 input49/X VGND VGND VPWR VPWR _6439_/A3 sky130_fd_sc_hd__clkdlybuf4s25_1
Xfanout514 input44/X VGND VGND VPWR VPWR _6449_/A0 sky130_fd_sc_hd__clkdlybuf4s25_1
X_4367_ _4681_/A1 _4681_/A0 _4367_/S VGND VGND VPWR VPWR _4367_/X sky130_fd_sc_hd__mux2_2
X_6106_ _6106_/A _6106_/B _6113_/C VGND VGND VPWR VPWR _6106_/X sky130_fd_sc_hd__or3b_2
Xfanout525 _6486_/B VGND VGND VPWR VPWR _3420_/A sky130_fd_sc_hd__clkdlybuf4s25_1
Xfanout536 input36/X VGND VGND VPWR VPWR _6450_/A3 sky130_fd_sc_hd__clkdlybuf4s25_1
Xfanout547 input31/X VGND VGND VPWR VPWR _6447_/A0 sky130_fd_sc_hd__clkdlybuf4s25_1
X_3318_ _3495_/A VGND VGND VPWR VPWR _3633_/A sky130_fd_sc_hd__clkbuf_2
Xfanout558 input27/X VGND VGND VPWR VPWR _6460_/A3 sky130_fd_sc_hd__clkdlybuf4s25_1
Xfanout569 input22/X VGND VGND VPWR VPWR _6224_/A sky130_fd_sc_hd__clkdlybuf4s25_1
X_4298_ _6199_/B VGND VGND VPWR VPWR _6200_/B sky130_fd_sc_hd__inv_2
XFILLER_58_225 VGND VGND VPWR VPWR sky130_fd_sc_hd__fill_1
X_6037_ _5874_/B _6407_/B _5881_/B VGND VGND VPWR VPWR _6037_/X sky130_fd_sc_hd__a21o_2
X_3249_ _3264_/A _3349_/A _3262_/A VGND VGND VPWR VPWR _3249_/X sky130_fd_sc_hd__o21a_2
XFILLER_26_111 VGND VGND VPWR VPWR sky130_fd_sc_hd__fill_1
XTAP_TAPCELL_ROW_69_798 VGND VPWR sky130_fd_sc_hd__tapvpwrvgnd_1
XFILLER_14_328 VGND VGND VPWR VPWR sky130_fd_sc_hd__decap_3
XFILLER_25_45 VGND VGND VPWR VPWR sky130_fd_sc_hd__fill_1
XTAP_TAPCELL_ROW_52_643 VGND VPWR sky130_fd_sc_hd__tapvpwrvgnd_1
XFILLER_22_361 VGND VGND VPWR VPWR sky130_fd_sc_hd__decap_3
XFILLER_41_169 VGND VGND VPWR VPWR sky130_fd_sc_hd__decap_3
XFILLER_22_383 VGND VGND VPWR VPWR sky130_fd_sc_hd__decap_3
XFILLER_41_55 VGND VGND VPWR VPWR sky130_fd_sc_hd__fill_1
XFILLER_2_27 VGND VGND VPWR VPWR sky130_fd_sc_hd__fill_1
XFILLER_49_258 VGND VGND VPWR VPWR sky130_fd_sc_hd__decap_3
XFILLER_64_206 VGND VGND VPWR VPWR sky130_fd_sc_hd__decap_3
XFILLER_17_111 VGND VGND VPWR VPWR sky130_fd_sc_hd__fill_1
XTAP_TAPCELL_ROW_15_312 VGND VPWR sky130_fd_sc_hd__tapvpwrvgnd_1
XFILLER_72_283 VGND VGND VPWR VPWR sky130_fd_sc_hd__fill_1
Xoutput139 _5992_/A VGND VGND VPWR VPWR result[11] sky130_fd_sc_hd__clkdlybuf4s25_1
X_5270_ _6391_/D _5270_/A2 _5269_/X VGND VGND VPWR VPWR _5270_/X sky130_fd_sc_hd__a21o_2
XFILLER_49_3 VGND VGND VPWR VPWR sky130_fd_sc_hd__fill_1
X_4221_ _4189_/X _4220_/X _4221_/S VGND VGND VPWR VPWR _4221_/X sky130_fd_sc_hd__mux2_2
X_4152_ _5176_/S _4151_/Y _4057_/Y VGND VGND VPWR VPWR _4152_/X sky130_fd_sc_hd__a21bo_2
X_4083_ _4044_/A _4044_/B _4035_/X _4037_/B VGND VGND VPWR VPWR _4084_/C sky130_fd_sc_hd__o31a_2
XFILLER_48_280 VGND VGND VPWR VPWR sky130_fd_sc_hd__decap_3
XFILLER_55_228 VGND VGND VPWR VPWR sky130_fd_sc_hd__decap_3
XFILLER_70_209 VGND VGND VPWR VPWR sky130_fd_sc_hd__decap_3
X_4985_ _6265_/A VGND VGND VPWR VPWR _4997_/A sky130_fd_sc_hd__inv_2
XFILLER_23_169 VGND VGND VPWR VPWR sky130_fd_sc_hd__decap_3
X_3936_ _3965_/A VGND VGND VPWR VPWR _3937_/S sky130_fd_sc_hd__inv_2
X_3867_ _6464_/A1 _6129_/A _3820_/A _3820_/B _3864_/B VGND VGND VPWR VPWR _3870_/B
+ sky130_fd_sc_hd__o2111a_2
X_5606_ _5606_/A _5606_/B VGND VGND VPWR VPWR _5607_/B sky130_fd_sc_hd__nand2_2
X_3798_ _3798_/A _3798_/B VGND VGND VPWR VPWR _3798_/X sky130_fd_sc_hd__or2_2
X_5537_ _5469_/A _5469_/B _5498_/A _5498_/B VGND VGND VPWR VPWR _5572_/C sky130_fd_sc_hd__o22a_2
X_5468_ _6322_/B _5501_/B _5466_/X _5421_/Y _5467_/X VGND VGND VPWR VPWR _5469_/B
+ sky130_fd_sc_hd__o221ai_2
X_5399_ _4883_/X _5374_/Y _5392_/X _5398_/X VGND VGND VPWR VPWR _5399_/X sky130_fd_sc_hd__a211o_2
X_4419_ _3748_/A _4418_/X _6427_/A VGND VGND VPWR VPWR _4419_/Y sky130_fd_sc_hd__o21ai_2
Xfanout355 input92/X VGND VGND VPWR VPWR _3798_/A sky130_fd_sc_hd__clkdlybuf4s25_1
XPHY_EDGE_ROW_21_Left_104 VGND VGND VPWR VPWR sky130_fd_sc_hd__decap_3
Xfanout377 _4675_/S1 VGND VGND VPWR VPWR _6450_/S0 sky130_fd_sc_hd__clkdlybuf4s25_1
Xfanout388 _3695_/S0 VGND VGND VPWR VPWR _6461_/S0 sky130_fd_sc_hd__clkdlybuf4s25_1
XFILLER_46_217 VGND VGND VPWR VPWR sky130_fd_sc_hd__decap_3
XTAP_TAPCELL_ROW_29_437 VGND VPWR sky130_fd_sc_hd__tapvpwrvgnd_1
XFILLER_14_103 VGND VGND VPWR VPWR sky130_fd_sc_hd__decap_3
XFILLER_36_77 VGND VGND VPWR VPWR sky130_fd_sc_hd__decap_3
XFILLER_36_88 VGND VGND VPWR VPWR sky130_fd_sc_hd__fill_1
XFILLER_14_147 VGND VGND VPWR VPWR sky130_fd_sc_hd__decap_3
XPHY_EDGE_ROW_30_Left_113 VGND VGND VPWR VPWR sky130_fd_sc_hd__decap_3
Xinput19 operand_a[21] VGND VGND VPWR VPWR input19/X sky130_fd_sc_hd__clkdlybuf4s25_1
XFILLER_37_206 VGND VGND VPWR VPWR sky130_fd_sc_hd__decap_3
XFILLER_37_217 VGND VGND VPWR VPWR sky130_fd_sc_hd__decap_3
XFILLER_37_239 VGND VGND VPWR VPWR sky130_fd_sc_hd__decap_3
XFILLER_18_464 VGND VGND VPWR VPWR sky130_fd_sc_hd__fill_1
XFILLER_18_475 VGND VGND VPWR VPWR sky130_fd_sc_hd__fill_1
XFILLER_52_209 VGND VGND VPWR VPWR sky130_fd_sc_hd__decap_3
XTAP_TAPCELL_ROW_63_749 VGND VPWR sky130_fd_sc_hd__tapvpwrvgnd_1
XFILLER_60_264 VGND VGND VPWR VPWR sky130_fd_sc_hd__fill_1
XFILLER_60_242 VGND VGND VPWR VPWR sky130_fd_sc_hd__decap_3
X_4770_ _4698_/A _4733_/B _4769_/Y _4753_/B VGND VGND VPWR VPWR _4772_/B sky130_fd_sc_hd__o31ai_2
XFILLER_60_275 VGND VGND VPWR VPWR sky130_fd_sc_hd__decap_3
X_3721_ _3563_/X _3676_/X _3693_/Y _3723_/A _3720_/X VGND VGND VPWR VPWR _3722_/A
+ sky130_fd_sc_hd__a221oi_2
X_6440_ _6440_/A0 _6440_/A1 _6440_/A2 _6440_/A3 _6437_/S _6438_/X VGND VGND VPWR VPWR
+ _6440_/X sky130_fd_sc_hd__mux4_2
X_3652_ _3327_/X _3651_/X _3652_/S VGND VGND VPWR VPWR _3652_/X sky130_fd_sc_hd__mux2_2
X_6371_ _6365_/B _6287_/B _6363_/A VGND VGND VPWR VPWR _6371_/Y sky130_fd_sc_hd__a21oi_2
X_3583_ _6449_/A3 _6449_/A2 _6439_/A3 _6439_/A2 _3631_/S0 _3631_/S1 VGND VGND VPWR
+ VPWR _3583_/X sky130_fd_sc_hd__mux4_2
X_5322_ _5322_/A _5322_/B VGND VGND VPWR VPWR _5322_/Y sky130_fd_sc_hd__xnor2_2
X_5253_ _6391_/B _5251_/Y _5167_/X _5204_/X _5277_/B VGND VGND VPWR VPWR _5258_/B
+ sky130_fd_sc_hd__o2111ai_2
X_5184_ _5182_/X _5183_/Y _5191_/A VGND VGND VPWR VPWR _5184_/X sky130_fd_sc_hd__mux2_2
X_4204_ _4370_/A _4258_/A _4198_/Y _4201_/X _4203_/Y VGND VGND VPWR VPWR _4204_/X
+ sky130_fd_sc_hd__o221a_2
XFILLER_3_92 VGND VGND VPWR VPWR sky130_fd_sc_hd__decap_3
X_4135_ _4135_/A _4135_/B VGND VGND VPWR VPWR _4136_/B sky130_fd_sc_hd__nor2_2
XFILLER_28_206 VGND VGND VPWR VPWR sky130_fd_sc_hd__decap_3
XFILLER_28_228 VGND VGND VPWR VPWR sky130_fd_sc_hd__decap_3
XFILLER_56_515 VGND VGND VPWR VPWR sky130_fd_sc_hd__fill_1
XTAP_TAPCELL_ROW_79_893 VGND VPWR sky130_fd_sc_hd__tapvpwrvgnd_1
X_4066_ _6167_/A _6164_/A VGND VGND VPWR VPWR _4170_/A sky130_fd_sc_hd__xnor2_2
XFILLER_36_272 VGND VGND VPWR VPWR sky130_fd_sc_hd__decap_3
XFILLER_51_220 VGND VGND VPWR VPWR sky130_fd_sc_hd__decap_3
XFILLER_51_231 VGND VGND VPWR VPWR sky130_fd_sc_hd__decap_3
XFILLER_11_128 VGND VGND VPWR VPWR sky130_fd_sc_hd__decap_3
X_4968_ _4968_/A _4968_/B _4968_/C _4968_/D VGND VGND VPWR VPWR _4969_/A sky130_fd_sc_hd__and4_2
XTAP_TAPCELL_ROW_34_484 VGND VPWR sky130_fd_sc_hd__tapvpwrvgnd_1
X_4899_ _4946_/B _5429_/A VGND VGND VPWR VPWR _4954_/D sky130_fd_sc_hd__or2_2
X_3919_ _6014_/B _3919_/B _3919_/C VGND VGND VPWR VPWR _3919_/X sky130_fd_sc_hd__or3_2
XFILLER_74_345 VGND VGND VPWR VPWR sky130_fd_sc_hd__decap_3
XFILLER_42_253 VGND VGND VPWR VPWR sky130_fd_sc_hd__decap_3
XTAP_TAPCELL_ROW_60_719 VGND VPWR sky130_fd_sc_hd__tapvpwrvgnd_1
XPHY_EDGE_ROW_69_Right_69 VGND VGND VPWR VPWR sky130_fd_sc_hd__decap_3
XFILLER_42_297 VGND VGND VPWR VPWR sky130_fd_sc_hd__decap_3
XFILLER_8_26 VGND VGND VPWR VPWR sky130_fd_sc_hd__fill_2
XFILLER_6_110 VGND VGND VPWR VPWR sky130_fd_sc_hd__decap_3
Xwire575 _4561_/A VGND VGND VPWR VPWR _5178_/A sky130_fd_sc_hd__clkbuf_4
Xmax_cap308 _6102_/B VGND VGND VPWR VPWR _3668_/A sky130_fd_sc_hd__buf_2
XPHY_EDGE_ROW_78_Right_78 VGND VGND VPWR VPWR sky130_fd_sc_hd__decap_3
XFILLER_77_150 VGND VGND VPWR VPWR sky130_fd_sc_hd__decap_3
XFILLER_65_301 VGND VGND VPWR VPWR sky130_fd_sc_hd__fill_1
X_5940_ _6410_/A _5970_/B _5937_/X _5938_/X _5939_/Y VGND VGND VPWR VPWR _5940_/X
+ sky130_fd_sc_hd__a221o_2
XTAP_TAPCELL_ROW_76_863 VGND VPWR sky130_fd_sc_hd__tapvpwrvgnd_1
XFILLER_65_389 VGND VGND VPWR VPWR sky130_fd_sc_hd__decap_3
XFILLER_33_220 VGND VGND VPWR VPWR sky130_fd_sc_hd__decap_3
XFILLER_33_231 VGND VGND VPWR VPWR sky130_fd_sc_hd__decap_3
X_5871_ _5685_/A _5854_/Y _5865_/X _5870_/Y VGND VGND VPWR VPWR _6004_/C sky130_fd_sc_hd__a211o_2
XFILLER_33_264 VGND VGND VPWR VPWR sky130_fd_sc_hd__decap_3
X_4822_ _4923_/B _4922_/B VGND VGND VPWR VPWR _4910_/B sky130_fd_sc_hd__nand2_2
X_4753_ _4783_/B _4753_/B VGND VGND VPWR VPWR _4753_/Y sky130_fd_sc_hd__nor2_2
X_3704_ _3704_/A _6442_/B VGND VGND VPWR VPWR _3704_/Y sky130_fd_sc_hd__nand2_2
XTAP_TAPCELL_ROW_31_454 VGND VPWR sky130_fd_sc_hd__tapvpwrvgnd_1
X_6423_ _6476_/A _6423_/B VGND VGND VPWR VPWR _6423_/X sky130_fd_sc_hd__or2_2
X_4684_ _5010_/S _3986_/X _4057_/Y VGND VGND VPWR VPWR _4685_/B sky130_fd_sc_hd__a21bo_2
X_3635_ _3703_/A _3630_/X _3634_/X _3580_/Y VGND VGND VPWR VPWR _3635_/Y sky130_fd_sc_hd__a22oi_2
X_6354_ _6354_/A _6354_/B _6354_/C _6354_/D VGND VGND VPWR VPWR _6355_/D sky130_fd_sc_hd__or4_2
X_3566_ _6108_/B _3668_/B _3565_/X VGND VGND VPWR VPWR _3566_/X sky130_fd_sc_hd__a21o_2
X_6285_ _6319_/A _6358_/B VGND VGND VPWR VPWR _6285_/Y sky130_fd_sc_hd__xnor2_2
X_5305_ _6358_/A VGND VGND VPWR VPWR _5328_/S sky130_fd_sc_hd__inv_2
X_3497_ _3467_/B _3666_/C _3668_/B VGND VGND VPWR VPWR _3498_/B sky130_fd_sc_hd__o21a_2
X_5236_ _5274_/D _5236_/B VGND VGND VPWR VPWR _5236_/Y sky130_fd_sc_hd__xnor2_2
XFILLER_29_515 VGND VGND VPWR VPWR sky130_fd_sc_hd__fill_1
XFILLER_56_312 VGND VGND VPWR VPWR sky130_fd_sc_hd__decap_3
X_5167_ _5421_/A _5421_/B _5167_/C VGND VGND VPWR VPWR _5167_/X sky130_fd_sc_hd__or3_2
X_5098_ _5098_/A1 _5099_/A _5097_/X VGND VGND VPWR VPWR _5098_/Y sky130_fd_sc_hd__o21ai_2
X_4118_ _4118_/A VGND VGND VPWR VPWR _4118_/X sky130_fd_sc_hd__clkbuf_1
XTAP_TAPCELL_ROW_39_532 VGND VPWR sky130_fd_sc_hd__tapvpwrvgnd_1
X_4049_ _4019_/A _4156_/A _4049_/S VGND VGND VPWR VPWR _4049_/X sky130_fd_sc_hd__mux2_2
XFILLER_17_57 VGND VGND VPWR VPWR sky130_fd_sc_hd__fill_2
XFILLER_71_337 VGND VGND VPWR VPWR sky130_fd_sc_hd__decap_3
XFILLER_24_253 VGND VGND VPWR VPWR sky130_fd_sc_hd__decap_3
XFILLER_33_89 VGND VGND VPWR VPWR sky130_fd_sc_hd__decap_3
XFILLER_3_113 VGND VGND VPWR VPWR sky130_fd_sc_hd__fill_1
XFILLER_59_172 VGND VGND VPWR VPWR sky130_fd_sc_hd__decap_3
XFILLER_62_315 VGND VGND VPWR VPWR sky130_fd_sc_hd__decap_3
XTAP_TAPCELL_ROW_73_833 VGND VPWR sky130_fd_sc_hd__tapvpwrvgnd_1
XFILLER_74_85 VGND VGND VPWR VPWR sky130_fd_sc_hd__fill_2
XFILLER_74_197 VGND VGND VPWR VPWR sky130_fd_sc_hd__decap_3
XFILLER_62_348 VGND VGND VPWR VPWR sky130_fd_sc_hd__decap_3
XFILLER_62_359 VGND VGND VPWR VPWR sky130_fd_sc_hd__decap_3
XFILLER_30_256 VGND VGND VPWR VPWR sky130_fd_sc_hd__decap_3
Xwire372 wire372/A VGND VGND VPWR VPWR wire372/X sky130_fd_sc_hd__clkbuf_4
XFILLER_7_474 VGND VGND VPWR VPWR sky130_fd_sc_hd__fill_2
X_3420_ _3420_/A _3940_/A _3694_/B VGND VGND VPWR VPWR _3421_/A sky130_fd_sc_hd__or3_2
X_3351_ _4106_/A _3361_/C _3348_/Y _3350_/X _3348_/A VGND VGND VPWR VPWR _3351_/X
+ sky130_fd_sc_hd__a32o_2
X_6070_ _4818_/A _6258_/B _4923_/B VGND VGND VPWR VPWR _6070_/X sky130_fd_sc_hd__o21a_2
Xload_slew344 _3527_/S VGND VGND VPWR VPWR _3948_/S1 sky130_fd_sc_hd__clkbuf_4
X_3282_ _6467_/A3 _4049_/S _4014_/S VGND VGND VPWR VPWR _3282_/X sky130_fd_sc_hd__mux2_2
XFILLER_38_301 VGND VGND VPWR VPWR sky130_fd_sc_hd__decap_3
XFILLER_38_312 VGND VGND VPWR VPWR sky130_fd_sc_hd__decap_3
X_5021_ input100/X _5180_/B _4797_/A _5030_/B VGND VGND VPWR VPWR _5021_/X sky130_fd_sc_hd__o2bb2a_2
Xload_slew399 _3376_/S0 VGND VGND VPWR VPWR _3654_/S0 sky130_fd_sc_hd__buf_4
XTAP_TAPCELL_ROW_36_502 VGND VPWR sky130_fd_sc_hd__tapvpwrvgnd_1
XFILLER_53_326 VGND VGND VPWR VPWR sky130_fd_sc_hd__decap_3
XFILLER_53_337 VGND VGND VPWR VPWR sky130_fd_sc_hd__decap_3
XFILLER_80_101 VGND VGND VPWR VPWR sky130_fd_sc_hd__fill_1
XFILLER_53_359 VGND VGND VPWR VPWR sky130_fd_sc_hd__decap_3
X_5923_ _5923_/A _5923_/B _5923_/C _5923_/D VGND VGND VPWR VPWR _5924_/C sky130_fd_sc_hd__and4_2
X_5854_ _6496_/C _5854_/B VGND VGND VPWR VPWR _5854_/Y sky130_fd_sc_hd__xnor2_2
XFILLER_61_370 VGND VGND VPWR VPWR sky130_fd_sc_hd__decap_3
X_4805_ _6106_/A VGND VGND VPWR VPWR _5175_/S sky130_fd_sc_hd__clkbuf_2
X_5785_ _6404_/S _5816_/A _5816_/B VGND VGND VPWR VPWR _5787_/A sky130_fd_sc_hd__and3_2
X_4736_ _4733_/Y _4735_/X _4736_/S VGND VGND VPWR VPWR _4736_/X sky130_fd_sc_hd__mux2_2
X_4667_ _4622_/A _4622_/B _4612_/C VGND VGND VPWR VPWR _4967_/A sky130_fd_sc_hd__o21bai_2
X_6406_ _5752_/A _6050_/X _6051_/Y _6399_/X _6405_/Y VGND VGND VPWR VPWR _6406_/X
+ sky130_fd_sc_hd__o311a_2
X_3618_ _3735_/A _3735_/B VGND VGND VPWR VPWR _3619_/B sky130_fd_sc_hd__nor2_2
X_6337_ _6337_/A _6337_/B VGND VGND VPWR VPWR _6339_/B sky130_fd_sc_hd__nand2_2
X_4598_ _4598_/A _4598_/B VGND VGND VPWR VPWR _4598_/Y sky130_fd_sc_hd__nor2_2
X_3549_ _3559_/C _3547_/C _3679_/D _3548_/Y VGND VGND VPWR VPWR _3551_/B sky130_fd_sc_hd__a211oi_2
XTAP_TAPCELL_ROW_8_249 VGND VPWR sky130_fd_sc_hd__tapvpwrvgnd_1
X_6268_ _6077_/C _6270_/C _6270_/A VGND VGND VPWR VPWR _6268_/Y sky130_fd_sc_hd__a21oi_2
X_6199_ _6199_/A _6199_/B _6199_/C _6208_/A VGND VGND VPWR VPWR _6199_/X sky130_fd_sc_hd__or4_2
X_5219_ input42/X _5281_/A3 _6446_/A0 _5096_/A wire423/X wire374/X VGND VGND VPWR
+ VPWR _5219_/X sky130_fd_sc_hd__mux4_2
XFILLER_29_334 VGND VGND VPWR VPWR sky130_fd_sc_hd__fill_2
XFILLER_29_367 VGND VGND VPWR VPWR sky130_fd_sc_hd__decap_3
XFILLER_56_153 VGND VGND VPWR VPWR sky130_fd_sc_hd__decap_3
XFILLER_44_315 VGND VGND VPWR VPWR sky130_fd_sc_hd__decap_3
XFILLER_56_197 VGND VGND VPWR VPWR sky130_fd_sc_hd__decap_3
XFILLER_44_88 VGND VGND VPWR VPWR sky130_fd_sc_hd__decap_3
XFILLER_60_54 VGND VGND VPWR VPWR sky130_fd_sc_hd__fill_2
XFILLER_60_43 VGND VGND VPWR VPWR sky130_fd_sc_hd__fill_1
XFILLER_5_38 VGND VGND VPWR VPWR sky130_fd_sc_hd__fill_2
XFILLER_79_256 VGND VGND VPWR VPWR sky130_fd_sc_hd__decap_3
XFILLER_47_164 VGND VGND VPWR VPWR sky130_fd_sc_hd__decap_3
XFILLER_47_175 VGND VGND VPWR VPWR sky130_fd_sc_hd__decap_3
XFILLER_62_123 VGND VGND VPWR VPWR sky130_fd_sc_hd__decap_3
XFILLER_62_145 VGND VGND VPWR VPWR sky130_fd_sc_hd__decap_3
XFILLER_50_318 VGND VGND VPWR VPWR sky130_fd_sc_hd__decap_3
X_5570_ _5570_/A _5570_/B VGND VGND VPWR VPWR _5604_/B sky130_fd_sc_hd__and2_2
XFILLER_79_3 VGND VGND VPWR VPWR sky130_fd_sc_hd__fill_1
X_4521_ _4568_/A1 _4510_/Y _4512_/X _4513_/X _4520_/X VGND VGND VPWR VPWR _4521_/X
+ sky130_fd_sc_hd__o2111a_2
XTAP_TAPCELL_ROW_13_295 VGND VPWR sky130_fd_sc_hd__tapvpwrvgnd_1
X_4452_ _4283_/B _4449_/Y _4450_/Y _4451_/Y VGND VGND VPWR VPWR _4452_/Y sky130_fd_sc_hd__o22ai_2
X_3403_ _3515_/A _3515_/B _3417_/A VGND VGND VPWR VPWR _3563_/A sky130_fd_sc_hd__nor3_2
X_4383_ _6427_/A _4383_/B VGND VGND VPWR VPWR _4384_/C sky130_fd_sc_hd__nand2_2
X_6122_ _6122_/A1 _6120_/X _6121_/X VGND VGND VPWR VPWR _6122_/X sky130_fd_sc_hd__a21o_2
X_3334_ _3798_/B _3799_/B _3331_/X _3332_/X _6013_/C _3750_/A VGND VGND VPWR VPWR
+ _3334_/X sky130_fd_sc_hd__mux4_2
XFILLER_58_407 VGND VGND VPWR VPWR sky130_fd_sc_hd__decap_3
X_6053_ _6053_/A _6055_/B VGND VGND VPWR VPWR _6053_/Y sky130_fd_sc_hd__xnor2_2
X_3265_ _4849_/B _3292_/A _6486_/A VGND VGND VPWR VPWR _4098_/A sky130_fd_sc_hd__or3b_2
X_5004_ _5004_/A _5004_/B _5004_/C VGND VGND VPWR VPWR _5004_/X sky130_fd_sc_hd__and3_2
XFILLER_38_186 VGND VGND VPWR VPWR sky130_fd_sc_hd__fill_2
XFILLER_38_197 VGND VGND VPWR VPWR sky130_fd_sc_hd__decap_3
XFILLER_26_359 VGND VGND VPWR VPWR sky130_fd_sc_hd__decap_3
XFILLER_41_329 VGND VGND VPWR VPWR sky130_fd_sc_hd__decap_3
XFILLER_53_167 VGND VGND VPWR VPWR sky130_fd_sc_hd__fill_1
X_5906_ _5906_/A1 _5881_/B _5905_/X VGND VGND VPWR VPWR _5906_/Y sky130_fd_sc_hd__a21oi_2
XFILLER_14_25 VGND VGND VPWR VPWR sky130_fd_sc_hd__decap_3
X_5837_ _4595_/X _5740_/Y _5830_/X _5177_/A _5836_/X VGND VGND VPWR VPWR _5837_/X
+ sky130_fd_sc_hd__a221o_2
X_5768_ _4884_/B _4514_/X _5767_/X VGND VGND VPWR VPWR _5768_/X sky130_fd_sc_hd__o21a_2
X_4719_ _4800_/B _4712_/X _4718_/X VGND VGND VPWR VPWR _4719_/X sky130_fd_sc_hd__a21o_2
X_5699_ _6374_/C _5477_/A wire261/X _6354_/A _5698_/X VGND VGND VPWR VPWR _5699_/X
+ sky130_fd_sc_hd__a221o_2
XFILLER_76_259 VGND VGND VPWR VPWR sky130_fd_sc_hd__fill_1
XFILLER_76_226 VGND VGND VPWR VPWR sky130_fd_sc_hd__decap_3
XFILLER_29_153 VGND VGND VPWR VPWR sky130_fd_sc_hd__decap_3
XFILLER_17_337 VGND VGND VPWR VPWR sky130_fd_sc_hd__fill_1
XFILLER_29_175 VGND VGND VPWR VPWR sky130_fd_sc_hd__decap_3
XFILLER_29_197 VGND VGND VPWR VPWR sky130_fd_sc_hd__decap_3
XFILLER_44_101 VGND VGND VPWR VPWR sky130_fd_sc_hd__decap_3
XFILLER_44_123 VGND VGND VPWR VPWR sky130_fd_sc_hd__decap_3
XFILLER_44_156 VGND VGND VPWR VPWR sky130_fd_sc_hd__decap_3
XFILLER_32_318 VGND VGND VPWR VPWR sky130_fd_sc_hd__decap_3
XTAP_TAPCELL_ROW_55_674 VGND VPWR sky130_fd_sc_hd__tapvpwrvgnd_1
XFILLER_9_503 VGND VGND VPWR VPWR sky130_fd_sc_hd__fill_1
XFILLER_40_395 VGND VGND VPWR VPWR sky130_fd_sc_hd__decap_3
XTAP_TAPCELL_ROW_10_265 VGND VPWR sky130_fd_sc_hd__tapvpwrvgnd_1
XFILLER_67_237 VGND VGND VPWR VPWR sky130_fd_sc_hd__decap_3
XFILLER_82_207 VGND VGND VPWR VPWR sky130_fd_sc_hd__fill_1
XFILLER_67_259 VGND VGND VPWR VPWR sky130_fd_sc_hd__decap_3
XFILLER_63_421 VGND VGND VPWR VPWR sky130_fd_sc_hd__decap_3
XFILLER_63_410 VGND VGND VPWR VPWR sky130_fd_sc_hd__decap_3
XFILLER_35_145 VGND VGND VPWR VPWR sky130_fd_sc_hd__decap_3
XTAP_TAPCELL_ROW_81_909 VGND VPWR sky130_fd_sc_hd__tapvpwrvgnd_1
XTAP_TAPCELL_ROW_18_343 VGND VPWR sky130_fd_sc_hd__tapvpwrvgnd_1
XFILLER_35_189 VGND VGND VPWR VPWR sky130_fd_sc_hd__decap_3
XFILLER_50_115 VGND VGND VPWR VPWR sky130_fd_sc_hd__decap_3
X_3952_ _3370_/X _4360_/A _3941_/X _3947_/Y _3951_/X VGND VGND VPWR VPWR _3952_/X
+ sky130_fd_sc_hd__a2111o_2
XFILLER_31_340 VGND VGND VPWR VPWR sky130_fd_sc_hd__decap_3
X_3883_ _3883_/A _3883_/B VGND VGND VPWR VPWR _3883_/X sky130_fd_sc_hd__or2_2
XFILLER_31_373 VGND VGND VPWR VPWR sky130_fd_sc_hd__fill_1
X_5622_ _5396_/X _5603_/Y _5608_/Y _5621_/X VGND VGND VPWR VPWR _5629_/A sky130_fd_sc_hd__a211o_2
X_5553_ _4846_/A _5938_/A1 _5553_/S VGND VGND VPWR VPWR _5553_/X sky130_fd_sc_hd__mux2_2
X_4504_ _6457_/A3 _6461_/A2 _4504_/S VGND VGND VPWR VPWR _4504_/X sky130_fd_sc_hd__mux2_2
X_5484_ _5706_/A1 _5483_/X _5664_/B1 VGND VGND VPWR VPWR _5484_/Y sky130_fd_sc_hd__o21ai_2
X_4435_ _4356_/A _4301_/B _4408_/X _4348_/X _4367_/S VGND VGND VPWR VPWR _4435_/X
+ sky130_fd_sc_hd__o2111a_2
Xfanout504 input48/X VGND VGND VPWR VPWR _5460_/A sky130_fd_sc_hd__clkdlybuf4s25_1
Xfanout515 _5338_/A3 VGND VGND VPWR VPWR _6391_/D sky130_fd_sc_hd__clkdlybuf4s25_1
X_4366_ _6176_/A VGND VGND VPWR VPWR _4367_/S sky130_fd_sc_hd__inv_2
X_6105_ _6109_/A _6113_/C VGND VGND VPWR VPWR _6114_/B sky130_fd_sc_hd__and2_2
Xfanout526 input4/X VGND VGND VPWR VPWR _6486_/B sky130_fd_sc_hd__clkdlybuf4s25_1
Xfanout537 input35/X VGND VGND VPWR VPWR _6265_/A sky130_fd_sc_hd__clkdlybuf4s25_1
Xfanout548 _6460_/A2 VGND VGND VPWR VPWR _4751_/A sky130_fd_sc_hd__clkdlybuf4s25_1
X_3317_ _3800_/B _3314_/X _3315_/X _3316_/X _3881_/S1 _4025_/S0 VGND VGND VPWR VPWR
+ _3317_/X sky130_fd_sc_hd__mux4_2
XFILLER_58_215 VGND VGND VPWR VPWR sky130_fd_sc_hd__fill_1
Xfanout559 _4679_/A VGND VGND VPWR VPWR _6243_/A sky130_fd_sc_hd__clkdlybuf4s25_1
X_4297_ _4118_/X _4266_/Y _4296_/X VGND VGND VPWR VPWR _5996_/B sky130_fd_sc_hd__a21o_2
XFILLER_58_237 VGND VGND VPWR VPWR sky130_fd_sc_hd__decap_3
X_6036_ _6400_/A _6417_/B VGND VGND VPWR VPWR _6407_/B sky130_fd_sc_hd__nand2_2
X_3248_ _3515_/B _3361_/C VGND VGND VPWR VPWR _4199_/A sky130_fd_sc_hd__nand2b_2
XFILLER_58_259 VGND VGND VPWR VPWR sky130_fd_sc_hd__decap_3
XFILLER_54_421 VGND VGND VPWR VPWR sky130_fd_sc_hd__decap_3
XTAP_TAPCELL_ROW_69_799 VGND VPWR sky130_fd_sc_hd__tapvpwrvgnd_1
XFILLER_81_240 VGND VGND VPWR VPWR sky130_fd_sc_hd__fill_1
XFILLER_26_156 VGND VGND VPWR VPWR sky130_fd_sc_hd__decap_3
XFILLER_81_273 VGND VGND VPWR VPWR sky130_fd_sc_hd__decap_3
XFILLER_81_262 VGND VGND VPWR VPWR sky130_fd_sc_hd__decap_3
XFILLER_41_115 VGND VGND VPWR VPWR sky130_fd_sc_hd__decap_3
XTAP_TAPCELL_ROW_52_644 VGND VPWR sky130_fd_sc_hd__tapvpwrvgnd_1
XFILLER_22_395 VGND VGND VPWR VPWR sky130_fd_sc_hd__decap_3
XFILLER_1_222 VGND VGND VPWR VPWR sky130_fd_sc_hd__fill_2
XFILLER_49_204 VGND VGND VPWR VPWR sky130_fd_sc_hd__decap_3
XFILLER_49_237 VGND VGND VPWR VPWR sky130_fd_sc_hd__fill_2
XFILLER_64_218 VGND VGND VPWR VPWR sky130_fd_sc_hd__decap_3
XFILLER_57_281 VGND VGND VPWR VPWR sky130_fd_sc_hd__fill_1
XFILLER_45_476 VGND VGND VPWR VPWR sky130_fd_sc_hd__decap_3
XTAP_TAPCELL_ROW_15_313 VGND VPWR sky130_fd_sc_hd__tapvpwrvgnd_1
XFILLER_13_384 VGND VGND VPWR VPWR sky130_fd_sc_hd__decap_3
XFILLER_9_333 VGND VGND VPWR VPWR sky130_fd_sc_hd__decap_3
XFILLER_40_192 VGND VGND VPWR VPWR sky130_fd_sc_hd__decap_3
XTAP_TAPCELL_ROW_23_390 VGND VPWR sky130_fd_sc_hd__tapvpwrvgnd_1
X_4220_ _4241_/C input14/X _4504_/S VGND VGND VPWR VPWR _4220_/X sky130_fd_sc_hd__mux2_2
X_4151_ _4150_/A _3782_/B _4150_/Y VGND VGND VPWR VPWR _4151_/Y sky130_fd_sc_hd__a21oi_2
X_4082_ _3934_/X _3955_/X _4035_/X _3956_/A _4044_/A VGND VGND VPWR VPWR _4084_/B
+ sky130_fd_sc_hd__a2111o_2
XFILLER_36_454 VGND VGND VPWR VPWR sky130_fd_sc_hd__fill_1
XTAP_TAPCELL_ROW_66_769 VGND VPWR sky130_fd_sc_hd__tapvpwrvgnd_1
XFILLER_51_402 VGND VGND VPWR VPWR sky130_fd_sc_hd__decap_3
XFILLER_63_240 VGND VGND VPWR VPWR sky130_fd_sc_hd__decap_3
X_4984_ _5178_/A _6077_/C VGND VGND VPWR VPWR _4984_/Y sky130_fd_sc_hd__nor2_2
X_3935_ _6151_/B VGND VGND VPWR VPWR _6086_/A sky130_fd_sc_hd__inv_2
X_5605_ _5604_/A _5570_/A _5570_/B _5591_/S VGND VGND VPWR VPWR _5606_/B sky130_fd_sc_hd__a31o_2
X_3866_ _3859_/Y _3919_/B _3863_/Y _3864_/Y _3865_/Y VGND VGND VPWR VPWR _3870_/A
+ sky130_fd_sc_hd__o221a_2
XFILLER_11_15 VGND VGND VPWR VPWR sky130_fd_sc_hd__fill_2
X_3797_ _3234_/X _3315_/X _3325_/X _3316_/X _3495_/A _4026_/S1 VGND VGND VPWR VPWR
+ _3797_/X sky130_fd_sc_hd__mux4_2
X_5536_ _5534_/X _5536_/B _5536_/C _5536_/D VGND VGND VPWR VPWR _5539_/B sky130_fd_sc_hd__nand4b_2
X_5467_ _5467_/A _5467_/B VGND VGND VPWR VPWR _5467_/X sky130_fd_sc_hd__or2_2
X_4418_ _3703_/B _3696_/X _5010_/S VGND VGND VPWR VPWR _4418_/X sky130_fd_sc_hd__mux2_2
X_5398_ _5322_/B _5384_/X _5395_/X _5396_/X _5397_/Y VGND VGND VPWR VPWR _5398_/X
+ sky130_fd_sc_hd__o2111a_2
Xfanout345 _3798_/A VGND VGND VPWR VPWR _3424_/B sky130_fd_sc_hd__clkdlybuf4s25_1
Xfanout356 _6251_/B VGND VGND VPWR VPWR _6061_/B sky130_fd_sc_hd__clkdlybuf4s25_1
X_4349_ _4356_/A _4301_/B _4348_/X VGND VGND VPWR VPWR _4393_/B sky130_fd_sc_hd__o21ai_2
Xfanout367 _6176_/B VGND VGND VPWR VPWR _6059_/A sky130_fd_sc_hd__clkdlybuf4s25_1
Xfanout378 _6449_/S0 VGND VGND VPWR VPWR _4675_/S1 sky130_fd_sc_hd__clkdlybuf4s25_1
XFILLER_46_229 VGND VGND VPWR VPWR sky130_fd_sc_hd__decap_3
X_6019_ _6152_/A _6151_/C _6151_/D _6019_/D VGND VGND VPWR VPWR _6183_/A sky130_fd_sc_hd__and4_2
XTAP_TAPCELL_ROW_29_438 VGND VPWR sky130_fd_sc_hd__tapvpwrvgnd_1
XFILLER_36_67 VGND VGND VPWR VPWR sky130_fd_sc_hd__decap_3
XFILLER_54_251 VGND VGND VPWR VPWR sky130_fd_sc_hd__fill_1
XFILLER_54_262 VGND VGND VPWR VPWR sky130_fd_sc_hd__fill_1
XFILLER_54_284 VGND VGND VPWR VPWR sky130_fd_sc_hd__decap_3
XTAP_TAPCELL_ROW_20_360 VGND VPWR sky130_fd_sc_hd__tapvpwrvgnd_1
XFILLER_77_30 VGND VGND VPWR VPWR sky130_fd_sc_hd__fill_2
XFILLER_45_240 VGND VGND VPWR VPWR sky130_fd_sc_hd__decap_3
XFILLER_45_262 VGND VGND VPWR VPWR sky130_fd_sc_hd__decap_3
XFILLER_45_284 VGND VGND VPWR VPWR sky130_fd_sc_hd__decap_3
XFILLER_60_221 VGND VGND VPWR VPWR sky130_fd_sc_hd__decap_3
XFILLER_60_210 VGND VGND VPWR VPWR sky130_fd_sc_hd__decap_3
XFILLER_20_129 VGND VGND VPWR VPWR sky130_fd_sc_hd__decap_3
X_3720_ _3335_/X _3701_/X _3710_/X _3719_/X VGND VGND VPWR VPWR _3720_/X sky130_fd_sc_hd__a211o_2
XFILLER_60_287 VGND VGND VPWR VPWR sky130_fd_sc_hd__decap_3
X_3651_ _3908_/A _6467_/A3 _3791_/S VGND VGND VPWR VPWR _3651_/X sky130_fd_sc_hd__mux2_2
X_6370_ _5658_/A _6369_/Y _6349_/B VGND VGND VPWR VPWR _6370_/X sky130_fd_sc_hd__a21o_2
X_3582_ _6450_/A1 _6446_/A0 _5225_/S _6449_/A0 _6450_/S0 _3648_/S1 VGND VGND VPWR
+ VPWR _3582_/X sky130_fd_sc_hd__mux4_2
X_5321_ _5406_/A2 _5272_/B _5320_/Y VGND VGND VPWR VPWR _5322_/B sky130_fd_sc_hd__a21boi_2
X_5252_ _6391_/C _5200_/B VGND VGND VPWR VPWR _5277_/B sky130_fd_sc_hd__or2b_2
X_5183_ _5191_/B _5274_/B VGND VGND VPWR VPWR _5183_/Y sky130_fd_sc_hd__nand2_2
X_4203_ _6171_/A _5180_/B VGND VGND VPWR VPWR _4203_/Y sky130_fd_sc_hd__nand2_2
XFILLER_68_321 VGND VGND VPWR VPWR sky130_fd_sc_hd__decap_3
X_4134_ _4120_/A _4120_/B _4120_/C _4120_/D _6167_/B VGND VGND VPWR VPWR _4135_/B
+ sky130_fd_sc_hd__o41a_2
XFILLER_68_365 VGND VGND VPWR VPWR sky130_fd_sc_hd__decap_3
XTAP_TAPCELL_ROW_79_894 VGND VPWR sky130_fd_sc_hd__tapvpwrvgnd_1
X_4065_ _4124_/A _4038_/Y _4048_/X _5685_/A _4064_/X VGND VGND VPWR VPWR _5993_/C
+ sky130_fd_sc_hd__a221o_2
XFILLER_24_402 VGND VGND VPWR VPWR sky130_fd_sc_hd__decap_3
XFILLER_36_251 VGND VGND VPWR VPWR sky130_fd_sc_hd__fill_1
XFILLER_36_284 VGND VGND VPWR VPWR sky130_fd_sc_hd__fill_2
XFILLER_51_243 VGND VGND VPWR VPWR sky130_fd_sc_hd__decap_3
XFILLER_51_276 VGND VGND VPWR VPWR sky130_fd_sc_hd__decap_3
X_4967_ _4967_/A _4967_/B _4967_/C _5535_/A VGND VGND VPWR VPWR _4968_/D sky130_fd_sc_hd__nor4_2
XTAP_TAPCELL_ROW_34_485 VGND VPWR sky130_fd_sc_hd__tapvpwrvgnd_1
X_4898_ _4901_/A _4898_/B VGND VGND VPWR VPWR _4898_/Y sky130_fd_sc_hd__nand2_2
X_3918_ _3921_/A _3921_/B VGND VGND VPWR VPWR _3919_/C sky130_fd_sc_hd__nand2_2
X_3849_ _6062_/C _3640_/A _4473_/A _6144_/B VGND VGND VPWR VPWR _3849_/X sky130_fd_sc_hd__o2bb2a_2
X_5519_ _5951_/A1 _5500_/A _5511_/X _5512_/Y _5518_/X VGND VGND VPWR VPWR _5519_/X
+ sky130_fd_sc_hd__a221o_2
XFILLER_3_328 VGND VGND VPWR VPWR sky130_fd_sc_hd__fill_1
X_6499_ _6491_/X _6492_/X _6499_/S VGND VGND VPWR VPWR _6499_/X sky130_fd_sc_hd__mux2_2
XFILLER_59_343 VGND VGND VPWR VPWR sky130_fd_sc_hd__decap_3
XFILLER_74_324 VGND VGND VPWR VPWR sky130_fd_sc_hd__decap_3
XFILLER_59_376 VGND VGND VPWR VPWR sky130_fd_sc_hd__decap_3
XFILLER_74_335 VGND VGND VPWR VPWR sky130_fd_sc_hd__fill_2
XFILLER_15_402 VGND VGND VPWR VPWR sky130_fd_sc_hd__decap_3
XFILLER_27_262 VGND VGND VPWR VPWR sky130_fd_sc_hd__decap_3
XFILLER_27_284 VGND VGND VPWR VPWR sky130_fd_sc_hd__fill_2
XFILLER_42_221 VGND VGND VPWR VPWR sky130_fd_sc_hd__fill_1
XFILLER_42_265 VGND VGND VPWR VPWR sky130_fd_sc_hd__decap_3
Xmax_cap309 _3500_/S VGND VGND VPWR VPWR _3529_/S sky130_fd_sc_hd__clkbuf_2
XTAP_TAPCELL_ROW_76_864 VGND VPWR sky130_fd_sc_hd__tapvpwrvgnd_1
X_5870_ _6477_/A _5870_/B VGND VGND VPWR VPWR _5870_/Y sky130_fd_sc_hd__nor2_2
X_4821_ _4821_/A VGND VGND VPWR VPWR _4922_/B sky130_fd_sc_hd__inv_2
XFILLER_21_405 VGND VGND VPWR VPWR sky130_fd_sc_hd__decap_3
XFILLER_33_287 VGND VGND VPWR VPWR sky130_fd_sc_hd__decap_3
XFILLER_21_449 VGND VGND VPWR VPWR sky130_fd_sc_hd__fill_2
X_4752_ _6244_/A _5180_/B _4748_/X _4749_/X _4751_/X VGND VGND VPWR VPWR _4752_/X
+ sky130_fd_sc_hd__a221o_2
X_4683_ _6061_/B _5099_/B _5352_/C _4657_/X _4682_/X VGND VGND VPWR VPWR _4683_/X
+ sky130_fd_sc_hd__a221o_2
X_3703_ _3703_/A _3703_/B VGND VGND VPWR VPWR _3710_/B sky130_fd_sc_hd__or2_2
XTAP_TAPCELL_ROW_31_455 VGND VPWR sky130_fd_sc_hd__tapvpwrvgnd_1
X_6422_ _6422_/A _5975_/C VGND VGND VPWR VPWR _6490_/S sky130_fd_sc_hd__or2b_2
X_3634_ _3581_/X _3582_/X _3631_/X _3632_/X _3949_/S _4506_/S VGND VGND VPWR VPWR
+ _3634_/X sky130_fd_sc_hd__mux4_2
X_6353_ _6336_/Y _6343_/Y _6352_/X VGND VGND VPWR VPWR _6354_/D sky130_fd_sc_hd__o21ba_2
X_3565_ _6108_/B _3668_/B _6113_/A VGND VGND VPWR VPWR _3565_/X sky130_fd_sc_hd__o21a_2
X_6284_ _6284_/A VGND VGND VPWR VPWR _6358_/B sky130_fd_sc_hd__buf_1
X_5304_ _5396_/A _5272_/Y _5296_/X _5303_/X VGND VGND VPWR VPWR _5984_/D sky130_fd_sc_hd__a211o_2
X_3496_ _3761_/S _3556_/A VGND VGND VPWR VPWR _3668_/B sky130_fd_sc_hd__or2_2
X_5235_ _5200_/B _5214_/B _5234_/X VGND VGND VPWR VPWR _5236_/B sky130_fd_sc_hd__o21a_2
XFILLER_29_505 VGND VGND VPWR VPWR sky130_fd_sc_hd__fill_2
X_5166_ _5166_/A _5166_/B VGND VGND VPWR VPWR _5166_/X sky130_fd_sc_hd__or2_2
XFILLER_56_324 VGND VGND VPWR VPWR sky130_fd_sc_hd__decap_3
X_5097_ _4515_/A _4288_/A _5097_/S VGND VGND VPWR VPWR _5097_/X sky130_fd_sc_hd__mux2_2
X_4117_ _4124_/A _4075_/Y _4093_/Y _4498_/B _4116_/X VGND VGND VPWR VPWR _5994_/A
+ sky130_fd_sc_hd__a221o_2
XTAP_TAPCELL_ROW_39_533 VGND VPWR sky130_fd_sc_hd__tapvpwrvgnd_1
XFILLER_68_195 VGND VGND VPWR VPWR sky130_fd_sc_hd__fill_1
XFILLER_68_184 VGND VGND VPWR VPWR sky130_fd_sc_hd__fill_2
XFILLER_56_368 VGND VGND VPWR VPWR sky130_fd_sc_hd__fill_2
XFILLER_56_379 VGND VGND VPWR VPWR sky130_fd_sc_hd__decap_3
X_4048_ _4048_/A _4048_/B VGND VGND VPWR VPWR _4048_/X sky130_fd_sc_hd__xor2_2
XFILLER_64_390 VGND VGND VPWR VPWR sky130_fd_sc_hd__decap_3
XFILLER_24_265 VGND VGND VPWR VPWR sky130_fd_sc_hd__decap_3
XFILLER_24_287 VGND VGND VPWR VPWR sky130_fd_sc_hd__decap_3
X_5999_ _5999_/A _5999_/B _5999_/C _5999_/D VGND VGND VPWR VPWR _5999_/Y sky130_fd_sc_hd__nor4_2
XFILLER_33_57 VGND VGND VPWR VPWR sky130_fd_sc_hd__fill_1
XFILLER_59_151 VGND VGND VPWR VPWR sky130_fd_sc_hd__decap_3
XFILLER_47_346 VGND VGND VPWR VPWR sky130_fd_sc_hd__decap_3
XFILLER_59_184 VGND VGND VPWR VPWR sky130_fd_sc_hd__decap_3
XTAP_TAPCELL_ROW_73_834 VGND VPWR sky130_fd_sc_hd__tapvpwrvgnd_1
XFILLER_62_327 VGND VGND VPWR VPWR sky130_fd_sc_hd__decap_3
XFILLER_55_390 VGND VGND VPWR VPWR sky130_fd_sc_hd__fill_2
XFILLER_15_287 VGND VGND VPWR VPWR sky130_fd_sc_hd__decap_3
XFILLER_30_202 VGND VGND VPWR VPWR sky130_fd_sc_hd__decap_3
XFILLER_30_235 VGND VGND VPWR VPWR sky130_fd_sc_hd__decap_3
XFILLER_30_279 VGND VGND VPWR VPWR sky130_fd_sc_hd__decap_3
X_3350_ _3350_/A VGND VGND VPWR VPWR _3350_/X sky130_fd_sc_hd__clkbuf_1
X_5020_ _6270_/A _6265_/B VGND VGND VPWR VPWR _5030_/B sky130_fd_sc_hd__nand2b_2
X_3281_ _3754_/A _6464_/A1 _3791_/S VGND VGND VPWR VPWR _3281_/X sky130_fd_sc_hd__mux2_2
XFILLER_24_3 VGND VGND VPWR VPWR sky130_fd_sc_hd__fill_1
Xload_slew389 _6461_/S0 VGND VGND VPWR VPWR _3575_/S0 sky130_fd_sc_hd__buf_4
XFILLER_38_346 VGND VGND VPWR VPWR sky130_fd_sc_hd__decap_3
XFILLER_38_368 VGND VGND VPWR VPWR sky130_fd_sc_hd__decap_3
XFILLER_53_305 VGND VGND VPWR VPWR sky130_fd_sc_hd__decap_3
XTAP_TAPCELL_ROW_36_503 VGND VPWR sky130_fd_sc_hd__tapvpwrvgnd_1
XFILLER_65_187 VGND VGND VPWR VPWR sky130_fd_sc_hd__decap_3
XFILLER_0_83 VGND VGND VPWR VPWR sky130_fd_sc_hd__fill_1
XFILLER_53_349 VGND VGND VPWR VPWR sky130_fd_sc_hd__fill_2
X_5922_ _5922_/A _5922_/B VGND VGND VPWR VPWR _5924_/B sky130_fd_sc_hd__nand2_2
X_5853_ _5853_/A _5853_/B VGND VGND VPWR VPWR _5854_/B sky130_fd_sc_hd__nor2_2
X_5784_ _5721_/B _5748_/A _5750_/B VGND VGND VPWR VPWR _5816_/B sky130_fd_sc_hd__a21oi_2
X_4804_ _4631_/X _4803_/X _5442_/S VGND VGND VPWR VPWR _4804_/X sky130_fd_sc_hd__mux2_2
XFILLER_61_393 VGND VGND VPWR VPWR sky130_fd_sc_hd__decap_3
XFILLER_61_382 VGND VGND VPWR VPWR sky130_fd_sc_hd__decap_3
XFILLER_21_268 VGND VGND VPWR VPWR sky130_fd_sc_hd__fill_2
XFILLER_21_279 VGND VGND VPWR VPWR sky130_fd_sc_hd__fill_1
X_4735_ _4783_/B _4753_/B VGND VGND VPWR VPWR _4735_/X sky130_fd_sc_hd__and2_2
X_4666_ _4666_/A VGND VGND VPWR VPWR _4967_/B sky130_fd_sc_hd__buf_1
X_6405_ _5866_/A _6400_/Y _6404_/X VGND VGND VPWR VPWR _6405_/Y sky130_fd_sc_hd__a21oi_2
X_4597_ _3881_/X _3898_/B _4636_/S VGND VGND VPWR VPWR _4597_/X sky130_fd_sc_hd__mux2_2
X_3617_ _3856_/A _3856_/B VGND VGND VPWR VPWR _3735_/B sky130_fd_sc_hd__nand2_2
X_6336_ _6343_/A _6325_/Y _6331_/X _6335_/Y VGND VGND VPWR VPWR _6336_/Y sky130_fd_sc_hd__o211ai_2
X_3548_ _3578_/A _3548_/B VGND VGND VPWR VPWR _3548_/Y sky130_fd_sc_hd__nor2_2
X_6267_ _6077_/C _6270_/C _6270_/A VGND VGND VPWR VPWR _6267_/Y sky130_fd_sc_hd__o21ai_2
X_3479_ _3479_/A _3489_/A _3479_/C VGND VGND VPWR VPWR _3480_/C sky130_fd_sc_hd__and3_2
X_6198_ _6198_/A _6198_/B _6198_/C VGND VGND VPWR VPWR _6239_/A sky130_fd_sc_hd__and3_2
X_5218_ _5664_/B1 _4554_/B _5217_/X VGND VGND VPWR VPWR _5218_/X sky130_fd_sc_hd__a21o_2
X_5149_ _4797_/X _5210_/A _5145_/Y _5147_/X _5148_/Y VGND VGND VPWR VPWR _5149_/X
+ sky130_fd_sc_hd__o221a_2
XFILLER_29_379 VGND VGND VPWR VPWR sky130_fd_sc_hd__decap_3
XFILLER_56_165 VGND VGND VPWR VPWR sky130_fd_sc_hd__fill_2
XFILLER_44_327 VGND VGND VPWR VPWR sky130_fd_sc_hd__decap_3
XFILLER_56_176 VGND VGND VPWR VPWR sky130_fd_sc_hd__decap_3
XFILLER_71_113 VGND VGND VPWR VPWR sky130_fd_sc_hd__fill_2
XFILLER_71_179 VGND VGND VPWR VPWR sky130_fd_sc_hd__decap_3
XFILLER_20_290 VGND VGND VPWR VPWR sky130_fd_sc_hd__decap_3
XFILLER_60_77 VGND VGND VPWR VPWR sky130_fd_sc_hd__fill_1
XFILLER_69_31 VGND VGND VPWR VPWR sky130_fd_sc_hd__fill_1
XFILLER_79_268 VGND VGND VPWR VPWR sky130_fd_sc_hd__decap_3
XFILLER_47_110 VGND VGND VPWR VPWR sky130_fd_sc_hd__fill_2
XFILLER_35_316 VGND VGND VPWR VPWR sky130_fd_sc_hd__decap_3
XFILLER_47_187 VGND VGND VPWR VPWR sky130_fd_sc_hd__decap_3
XFILLER_62_157 VGND VGND VPWR VPWR sky130_fd_sc_hd__fill_1
XFILLER_62_135 VGND VGND VPWR VPWR sky130_fd_sc_hd__decap_3
XFILLER_43_360 VGND VGND VPWR VPWR sky130_fd_sc_hd__decap_3
XFILLER_62_179 VGND VGND VPWR VPWR sky130_fd_sc_hd__decap_3
XFILLER_43_382 VGND VGND VPWR VPWR sky130_fd_sc_hd__decap_3
XFILLER_43_393 VGND VGND VPWR VPWR sky130_fd_sc_hd__decap_3
XTAP_TAPCELL_ROW_41_550 VGND VPWR sky130_fd_sc_hd__tapvpwrvgnd_1
XFILLER_11_290 VGND VGND VPWR VPWR sky130_fd_sc_hd__decap_3
X_4520_ _3805_/X _4598_/B _4514_/X _3704_/A _4519_/X VGND VGND VPWR VPWR _4520_/X
+ sky130_fd_sc_hd__o221a_2
XTAP_TAPCELL_ROW_13_296 VGND VPWR sky130_fd_sc_hd__tapvpwrvgnd_1
X_4451_ _6022_/C _4450_/B _6208_/A VGND VGND VPWR VPWR _4451_/Y sky130_fd_sc_hd__a21oi_2
X_3402_ _3535_/A _3389_/X _3398_/X _3310_/Y _3401_/Y VGND VGND VPWR VPWR _3402_/X
+ sky130_fd_sc_hd__a221o_2
X_6121_ _6120_/X _6116_/A _6121_/S VGND VGND VPWR VPWR _6121_/X sky130_fd_sc_hd__mux2_2
X_4382_ _3650_/X _3634_/X _4382_/S VGND VGND VPWR VPWR _4383_/B sky130_fd_sc_hd__mux2_2
X_3333_ _3633_/A VGND VGND VPWR VPWR _3750_/A sky130_fd_sc_hd__clkbuf_2
X_6052_ _6078_/A _6250_/B _6078_/C VGND VGND VPWR VPWR _6055_/B sky130_fd_sc_hd__and3_2
X_3264_ _3264_/A VGND VGND VPWR VPWR _3760_/A sky130_fd_sc_hd__inv_2
XPHY_EDGE_ROW_7_Right_7 VGND VGND VPWR VPWR sky130_fd_sc_hd__decap_3
XFILLER_58_419 VGND VGND VPWR VPWR sky130_fd_sc_hd__fill_1
X_5003_ _5004_/B _5004_/C _5004_/A VGND VGND VPWR VPWR _5003_/X sky130_fd_sc_hd__a21o_2
XFILLER_38_154 VGND VGND VPWR VPWR sky130_fd_sc_hd__decap_3
XFILLER_26_338 VGND VGND VPWR VPWR sky130_fd_sc_hd__decap_3
XFILLER_53_102 VGND VGND VPWR VPWR sky130_fd_sc_hd__fill_1
XFILLER_53_113 VGND VGND VPWR VPWR sky130_fd_sc_hd__decap_3
XFILLER_19_390 VGND VGND VPWR VPWR sky130_fd_sc_hd__fill_2
XFILLER_53_135 VGND VGND VPWR VPWR sky130_fd_sc_hd__decap_3
XFILLER_53_157 VGND VGND VPWR VPWR sky130_fd_sc_hd__decap_3
XFILLER_41_308 VGND VGND VPWR VPWR sky130_fd_sc_hd__decap_3
XFILLER_53_179 VGND VGND VPWR VPWR sky130_fd_sc_hd__decap_3
X_5905_ wire282/X wire281/X _5925_/A VGND VGND VPWR VPWR _5905_/X sky130_fd_sc_hd__mux2_2
X_5836_ _3901_/B _4456_/Y _5242_/Y _5835_/X VGND VGND VPWR VPWR _5836_/X sky130_fd_sc_hd__a31o_2
X_5767_ _3805_/X _5510_/B _5740_/A _5766_/Y VGND VGND VPWR VPWR _5767_/X sky130_fd_sc_hd__o211a_2
X_5698_ _5968_/A _6374_/C _5697_/X VGND VGND VPWR VPWR _5698_/X sky130_fd_sc_hd__o21a_2
X_4718_ _4567_/B2 _4717_/X _4154_/Y _4010_/X VGND VGND VPWR VPWR _4718_/X sky130_fd_sc_hd__a2bb2o_2
X_4649_ _6060_/D _5180_/B _4945_/A _4648_/X VGND VGND VPWR VPWR _4649_/Y sky130_fd_sc_hd__a22oi_2
XPHY_EDGE_ROW_12_Left_95 VGND VGND VPWR VPWR sky130_fd_sc_hd__decap_3
X_6319_ _6319_/A _6319_/B _6358_/B VGND VGND VPWR VPWR _6324_/S sky130_fd_sc_hd__and3_2
XFILLER_39_45 VGND VGND VPWR VPWR sky130_fd_sc_hd__fill_2
XFILLER_49_408 VGND VGND VPWR VPWR sky130_fd_sc_hd__decap_3
XFILLER_76_205 VGND VGND VPWR VPWR sky130_fd_sc_hd__decap_3
XFILLER_76_238 VGND VGND VPWR VPWR sky130_fd_sc_hd__decap_3
XFILLER_29_165 VGND VGND VPWR VPWR sky130_fd_sc_hd__decap_3
XFILLER_29_187 VGND VGND VPWR VPWR sky130_fd_sc_hd__fill_1
XFILLER_44_113 VGND VGND VPWR VPWR sky130_fd_sc_hd__fill_1
XFILLER_44_135 VGND VGND VPWR VPWR sky130_fd_sc_hd__decap_3
XFILLER_72_455 VGND VGND VPWR VPWR sky130_fd_sc_hd__fill_1
XFILLER_44_168 VGND VGND VPWR VPWR sky130_fd_sc_hd__decap_3
XTAP_TAPCELL_ROW_55_675 VGND VPWR sky130_fd_sc_hd__tapvpwrvgnd_1
XFILLER_25_393 VGND VGND VPWR VPWR sky130_fd_sc_hd__decap_3
XFILLER_40_330 VGND VGND VPWR VPWR sky130_fd_sc_hd__decap_3
XFILLER_40_374 VGND VGND VPWR VPWR sky130_fd_sc_hd__decap_3
XTAP_TAPCELL_ROW_10_266 VGND VPWR sky130_fd_sc_hd__tapvpwrvgnd_1
XFILLER_35_113 VGND VGND VPWR VPWR sky130_fd_sc_hd__decap_3
XFILLER_75_271 VGND VGND VPWR VPWR sky130_fd_sc_hd__decap_3
XFILLER_75_293 VGND VGND VPWR VPWR sky130_fd_sc_hd__decap_3
XFILLER_23_319 VGND VGND VPWR VPWR sky130_fd_sc_hd__fill_2
X_3951_ _4233_/A _3948_/X _3950_/X _3976_/A VGND VGND VPWR VPWR _3951_/X sky130_fd_sc_hd__o211a_2
XTAP_TAPCELL_ROW_18_344 VGND VPWR sky130_fd_sc_hd__tapvpwrvgnd_1
XFILLER_50_127 VGND VGND VPWR VPWR sky130_fd_sc_hd__decap_3
XFILLER_43_190 VGND VGND VPWR VPWR sky130_fd_sc_hd__decap_3
X_3882_ _3376_/X _3388_/X _3441_/X _3483_/X _4061_/S1 _3800_/A VGND VGND VPWR VPWR
+ _3883_/B sky130_fd_sc_hd__mux4_2
XFILLER_31_396 VGND VGND VPWR VPWR sky130_fd_sc_hd__decap_3
X_5621_ _5609_/X _5612_/X _5613_/X _5967_/B1 _5620_/Y VGND VGND VPWR VPWR _5621_/X
+ sky130_fd_sc_hd__a221o_2
X_5552_ _5587_/A _5552_/B VGND VGND VPWR VPWR _5552_/Y sky130_fd_sc_hd__nand2_2
X_4503_ _4503_/A VGND VGND VPWR VPWR _4503_/Y sky130_fd_sc_hd__inv_2
X_5483_ _4505_/X _4833_/X _5174_/X _5482_/X _5548_/S _5284_/S VGND VGND VPWR VPWR
+ _5483_/X sky130_fd_sc_hd__mux4_2
X_4434_ _4356_/A _4301_/B _4408_/X _4348_/X _6059_/A VGND VGND VPWR VPWR _4434_/X
+ sky130_fd_sc_hd__o2111a_2
Xfanout505 input48/X VGND VGND VPWR VPWR _6439_/A0 sky130_fd_sc_hd__clkdlybuf4s25_1
X_4365_ _4365_/A _6059_/A VGND VGND VPWR VPWR _4365_/X sky130_fd_sc_hd__or2_2
X_6104_ _6109_/B _6103_/Y _6098_/Y _3667_/A VGND VGND VPWR VPWR _6104_/X sky130_fd_sc_hd__a22o_2
Xfanout516 input43/X VGND VGND VPWR VPWR _5338_/A3 sky130_fd_sc_hd__clkdlybuf4s25_1
Xfanout527 _6109_/B VGND VGND VPWR VPWR _3556_/A sky130_fd_sc_hd__clkdlybuf4s25_1
Xfanout538 input35/X VGND VGND VPWR VPWR _6450_/A0 sky130_fd_sc_hd__clkdlybuf4s25_1
X_3316_ _6457_/A1 _6460_/A0 _6460_/A1 _6447_/A0 _3575_/S0 _3948_/S1 VGND VGND VPWR
+ VPWR _3316_/X sky130_fd_sc_hd__mux4_2
X_6035_ _6035_/A VGND VGND VPWR VPWR _6417_/B sky130_fd_sc_hd__buf_1
Xfanout549 input30/X VGND VGND VPWR VPWR _6460_/A2 sky130_fd_sc_hd__clkdlybuf4s25_1
X_4296_ _4124_/A _4273_/X _4266_/A _4168_/X _4295_/Y VGND VGND VPWR VPWR _4296_/X
+ sky130_fd_sc_hd__a221o_2
X_3247_ _3367_/A VGND VGND VPWR VPWR _4106_/A sky130_fd_sc_hd__clkbuf_1
XFILLER_39_463 VGND VGND VPWR VPWR sky130_fd_sc_hd__fill_2
XFILLER_54_411 VGND VGND VPWR VPWR sky130_fd_sc_hd__decap_3
XFILLER_66_271 VGND VGND VPWR VPWR sky130_fd_sc_hd__decap_3
XFILLER_54_433 VGND VGND VPWR VPWR sky130_fd_sc_hd__decap_3
XFILLER_54_477 VGND VGND VPWR VPWR sky130_fd_sc_hd__decap_3
XFILLER_34_190 VGND VGND VPWR VPWR sky130_fd_sc_hd__decap_3
XFILLER_41_149 VGND VGND VPWR VPWR sky130_fd_sc_hd__decap_3
XTAP_TAPCELL_ROW_52_645 VGND VPWR sky130_fd_sc_hd__tapvpwrvgnd_1
X_5819_ _5818_/B _5818_/C _5885_/A VGND VGND VPWR VPWR _5819_/Y sky130_fd_sc_hd__o21ai_2
XFILLER_49_216 VGND VGND VPWR VPWR sky130_fd_sc_hd__decap_3
XFILLER_57_260 VGND VGND VPWR VPWR sky130_fd_sc_hd__decap_3
XFILLER_45_466 VGND VGND VPWR VPWR sky130_fd_sc_hd__fill_1
XFILLER_32_127 VGND VGND VPWR VPWR sky130_fd_sc_hd__decap_3
XTAP_TAPCELL_ROW_15_314 VGND VPWR sky130_fd_sc_hd__tapvpwrvgnd_1
XFILLER_25_190 VGND VGND VPWR VPWR sky130_fd_sc_hd__fill_2
XFILLER_40_171 VGND VGND VPWR VPWR sky130_fd_sc_hd__decap_3
XFILLER_13_396 VGND VGND VPWR VPWR sky130_fd_sc_hd__fill_1
X_4150_ _4150_/A _4150_/B VGND VGND VPWR VPWR _4150_/Y sky130_fd_sc_hd__nor2_2
X_4081_ _3934_/X _3955_/X _4035_/X _3956_/A _4044_/B VGND VGND VPWR VPWR _4084_/A
+ sky130_fd_sc_hd__a2111o_2
XFILLER_36_400 VGND VGND VPWR VPWR sky130_fd_sc_hd__decap_3
XFILLER_48_271 VGND VGND VPWR VPWR sky130_fd_sc_hd__decap_3
XFILLER_55_208 VGND VGND VPWR VPWR sky130_fd_sc_hd__fill_1
XFILLER_36_477 VGND VGND VPWR VPWR sky130_fd_sc_hd__fill_2
XFILLER_63_252 VGND VGND VPWR VPWR sky130_fd_sc_hd__decap_3
X_4983_ _6077_/C _6265_/A VGND VGND VPWR VPWR _6270_/B sky130_fd_sc_hd__nand2b_2
X_3934_ _6151_/B _3965_/A VGND VGND VPWR VPWR _3934_/X sky130_fd_sc_hd__and2b_2
X_3865_ _3752_/X _3812_/X _3786_/X VGND VGND VPWR VPWR _3865_/Y sky130_fd_sc_hd__a21oi_2
XFILLER_31_182 VGND VGND VPWR VPWR sky130_fd_sc_hd__fill_2
XFILLER_31_193 VGND VGND VPWR VPWR sky130_fd_sc_hd__decap_3
X_5604_ _5604_/A _5604_/B VGND VGND VPWR VPWR _5606_/A sky130_fd_sc_hd__or2_2
X_3796_ _3940_/A _3789_/X _4503_/A _3594_/X VGND VGND VPWR VPWR _3796_/Y sky130_fd_sc_hd__a22oi_2
X_5535_ _5535_/A _5535_/B _5535_/C VGND VGND VPWR VPWR _5536_/C sky130_fd_sc_hd__nor3_2
X_5466_ _5466_/A _5530_/B _5501_/B VGND VGND VPWR VPWR _5466_/X sky130_fd_sc_hd__or3_2
X_4417_ _4636_/S _3714_/Y _4416_/Y _4840_/B VGND VGND VPWR VPWR _4417_/X sky130_fd_sc_hd__a211o_2
X_5397_ _5418_/B _5383_/Y _5393_/Y _5322_/B VGND VGND VPWR VPWR _5397_/Y sky130_fd_sc_hd__o211ai_2
Xfanout335 _5002_/A VGND VGND VPWR VPWR _6077_/C sky130_fd_sc_hd__clkdlybuf4s25_1
Xfanout346 _3798_/A VGND VGND VPWR VPWR _3654_/S1 sky130_fd_sc_hd__clkdlybuf4s25_1
Xfanout357 input90/X VGND VGND VPWR VPWR _6060_/D sky130_fd_sc_hd__clkdlybuf4s25_1
X_4348_ _6021_/D _6199_/B VGND VGND VPWR VPWR _4348_/X sky130_fd_sc_hd__or2b_2
Xfanout368 _6173_/B VGND VGND VPWR VPWR _6021_/D sky130_fd_sc_hd__clkdlybuf4s25_1
Xfanout379 fanout406/X VGND VGND VPWR VPWR _6449_/S0 sky130_fd_sc_hd__clkdlybuf4s25_1
X_4279_ _6108_/A _4279_/B VGND VGND VPWR VPWR _4279_/Y sky130_fd_sc_hd__nand2_2
XFILLER_46_208 VGND VGND VPWR VPWR sky130_fd_sc_hd__decap_3
X_6018_ _6151_/A _6151_/B VGND VGND VPWR VPWR _6019_/D sky130_fd_sc_hd__and2_2
XFILLER_27_422 VGND VGND VPWR VPWR sky130_fd_sc_hd__fill_2
XTAP_TAPCELL_ROW_29_439 VGND VPWR sky130_fd_sc_hd__tapvpwrvgnd_1
XFILLER_42_414 VGND VGND VPWR VPWR sky130_fd_sc_hd__decap_3
XFILLER_10_333 VGND VGND VPWR VPWR sky130_fd_sc_hd__decap_3
XFILLER_10_355 VGND VGND VPWR VPWR sky130_fd_sc_hd__decap_3
XTAP_TAPCELL_ROW_20_361 VGND VPWR sky130_fd_sc_hd__tapvpwrvgnd_1
XFILLER_45_274 VGND VGND VPWR VPWR sky130_fd_sc_hd__decap_3
XFILLER_45_296 VGND VGND VPWR VPWR sky130_fd_sc_hd__decap_3
XFILLER_60_233 VGND VGND VPWR VPWR sky130_fd_sc_hd__decap_3
XFILLER_60_299 VGND VGND VPWR VPWR sky130_fd_sc_hd__decap_3
X_3650_ _3573_/X _3574_/X _3648_/X _3649_/X _3633_/A _4025_/S1 VGND VGND VPWR VPWR
+ _3650_/X sky130_fd_sc_hd__mux4_2
X_3581_ _6449_/A1 _6439_/A0 _5615_/A3 _6440_/A0 _3631_/S0 _3631_/S1 VGND VGND VPWR
+ VPWR _3581_/X sky130_fd_sc_hd__mux4_2
X_5320_ _5406_/A2 _5272_/B _5316_/A VGND VGND VPWR VPWR _5320_/Y sky130_fd_sc_hd__o21ai_2
X_5251_ _6306_/C VGND VGND VPWR VPWR _5251_/Y sky130_fd_sc_hd__inv_2
X_4202_ _4202_/A VGND VGND VPWR VPWR _5180_/B sky130_fd_sc_hd__clkbuf_2
X_5182_ _5191_/B _5274_/B VGND VGND VPWR VPWR _5182_/X sky130_fd_sc_hd__or2_2
X_4133_ input77/X _4089_/B _4109_/S VGND VGND VPWR VPWR _4135_/A sky130_fd_sc_hd__a21oi_2
XFILLER_68_333 VGND VGND VPWR VPWR sky130_fd_sc_hd__decap_3
X_4064_ _4064_/A _4064_/B VGND VGND VPWR VPWR _4064_/X sky130_fd_sc_hd__or2_2
XTAP_TAPCELL_ROW_26_409 VGND VPWR sky130_fd_sc_hd__tapvpwrvgnd_1
XFILLER_24_414 VGND VGND VPWR VPWR sky130_fd_sc_hd__fill_2
XFILLER_51_211 VGND VGND VPWR VPWR sky130_fd_sc_hd__decap_3
XFILLER_51_255 VGND VGND VPWR VPWR sky130_fd_sc_hd__decap_3
XTAP_TAPCELL_ROW_62_740 VGND VPWR sky130_fd_sc_hd__tapvpwrvgnd_1
XFILLER_11_119 VGND VGND VPWR VPWR sky130_fd_sc_hd__fill_2
X_4966_ _4918_/X _4921_/X _4924_/Y _5535_/C VGND VGND VPWR VPWR _4968_/C sky130_fd_sc_hd__a211oi_2
X_4897_ _4900_/A _6077_/A VGND VGND VPWR VPWR _4898_/B sky130_fd_sc_hd__nand2_2
X_3917_ _3917_/A VGND VGND VPWR VPWR _3926_/A sky130_fd_sc_hd__inv_2
XTAP_TAPCELL_ROW_34_486 VGND VPWR sky130_fd_sc_hd__tapvpwrvgnd_1
X_3848_ _6062_/C _6130_/S VGND VGND VPWR VPWR _6144_/B sky130_fd_sc_hd__or2b_2
X_3779_ _3949_/S _3748_/B _6453_/A VGND VGND VPWR VPWR _3779_/X sky130_fd_sc_hd__o21a_2
X_5518_ _4207_/B _5050_/A _5517_/X _4848_/A wire230/X VGND VGND VPWR VPWR _5518_/X
+ sky130_fd_sc_hd__a221o_2
X_6498_ _6498_/A _6498_/B VGND VGND VPWR VPWR _6499_/S sky130_fd_sc_hd__xnor2_2
X_5449_ _5458_/A _5290_/B _5658_/C _5446_/Y _5448_/X VGND VGND VPWR VPWR _5449_/X
+ sky130_fd_sc_hd__a221o_2
XFILLER_59_355 VGND VGND VPWR VPWR sky130_fd_sc_hd__decap_3
XFILLER_59_388 VGND VGND VPWR VPWR sky130_fd_sc_hd__decap_3
XFILLER_59_399 VGND VGND VPWR VPWR sky130_fd_sc_hd__decap_3
XFILLER_42_233 VGND VGND VPWR VPWR sky130_fd_sc_hd__decap_3
XFILLER_42_277 VGND VGND VPWR VPWR sky130_fd_sc_hd__decap_3
Xwire500 wire500/A VGND VGND VPWR VPWR _5853_/A sky130_fd_sc_hd__clkbuf_4
XFILLER_10_141 VGND VGND VPWR VPWR sky130_fd_sc_hd__fill_1
XFILLER_2_362 VGND VGND VPWR VPWR sky130_fd_sc_hd__fill_2
XPHY_EDGE_ROW_0_Left_83 VGND VGND VPWR VPWR sky130_fd_sc_hd__decap_3
XFILLER_77_196 VGND VGND VPWR VPWR sky130_fd_sc_hd__fill_1
XTAP_TAPCELL_ROW_76_865 VGND VPWR sky130_fd_sc_hd__tapvpwrvgnd_1
XFILLER_18_263 VGND VGND VPWR VPWR sky130_fd_sc_hd__fill_1
XFILLER_33_211 VGND VGND VPWR VPWR sky130_fd_sc_hd__decap_3
X_4820_ _4923_/B _4821_/A VGND VGND VPWR VPWR _4823_/A sky130_fd_sc_hd__or2b_2
XFILLER_33_255 VGND VGND VPWR VPWR sky130_fd_sc_hd__decap_3
X_4751_ _4751_/A _4751_/B _5352_/C VGND VGND VPWR VPWR _4751_/X sky130_fd_sc_hd__and3_2
X_4682_ _4561_/A _6061_/B _4681_/X VGND VGND VPWR VPWR _4682_/X sky130_fd_sc_hd__o21a_2
X_3702_ _3226_/X _3235_/X _3631_/X _3632_/X _3572_/S _3970_/A VGND VGND VPWR VPWR
+ _3703_/B sky130_fd_sc_hd__mux4_2
XTAP_TAPCELL_ROW_31_456 VGND VPWR sky130_fd_sc_hd__tapvpwrvgnd_1
X_6421_ _6047_/X _6406_/X _5627_/A _6413_/X _6420_/X VGND VGND VPWR VPWR _6488_/A
+ sky130_fd_sc_hd__o2111a_2
X_3633_ _3633_/A VGND VGND VPWR VPWR _3949_/S sky130_fd_sc_hd__clkbuf_2
X_6352_ _6374_/B _6352_/B _6374_/D _6347_/X VGND VGND VPWR VPWR _6352_/X sky130_fd_sc_hd__or4b_2
X_3564_ _6113_/A _6108_/B VGND VGND VPWR VPWR _6106_/B sky130_fd_sc_hd__and2_2
X_6283_ _6283_/A _6337_/B VGND VGND VPWR VPWR _6284_/A sky130_fd_sc_hd__and2_2
X_5303_ _5300_/Y _5319_/A _5669_/B2 VGND VGND VPWR VPWR _5303_/X sky130_fd_sc_hd__o21a_2
X_3495_ _3495_/A _3679_/A VGND VGND VPWR VPWR _3666_/C sky130_fd_sc_hd__nor2_2
X_5234_ _5200_/B _5214_/B _6391_/C VGND VGND VPWR VPWR _5234_/X sky130_fd_sc_hd__a21o_2
X_5165_ _5421_/A _5421_/B _5167_/C _6391_/A VGND VGND VPWR VPWR _5166_/B sky130_fd_sc_hd__o31a_2
X_4116_ _4842_/A _4105_/X _4093_/A _4168_/A _4115_/X VGND VGND VPWR VPWR _4116_/X
+ sky130_fd_sc_hd__a221o_2
XFILLER_56_336 VGND VGND VPWR VPWR sky130_fd_sc_hd__decap_3
X_5096_ _5096_/A VGND VGND VPWR VPWR _5097_/S sky130_fd_sc_hd__inv_2
XTAP_TAPCELL_ROW_39_534 VGND VPWR sky130_fd_sc_hd__tapvpwrvgnd_1
X_4047_ _4211_/A _4709_/A _4708_/A _4708_/B VGND VGND VPWR VPWR _4048_/B sky130_fd_sc_hd__or4_4
XFILLER_24_200 VGND VGND VPWR VPWR sky130_fd_sc_hd__decap_3
X_5998_ _5998_/A _5998_/B _5998_/C _5998_/D VGND VGND VPWR VPWR _6001_/B sky130_fd_sc_hd__or4_4
X_4949_ _4944_/X _4946_/Y _4948_/Y _4926_/A VGND VGND VPWR VPWR _4949_/X sky130_fd_sc_hd__a31o_2
XPHY_EDGE_ROW_18_Left_101 VGND VGND VPWR VPWR sky130_fd_sc_hd__decap_3
XFILLER_47_303 VGND VGND VPWR VPWR sky130_fd_sc_hd__decap_3
XFILLER_59_196 VGND VGND VPWR VPWR sky130_fd_sc_hd__fill_2
XPHY_EDGE_ROW_27_Left_110 VGND VGND VPWR VPWR sky130_fd_sc_hd__decap_3
XTAP_TAPCELL_ROW_73_835 VGND VPWR sky130_fd_sc_hd__tapvpwrvgnd_1
XFILLER_62_339 VGND VGND VPWR VPWR sky130_fd_sc_hd__decap_3
XFILLER_15_266 VGND VGND VPWR VPWR sky130_fd_sc_hd__fill_1
XFILLER_70_361 VGND VGND VPWR VPWR sky130_fd_sc_hd__decap_3
XFILLER_15_299 VGND VGND VPWR VPWR sky130_fd_sc_hd__fill_1
XFILLER_30_214 VGND VGND VPWR VPWR sky130_fd_sc_hd__fill_1
XFILLER_30_247 VGND VGND VPWR VPWR sky130_fd_sc_hd__decap_3
Xwire374 wire374/A VGND VGND VPWR VPWR wire374/X sky130_fd_sc_hd__clkbuf_4
X_3280_ _3965_/A _6467_/A1 _4014_/S VGND VGND VPWR VPWR _3280_/X sky130_fd_sc_hd__mux2_2
XFILLER_17_3 VGND VGND VPWR VPWR sky130_fd_sc_hd__fill_2
XFILLER_65_111 VGND VGND VPWR VPWR sky130_fd_sc_hd__fill_1
XFILLER_38_358 VGND VGND VPWR VPWR sky130_fd_sc_hd__decap_3
XFILLER_53_317 VGND VGND VPWR VPWR sky130_fd_sc_hd__decap_3
X_5921_ _5942_/S VGND VGND VPWR VPWR _5921_/Y sky130_fd_sc_hd__inv_2
XTAP_TAPCELL_ROW_36_504 VGND VPWR sky130_fd_sc_hd__tapvpwrvgnd_1
XFILLER_0_95 VGND VGND VPWR VPWR sky130_fd_sc_hd__fill_2
XFILLER_46_391 VGND VGND VPWR VPWR sky130_fd_sc_hd__decap_3
X_5852_ _5852_/A _5852_/B _5852_/C VGND VGND VPWR VPWR _6496_/C sky130_fd_sc_hd__and3_2
XFILLER_61_361 VGND VGND VPWR VPWR sky130_fd_sc_hd__decap_3
X_5783_ _5734_/S _6051_/A _5723_/B _5723_/C _5748_/A VGND VGND VPWR VPWR _5816_/A
+ sky130_fd_sc_hd__o2111ai_2
X_4803_ _4923_/A _6460_/A2 _6460_/A1 _6460_/A3 wire423/X wire372/X VGND VGND VPWR
+ VPWR _4803_/X sky130_fd_sc_hd__mux4_2
X_4734_ _4734_/A _6247_/A VGND VGND VPWR VPWR _4753_/B sky130_fd_sc_hd__nand2_2
X_4665_ _4665_/A _4665_/B _4665_/C VGND VGND VPWR VPWR _4666_/A sky130_fd_sc_hd__or3_2
X_6404_ _6401_/Y _6403_/Y _6404_/S VGND VGND VPWR VPWR _6404_/X sky130_fd_sc_hd__mux2_2
X_4596_ _6474_/A _4840_/B VGND VGND VPWR VPWR _4761_/A sky130_fd_sc_hd__nor2_2
X_3616_ _3691_/A _3691_/B VGND VGND VPWR VPWR _3734_/A sky130_fd_sc_hd__xor2_2
X_6335_ _5637_/A _6332_/Y _6334_/X _5712_/A VGND VGND VPWR VPWR _6335_/Y sky130_fd_sc_hd__a22oi_2
X_3547_ _3612_/B _3559_/C _3547_/C _3679_/D VGND VGND VPWR VPWR _3551_/A sky130_fd_sc_hd__and4b_2
X_6266_ _6275_/D _6274_/A _6011_/D _6056_/B VGND VGND VPWR VPWR _6266_/X sky130_fd_sc_hd__or4bb_2
X_3478_ _3479_/A _3479_/C _3489_/A VGND VGND VPWR VPWR _3480_/B sky130_fd_sc_hd__a21oi_2
X_6197_ _6177_/Y _6178_/X _6182_/X _6196_/X VGND VGND VPWR VPWR _6198_/C sky130_fd_sc_hd__o211a_2
X_5217_ _4842_/B _4558_/Y _5216_/Y _6473_/S VGND VGND VPWR VPWR _5217_/X sky130_fd_sc_hd__a22o_2
XFILLER_29_325 VGND VGND VPWR VPWR sky130_fd_sc_hd__decap_3
XFILLER_56_122 VGND VGND VPWR VPWR sky130_fd_sc_hd__decap_3
X_5148_ _5191_/B _5290_/B VGND VGND VPWR VPWR _5148_/Y sky130_fd_sc_hd__nand2_2
XFILLER_28_69 VGND VGND VPWR VPWR sky130_fd_sc_hd__fill_2
XFILLER_29_358 VGND VGND VPWR VPWR sky130_fd_sc_hd__decap_3
XFILLER_56_144 VGND VGND VPWR VPWR sky130_fd_sc_hd__decap_3
X_5079_ _5054_/A _6298_/A _5123_/C VGND VGND VPWR VPWR _5079_/Y sky130_fd_sc_hd__a21oi_2
XFILLER_44_339 VGND VGND VPWR VPWR sky130_fd_sc_hd__decap_3
XFILLER_56_188 VGND VGND VPWR VPWR sky130_fd_sc_hd__fill_2
XFILLER_71_103 VGND VGND VPWR VPWR sky130_fd_sc_hd__fill_2
XFILLER_37_391 VGND VGND VPWR VPWR sky130_fd_sc_hd__fill_1
XFILLER_71_158 VGND VGND VPWR VPWR sky130_fd_sc_hd__fill_1
XFILLER_44_68 VGND VGND VPWR VPWR sky130_fd_sc_hd__decap_3
XTAP_TAPCELL_ROW_70_805 VGND VPWR sky130_fd_sc_hd__tapvpwrvgnd_1
XFILLER_79_214 VGND VGND VPWR VPWR sky130_fd_sc_hd__decap_3
XTAP_TAPCELL_ROW_7_240 VGND VPWR sky130_fd_sc_hd__tapvpwrvgnd_1
XFILLER_79_247 VGND VGND VPWR VPWR sky130_fd_sc_hd__decap_3
XFILLER_79_225 VGND VGND VPWR VPWR sky130_fd_sc_hd__decap_3
XFILLER_50_309 VGND VGND VPWR VPWR sky130_fd_sc_hd__decap_3
XFILLER_70_180 VGND VGND VPWR VPWR sky130_fd_sc_hd__decap_3
XTAP_TAPCELL_ROW_41_551 VGND VPWR sky130_fd_sc_hd__tapvpwrvgnd_1
XTAP_TAPCELL_ROW_13_297 VGND VPWR sky130_fd_sc_hd__tapvpwrvgnd_1
X_4450_ _6022_/C _4450_/B VGND VGND VPWR VPWR _4450_/Y sky130_fd_sc_hd__nor2_2
X_4381_ _4286_/A _3647_/Y _4380_/Y _4840_/B VGND VGND VPWR VPWR _4384_/B sky130_fd_sc_hd__a211o_2
X_3401_ _4154_/B _3400_/Y _3703_/A VGND VGND VPWR VPWR _3401_/Y sky130_fd_sc_hd__o21ai_2
X_6120_ _6120_/A _6120_/B VGND VGND VPWR VPWR _6120_/X sky130_fd_sc_hd__or2_2
X_3332_ _3612_/A _4086_/A _3664_/A _3754_/A _3652_/S _3758_/S VGND VGND VPWR VPWR
+ _3332_/X sky130_fd_sc_hd__mux4_2
X_6051_ _6051_/A _6051_/B VGND VGND VPWR VPWR _6051_/Y sky130_fd_sc_hd__xnor2_2
X_3263_ _3255_/X _3261_/X _3486_/B VGND VGND VPWR VPWR _3263_/X sky130_fd_sc_hd__mux2_2
X_5002_ _5002_/A VGND VGND VPWR VPWR _5004_/A sky130_fd_sc_hd__inv_2
XFILLER_26_317 VGND VGND VPWR VPWR sky130_fd_sc_hd__decap_3
XFILLER_81_401 VGND VGND VPWR VPWR sky130_fd_sc_hd__fill_1
XFILLER_53_169 VGND VGND VPWR VPWR sky130_fd_sc_hd__fill_1
X_5904_ _5381_/S _3985_/X _5904_/A3 _4885_/X _4685_/B VGND VGND VPWR VPWR _5904_/X
+ sky130_fd_sc_hd__a32o_2
X_5835_ _4604_/X _4885_/X _5834_/X _6486_/C _5228_/X VGND VGND VPWR VPWR _5835_/X
+ sky130_fd_sc_hd__a221o_2
X_5766_ _5175_/X _5739_/Y _5765_/X _4840_/Y VGND VGND VPWR VPWR _5766_/Y sky130_fd_sc_hd__a22oi_2
X_5697_ wire263/X _5938_/A1 _5697_/S VGND VGND VPWR VPWR _5697_/X sky130_fd_sc_hd__mux2_2
X_4717_ _4797_/A _4694_/A _4713_/Y _4715_/X _4716_/Y VGND VGND VPWR VPWR _4717_/X
+ sky130_fd_sc_hd__o221a_2
X_4648_ _6060_/D _6243_/A VGND VGND VPWR VPWR _4648_/X sky130_fd_sc_hd__and2b_2
X_4579_ _6193_/S _6194_/A VGND VGND VPWR VPWR _4579_/Y sky130_fd_sc_hd__nor2_2
X_6318_ _6314_/Y _6317_/X _6318_/S VGND VGND VPWR VPWR _6343_/A sky130_fd_sc_hd__mux2_2
X_6249_ _6242_/X _6243_/X _6245_/X _6248_/X VGND VGND VPWR VPWR _6249_/X sky130_fd_sc_hd__o2bb2a_2
XFILLER_39_68 VGND VGND VPWR VPWR sky130_fd_sc_hd__fill_1
XFILLER_76_217 VGND VGND VPWR VPWR sky130_fd_sc_hd__decap_3
XFILLER_29_133 VGND VGND VPWR VPWR sky130_fd_sc_hd__fill_2
XFILLER_17_328 VGND VGND VPWR VPWR sky130_fd_sc_hd__fill_1
XTAP_TAPCELL_ROW_55_676 VGND VPWR sky130_fd_sc_hd__tapvpwrvgnd_1
XFILLER_40_342 VGND VGND VPWR VPWR sky130_fd_sc_hd__decap_3
XFILLER_52_191 VGND VGND VPWR VPWR sky130_fd_sc_hd__decap_3
XFILLER_40_386 VGND VGND VPWR VPWR sky130_fd_sc_hd__decap_3
XFILLER_71_88 VGND VGND VPWR VPWR sky130_fd_sc_hd__fill_1
XTAP_TAPCELL_ROW_10_267 VGND VPWR sky130_fd_sc_hd__tapvpwrvgnd_1
XFILLER_4_243 VGND VGND VPWR VPWR sky130_fd_sc_hd__fill_1
XFILLER_20_81 VGND VGND VPWR VPWR sky130_fd_sc_hd__decap_3
XFILLER_67_206 VGND VGND VPWR VPWR sky130_fd_sc_hd__decap_3
XFILLER_48_431 VGND VGND VPWR VPWR sky130_fd_sc_hd__fill_2
XFILLER_48_442 VGND VGND VPWR VPWR sky130_fd_sc_hd__decap_3
XFILLER_29_90 VGND VGND VPWR VPWR sky130_fd_sc_hd__decap_3
XFILLER_35_136 VGND VGND VPWR VPWR sky130_fd_sc_hd__decap_3
XFILLER_35_169 VGND VGND VPWR VPWR sky130_fd_sc_hd__fill_2
XFILLER_50_106 VGND VGND VPWR VPWR sky130_fd_sc_hd__decap_3
X_3950_ _4027_/A _3950_/B VGND VGND VPWR VPWR _3950_/X sky130_fd_sc_hd__or2_2
XTAP_TAPCELL_ROW_18_345 VGND VPWR sky130_fd_sc_hd__tapvpwrvgnd_1
XFILLER_50_139 VGND VGND VPWR VPWR sky130_fd_sc_hd__fill_1
X_3881_ _3384_/X _3387_/X _3439_/X _3482_/X _3750_/A _3881_/S1 VGND VGND VPWR VPWR
+ _3881_/X sky130_fd_sc_hd__mux4_2
X_5620_ _5706_/A1 _4333_/Y _5619_/X VGND VGND VPWR VPWR _5620_/Y sky130_fd_sc_hd__a21oi_2
X_5551_ _4236_/X _5485_/B _5618_/A _5548_/X _5550_/Y VGND VGND VPWR VPWR _5551_/X
+ sky130_fd_sc_hd__a221o_2
X_4502_ _3784_/B _3797_/X _4502_/S VGND VGND VPWR VPWR _4502_/X sky130_fd_sc_hd__mux2_2
X_5482_ _5325_/X _5481_/X _5616_/A VGND VGND VPWR VPWR _5482_/X sky130_fd_sc_hd__mux2_2
X_4433_ _6176_/A _6174_/A VGND VGND VPWR VPWR _6178_/A sky130_fd_sc_hd__nor2_2
XFILLER_6_83 VGND VGND VPWR VPWR sky130_fd_sc_hd__fill_1
Xfanout506 input47/X VGND VGND VPWR VPWR _5388_/S sky130_fd_sc_hd__clkdlybuf4s25_1
X_4364_ _4364_/A _4544_/A VGND VGND VPWR VPWR _4364_/Y sky130_fd_sc_hd__nand2_2
X_6103_ _6106_/A _6101_/Y _6102_/X VGND VGND VPWR VPWR _6103_/Y sky130_fd_sc_hd__o21ai_2
Xfanout517 _5225_/S VGND VGND VPWR VPWR _6391_/C sky130_fd_sc_hd__clkdlybuf4s25_1
Xfanout528 _6109_/B VGND VGND VPWR VPWR _3667_/B sky130_fd_sc_hd__clkdlybuf4s25_1
Xfanout539 input34/X VGND VGND VPWR VPWR _4942_/A sky130_fd_sc_hd__clkdlybuf4s25_1
X_4295_ _4295_/A1 _4282_/Y _4294_/X VGND VGND VPWR VPWR _4295_/Y sky130_fd_sc_hd__o21ai_2
X_3315_ _4546_/A _6457_/A2 _6460_/A3 _6460_/A2 _6461_/S0 _3948_/S1 VGND VGND VPWR
+ VPWR _3315_/X sky130_fd_sc_hd__mux4_2
XFILLER_58_206 VGND VGND VPWR VPWR sky130_fd_sc_hd__decap_3
X_6034_ _6042_/A _6401_/A VGND VGND VPWR VPWR _6035_/A sky130_fd_sc_hd__and2_2
X_3246_ _3349_/A VGND VGND VPWR VPWR _3367_/A sky130_fd_sc_hd__inv_2
XFILLER_14_309 VGND VGND VPWR VPWR sky130_fd_sc_hd__decap_3
XTAP_TAPCELL_ROW_80_900 VGND VPWR sky130_fd_sc_hd__tapvpwrvgnd_1
XTAP_TAPCELL_ROW_52_646 VGND VPWR sky130_fd_sc_hd__tapvpwrvgnd_1
XFILLER_10_515 VGND VGND VPWR VPWR sky130_fd_sc_hd__fill_1
XFILLER_22_386 VGND VGND VPWR VPWR sky130_fd_sc_hd__decap_3
X_5818_ _5885_/A _5818_/B _5818_/C VGND VGND VPWR VPWR _5818_/Y sky130_fd_sc_hd__nor3_2
X_5749_ _6050_/A _6033_/B VGND VGND VPWR VPWR _5750_/B sky130_fd_sc_hd__and2b_2
XFILLER_64_209 VGND VGND VPWR VPWR sky130_fd_sc_hd__decap_3
XFILLER_57_272 VGND VGND VPWR VPWR sky130_fd_sc_hd__decap_3
XTAP_TAPCELL_ROW_68_790 VGND VPWR sky130_fd_sc_hd__tapvpwrvgnd_1
XFILLER_17_169 VGND VGND VPWR VPWR sky130_fd_sc_hd__decap_3
XFILLER_72_264 VGND VGND VPWR VPWR sky130_fd_sc_hd__decap_3
XFILLER_72_253 VGND VGND VPWR VPWR sky130_fd_sc_hd__decap_3
XFILLER_32_106 VGND VGND VPWR VPWR sky130_fd_sc_hd__fill_2
XTAP_TAPCELL_ROW_15_315 VGND VPWR sky130_fd_sc_hd__tapvpwrvgnd_1
XFILLER_32_139 VGND VGND VPWR VPWR sky130_fd_sc_hd__fill_1
XFILLER_15_70 VGND VGND VPWR VPWR sky130_fd_sc_hd__fill_1
XFILLER_15_92 VGND VGND VPWR VPWR sky130_fd_sc_hd__decap_3
XFILLER_9_324 VGND VGND VPWR VPWR sky130_fd_sc_hd__decap_3
X_4080_ _3686_/B _3686_/C _3686_/D _4079_/X _6120_/B VGND VGND VPWR VPWR _4120_/B
+ sky130_fd_sc_hd__o311a_2
XFILLER_48_283 VGND VGND VPWR VPWR sky130_fd_sc_hd__decap_3
XFILLER_63_264 VGND VGND VPWR VPWR sky130_fd_sc_hd__decap_3
X_4982_ _4982_/A _5042_/A VGND VGND VPWR VPWR _4982_/X sky130_fd_sc_hd__xor2_2
X_3933_ _3524_/B _3932_/Y _3949_/S VGND VGND VPWR VPWR _3933_/X sky130_fd_sc_hd__mux2_2
XFILLER_31_161 VGND VGND VPWR VPWR sky130_fd_sc_hd__decap_3
X_3864_ _6130_/S _3864_/B VGND VGND VPWR VPWR _3864_/Y sky130_fd_sc_hd__nor2_2
X_5603_ _5628_/C _5603_/B VGND VGND VPWR VPWR _5603_/Y sky130_fd_sc_hd__xnor2_2
X_3795_ _4462_/S _3793_/X _3794_/X VGND VGND VPWR VPWR _4503_/A sky130_fd_sc_hd__a21o_2
X_5534_ _5534_/A _5534_/B _5534_/C _5534_/D VGND VGND VPWR VPWR _5534_/X sky130_fd_sc_hd__or4_2
X_5465_ _5465_/A _5465_/B _5465_/C _5464_/X VGND VGND VPWR VPWR _5469_/A sky130_fd_sc_hd__or4b_2
X_4416_ _4416_/A _4416_/B VGND VGND VPWR VPWR _4416_/Y sky130_fd_sc_hd__nor2_2
X_5396_ _5396_/A VGND VGND VPWR VPWR _5396_/X sky130_fd_sc_hd__clkbuf_1
Xfanout336 _6053_/A VGND VGND VPWR VPWR _6077_/A sky130_fd_sc_hd__clkdlybuf4s25_1
X_4347_ _4430_/A _4430_/B VGND VGND VPWR VPWR _4394_/A sky130_fd_sc_hd__nor2_2
XFILLER_59_515 VGND VGND VPWR VPWR sky130_fd_sc_hd__fill_1
Xfanout358 input90/X VGND VGND VPWR VPWR _4679_/B sky130_fd_sc_hd__clkdlybuf4s25_1
Xfanout369 _6173_/A VGND VGND VPWR VPWR _4355_/B sky130_fd_sc_hd__clkdlybuf4s25_1
X_4278_ _4052_/X _4099_/X _4220_/X _4277_/X _4674_/S _4191_/X VGND VGND VPWR VPWR
+ _4279_/B sky130_fd_sc_hd__mux4_2
X_6017_ _6126_/A _6126_/B _6062_/C VGND VGND VPWR VPWR _6151_/D sky130_fd_sc_hd__and3_2
X_3229_ _6113_/B VGND VGND VPWR VPWR _3559_/D sky130_fd_sc_hd__inv_2
XFILLER_54_253 VGND VGND VPWR VPWR sky130_fd_sc_hd__decap_3
XTAP_TAPCELL_ROW_65_760 VGND VPWR sky130_fd_sc_hd__tapvpwrvgnd_1
XFILLER_14_106 VGND VGND VPWR VPWR sky130_fd_sc_hd__fill_1
XFILLER_14_128 VGND VGND VPWR VPWR sky130_fd_sc_hd__decap_3
XTAP_TAPCELL_ROW_20_362 VGND VPWR sky130_fd_sc_hd__tapvpwrvgnd_1
XFILLER_37_209 VGND VGND VPWR VPWR sky130_fd_sc_hd__decap_3
XFILLER_45_231 VGND VGND VPWR VPWR sky130_fd_sc_hd__decap_3
XFILLER_45_253 VGND VGND VPWR VPWR sky130_fd_sc_hd__decap_3
XFILLER_33_404 VGND VGND VPWR VPWR sky130_fd_sc_hd__decap_3
XFILLER_60_245 VGND VGND VPWR VPWR sky130_fd_sc_hd__decap_3
XFILLER_20_109 VGND VGND VPWR VPWR sky130_fd_sc_hd__decap_3
XFILLER_60_278 VGND VGND VPWR VPWR sky130_fd_sc_hd__decap_3
XFILLER_13_172 VGND VGND VPWR VPWR sky130_fd_sc_hd__decap_3
X_3580_ _3703_/A _3947_/A VGND VGND VPWR VPWR _3580_/Y sky130_fd_sc_hd__nor2_2
XFILLER_9_198 VGND VGND VPWR VPWR sky130_fd_sc_hd__fill_1
X_5250_ _4761_/X _5241_/X _5243_/X _5249_/X VGND VGND VPWR VPWR _5250_/X sky130_fd_sc_hd__a211o_2
XFILLER_47_3 VGND VGND VPWR VPWR sky130_fd_sc_hd__decap_3
X_4201_ _4199_/X _4200_/X _4230_/A VGND VGND VPWR VPWR _4201_/X sky130_fd_sc_hd__mux2_2
X_5181_ _4797_/A _5160_/B _5178_/Y _5179_/X _5180_/Y VGND VGND VPWR VPWR _5181_/X
+ sky130_fd_sc_hd__o221a_2
X_4132_ _4132_/A VGND VGND VPWR VPWR _4513_/B sky130_fd_sc_hd__clkbuf_1
XFILLER_28_209 VGND VGND VPWR VPWR sky130_fd_sc_hd__decap_3
X_4063_ _3710_/A _4059_/X _4062_/X _3976_/X VGND VGND VPWR VPWR _4064_/B sky130_fd_sc_hd__a22o_2
XFILLER_36_242 VGND VGND VPWR VPWR sky130_fd_sc_hd__decap_3
XFILLER_36_253 VGND VGND VPWR VPWR sky130_fd_sc_hd__decap_3
XFILLER_36_275 VGND VGND VPWR VPWR sky130_fd_sc_hd__decap_3
XFILLER_51_223 VGND VGND VPWR VPWR sky130_fd_sc_hd__fill_1
XFILLER_51_234 VGND VGND VPWR VPWR sky130_fd_sc_hd__decap_3
X_4965_ _4962_/A _4962_/B _4789_/B VGND VGND VPWR VPWR _5535_/C sky130_fd_sc_hd__a21bo_2
XTAP_TAPCELL_ROW_62_741 VGND VPWR sky130_fd_sc_hd__tapvpwrvgnd_1
X_3916_ _3817_/C _3914_/X _3915_/Y VGND VGND VPWR VPWR _3917_/A sky130_fd_sc_hd__a21o_2
X_4896_ _4946_/B _5429_/A VGND VGND VPWR VPWR _4975_/D sky130_fd_sc_hd__nor2_2
XTAP_TAPCELL_ROW_34_487 VGND VPWR sky130_fd_sc_hd__tapvpwrvgnd_1
X_3847_ _3432_/A _6129_/A _3846_/X VGND VGND VPWR VPWR _3847_/X sky130_fd_sc_hd__a21o_2
X_3778_ _3928_/A _3928_/B VGND VGND VPWR VPWR _3778_/Y sky130_fd_sc_hd__xnor2_2
X_5517_ _5530_/A _5290_/B _5513_/X _5515_/X _5516_/X VGND VGND VPWR VPWR _5517_/X
+ sky130_fd_sc_hd__a221o_2
X_6497_ _6497_/A _6497_/B _6497_/C VGND VGND VPWR VPWR _6498_/B sky130_fd_sc_hd__and3_2
X_5448_ _6485_/A _5458_/A _5447_/X VGND VGND VPWR VPWR _5448_/X sky130_fd_sc_hd__o21a_2
X_5379_ _5388_/S _5352_/A _6358_/A _5316_/A wire423/A wire374/X VGND VGND VPWR VPWR
+ _5379_/X sky130_fd_sc_hd__mux4_2
XFILLER_47_35 VGND VGND VPWR VPWR sky130_fd_sc_hd__fill_1
XPHY_EDGE_ROW_29_Right_29 VGND VGND VPWR VPWR sky130_fd_sc_hd__decap_3
XFILLER_74_348 VGND VGND VPWR VPWR sky130_fd_sc_hd__decap_3
XFILLER_27_231 VGND VGND VPWR VPWR sky130_fd_sc_hd__decap_3
XFILLER_42_212 VGND VGND VPWR VPWR sky130_fd_sc_hd__decap_3
XFILLER_30_418 VGND VGND VPWR VPWR sky130_fd_sc_hd__fill_2
XPHY_EDGE_ROW_38_Right_38 VGND VGND VPWR VPWR sky130_fd_sc_hd__decap_3
XFILLER_6_113 VGND VGND VPWR VPWR sky130_fd_sc_hd__fill_1
XFILLER_6_168 VGND VGND VPWR VPWR sky130_fd_sc_hd__fill_1
XFILLER_2_385 VGND VGND VPWR VPWR sky130_fd_sc_hd__fill_1
XPHY_EDGE_ROW_47_Right_47 VGND VGND VPWR VPWR sky130_fd_sc_hd__decap_3
XFILLER_77_153 VGND VGND VPWR VPWR sky130_fd_sc_hd__fill_1
XTAP_TAPCELL_ROW_76_866 VGND VPWR sky130_fd_sc_hd__tapvpwrvgnd_1
XFILLER_65_359 VGND VGND VPWR VPWR sky130_fd_sc_hd__decap_3
XFILLER_33_223 VGND VGND VPWR VPWR sky130_fd_sc_hd__fill_1
XFILLER_33_234 VGND VGND VPWR VPWR sky130_fd_sc_hd__decap_3
XFILLER_33_267 VGND VGND VPWR VPWR sky130_fd_sc_hd__decap_3
X_4750_ _6244_/A VGND VGND VPWR VPWR _4751_/B sky130_fd_sc_hd__inv_2
XPHY_EDGE_ROW_56_Right_56 VGND VGND VPWR VPWR sky130_fd_sc_hd__decap_3
X_4681_ _4681_/A0 _4681_/A1 _4695_/A VGND VGND VPWR VPWR _4681_/X sky130_fd_sc_hd__mux2_2
X_3701_ _3696_/X _3700_/X _3803_/S VGND VGND VPWR VPWR _3701_/X sky130_fd_sc_hd__mux2_2
XTAP_TAPCELL_ROW_31_457 VGND VPWR sky130_fd_sc_hd__tapvpwrvgnd_1
X_6420_ _6420_/A _6479_/A _6420_/C _6419_/X VGND VGND VPWR VPWR _6420_/X sky130_fd_sc_hd__or4b_2
X_3632_ _5096_/A _5281_/A3 _5338_/A3 _6449_/A3 _6450_/S0 _3648_/S1 VGND VGND VPWR
+ VPWR _3632_/X sky130_fd_sc_hd__mux4_2
X_6351_ _5658_/B _6336_/Y _6343_/Y _6350_/X VGND VGND VPWR VPWR _6354_/C sky130_fd_sc_hd__o31a_2
X_5302_ _5499_/A _5302_/B _5359_/C _5302_/D VGND VGND VPWR VPWR _5319_/A sky130_fd_sc_hd__and4b_2
X_3563_ _3563_/A VGND VGND VPWR VPWR _3563_/X sky130_fd_sc_hd__clkbuf_1
X_6282_ _6084_/X _6239_/X _6249_/X _6281_/X VGND VGND VPWR VPWR _6282_/X sky130_fd_sc_hd__a31o_2
X_3494_ _3679_/C VGND VGND VPWR VPWR _6102_/B sky130_fd_sc_hd__clkbuf_1
X_5233_ _6391_/D _6392_/B VGND VGND VPWR VPWR _5274_/D sky130_fd_sc_hd__xnor2_2
XPHY_EDGE_ROW_65_Right_65 VGND VGND VPWR VPWR sky130_fd_sc_hd__decap_3
X_5164_ _5116_/A _5116_/B _5144_/B VGND VGND VPWR VPWR _5167_/C sky130_fd_sc_hd__a21o_2
X_4115_ _3232_/X _3580_/Y _5228_/A _3883_/A _4114_/Y VGND VGND VPWR VPWR _4115_/X
+ sky130_fd_sc_hd__a221o_2
XFILLER_56_315 VGND VGND VPWR VPWR sky130_fd_sc_hd__decap_3
X_5095_ _5038_/A _5092_/Y _5093_/Y _4606_/A _5057_/S VGND VGND VPWR VPWR _5095_/X
+ sky130_fd_sc_hd__o221a_2
XFILLER_68_197 VGND VGND VPWR VPWR sky130_fd_sc_hd__decap_3
X_4046_ _4046_/A _4046_/B _4046_/C VGND VGND VPWR VPWR _4048_/A sky130_fd_sc_hd__or3_2
XFILLER_24_212 VGND VGND VPWR VPWR sky130_fd_sc_hd__decap_3
XFILLER_64_381 VGND VGND VPWR VPWR sky130_fd_sc_hd__decap_3
XFILLER_24_256 VGND VGND VPWR VPWR sky130_fd_sc_hd__decap_3
XFILLER_24_278 VGND VGND VPWR VPWR sky130_fd_sc_hd__decap_3
X_5997_ _4312_/X _4545_/Y _4653_/Y _4691_/X _4570_/X VGND VGND VPWR VPWR _5998_/D
+ sky130_fd_sc_hd__a2111o_2
XPHY_EDGE_ROW_74_Right_74 VGND VGND VPWR VPWR sky130_fd_sc_hd__decap_3
X_4948_ _6077_/B _4987_/B VGND VGND VPWR VPWR _4948_/Y sky130_fd_sc_hd__nand2_2
X_4879_ _4193_/B _4878_/X _4879_/S VGND VGND VPWR VPWR _4879_/X sky130_fd_sc_hd__mux2_2
XFILLER_47_337 VGND VGND VPWR VPWR sky130_fd_sc_hd__decap_3
XFILLER_59_175 VGND VGND VPWR VPWR sky130_fd_sc_hd__decap_3
XTAP_TAPCELL_ROW_73_836 VGND VPWR sky130_fd_sc_hd__tapvpwrvgnd_1
XFILLER_62_318 VGND VGND VPWR VPWR sky130_fd_sc_hd__decap_3
XFILLER_15_234 VGND VGND VPWR VPWR sky130_fd_sc_hd__decap_3
XFILLER_55_381 VGND VGND VPWR VPWR sky130_fd_sc_hd__decap_3
XTAP_TAPCELL_ROW_2_193 VGND VPWR sky130_fd_sc_hd__tapvpwrvgnd_1
XFILLER_70_373 VGND VGND VPWR VPWR sky130_fd_sc_hd__decap_3
Xload_slew347 _3654_/S1 VGND VGND VPWR VPWR _3653_/S sky130_fd_sc_hd__buf_2
XFILLER_38_304 VGND VGND VPWR VPWR sky130_fd_sc_hd__decap_3
XFILLER_38_315 VGND VGND VPWR VPWR sky130_fd_sc_hd__decap_3
XFILLER_65_156 VGND VGND VPWR VPWR sky130_fd_sc_hd__decap_3
XFILLER_53_329 VGND VGND VPWR VPWR sky130_fd_sc_hd__decap_3
X_5920_ _6479_/B _5957_/A VGND VGND VPWR VPWR _5942_/S sky130_fd_sc_hd__nand2_2
XTAP_TAPCELL_ROW_36_505 VGND VPWR sky130_fd_sc_hd__tapvpwrvgnd_1
XFILLER_65_178 VGND VGND VPWR VPWR sky130_fd_sc_hd__decap_3
XFILLER_0_85 VGND VGND VPWR VPWR sky130_fd_sc_hd__fill_2
X_5851_ _5851_/A _5851_/B VGND VGND VPWR VPWR _5852_/C sky130_fd_sc_hd__and2_2
XFILLER_61_340 VGND VGND VPWR VPWR sky130_fd_sc_hd__decap_3
X_5782_ _5847_/A _6400_/B VGND VGND VPWR VPWR _6404_/S sky130_fd_sc_hd__nor2_2
X_4802_ _3760_/A _6454_/A _5740_/A _4799_/X _5061_/A VGND VGND VPWR VPWR _4802_/X
+ sky130_fd_sc_hd__o311a_2
XTAP_TAPCELL_ROW_44_571 VGND VPWR sky130_fd_sc_hd__tapvpwrvgnd_1
XFILLER_61_373 VGND VGND VPWR VPWR sky130_fd_sc_hd__decap_3
X_4733_ _4783_/B _4733_/B VGND VGND VPWR VPWR _4733_/Y sky130_fd_sc_hd__nor2_2
XFILLER_9_72 VGND VGND VPWR VPWR sky130_fd_sc_hd__fill_2
X_6403_ _6050_/A _6401_/Y _6402_/Y VGND VGND VPWR VPWR _6403_/Y sky130_fd_sc_hd__a21oi_2
X_4664_ _4648_/X _4768_/B _4661_/X _4662_/X _4663_/X VGND VGND VPWR VPWR _4665_/C
+ sky130_fd_sc_hd__a2111o_2
X_4595_ _3880_/X _4594_/X _5084_/S VGND VGND VPWR VPWR _4595_/X sky130_fd_sc_hd__mux2_2
X_3615_ _3615_/A _3615_/B _3615_/C VGND VGND VPWR VPWR _3691_/B sky130_fd_sc_hd__and3_2
X_6334_ _6333_/A _6326_/C _6333_/Y _6317_/S VGND VGND VPWR VPWR _6334_/X sky130_fd_sc_hd__a2bb2o_2
X_3546_ _6090_/A _3600_/B VGND VGND VPWR VPWR _3608_/C sky130_fd_sc_hd__xor2_2
X_6265_ _6265_/A _6265_/B VGND VGND VPWR VPWR _6275_/D sky130_fd_sc_hd__or2_2
X_5216_ _5216_/A _5216_/B VGND VGND VPWR VPWR _5216_/Y sky130_fd_sc_hd__nand2_2
X_3477_ _6098_/A _3554_/B _3408_/Y _3372_/A _3412_/Y VGND VGND VPWR VPWR _3479_/C
+ sky130_fd_sc_hd__a221o_2
X_6196_ _6187_/X _6188_/X _6195_/X VGND VGND VPWR VPWR _6196_/X sky130_fd_sc_hd__o21a_2
X_5147_ _4940_/A _4941_/A _5188_/S VGND VGND VPWR VPWR _5147_/X sky130_fd_sc_hd__mux2_2
X_5078_ _5123_/C _5078_/B VGND VGND VPWR VPWR _5078_/X sky130_fd_sc_hd__and2_2
XFILLER_44_307 VGND VGND VPWR VPWR sky130_fd_sc_hd__fill_1
XFILLER_44_318 VGND VGND VPWR VPWR sky130_fd_sc_hd__decap_3
X_4029_ _3594_/X _4017_/X _4024_/X _4339_/A _4028_/X VGND VGND VPWR VPWR _4029_/X
+ sky130_fd_sc_hd__a221o_2
XTAP_TAPCELL_ROW_70_806 VGND VPWR sky130_fd_sc_hd__tapvpwrvgnd_1
XFILLER_20_281 VGND VGND VPWR VPWR sky130_fd_sc_hd__decap_3
XFILLER_69_66 VGND VGND VPWR VPWR sky130_fd_sc_hd__fill_2
XTAP_TAPCELL_ROW_7_241 VGND VPWR sky130_fd_sc_hd__tapvpwrvgnd_1
XFILLER_79_259 VGND VGND VPWR VPWR sky130_fd_sc_hd__decap_3
XFILLER_47_134 VGND VGND VPWR VPWR sky130_fd_sc_hd__decap_3
XFILLER_47_167 VGND VGND VPWR VPWR sky130_fd_sc_hd__fill_1
XFILLER_47_178 VGND VGND VPWR VPWR sky130_fd_sc_hd__decap_3
XFILLER_28_392 VGND VGND VPWR VPWR sky130_fd_sc_hd__decap_3
XFILLER_62_148 VGND VGND VPWR VPWR sky130_fd_sc_hd__decap_3
XFILLER_62_126 VGND VGND VPWR VPWR sky130_fd_sc_hd__decap_3
XFILLER_43_340 VGND VGND VPWR VPWR sky130_fd_sc_hd__decap_3
XFILLER_43_373 VGND VGND VPWR VPWR sky130_fd_sc_hd__decap_3
XFILLER_34_91 VGND VGND VPWR VPWR sky130_fd_sc_hd__fill_2
XFILLER_70_192 VGND VGND VPWR VPWR sky130_fd_sc_hd__decap_3
XTAP_TAPCELL_ROW_41_552 VGND VPWR sky130_fd_sc_hd__tapvpwrvgnd_1
XFILLER_11_281 VGND VGND VPWR VPWR sky130_fd_sc_hd__decap_3
XTAP_TAPCELL_ROW_13_298 VGND VPWR sky130_fd_sc_hd__tapvpwrvgnd_1
X_4380_ _5216_/A _4380_/B VGND VGND VPWR VPWR _4380_/Y sky130_fd_sc_hd__nor2_2
X_3400_ _4465_/S _3392_/B _3396_/X VGND VGND VPWR VPWR _3400_/Y sky130_fd_sc_hd__o21ai_2
X_3331_ _3357_/B _3464_/A _3556_/A _3548_/B _3262_/A _3520_/S VGND VGND VPWR VPWR
+ _3331_/X sky130_fd_sc_hd__mux4_2
X_6050_ _6050_/A _6050_/B _6050_/C VGND VGND VPWR VPWR _6050_/X sky130_fd_sc_hd__and3_2
X_3262_ _3262_/A _3264_/A VGND VGND VPWR VPWR _3486_/B sky130_fd_sc_hd__xor2_2
X_5001_ _5573_/A _5120_/C VGND VGND VPWR VPWR _5001_/Y sky130_fd_sc_hd__xnor2_2
XFILLER_66_421 VGND VGND VPWR VPWR sky130_fd_sc_hd__fill_1
XFILLER_19_381 VGND VGND VPWR VPWR sky130_fd_sc_hd__decap_3
X_5903_ _3979_/X _4677_/X _5326_/X _5902_/X _5948_/S1 _4937_/A VGND VGND VPWR VPWR
+ _5903_/X sky130_fd_sc_hd__mux4_2
XFILLER_34_362 VGND VGND VPWR VPWR sky130_fd_sc_hd__fill_2
XFILLER_34_373 VGND VGND VPWR VPWR sky130_fd_sc_hd__decap_3
X_5834_ _6400_/A _5970_/B wire261/X _5874_/C _5833_/X VGND VGND VPWR VPWR _5834_/X
+ sky130_fd_sc_hd__a221o_2
XPHY_EDGE_ROW_46_Left_129 VGND VGND VPWR VPWR sky130_fd_sc_hd__decap_3
XFILLER_61_181 VGND VGND VPWR VPWR sky130_fd_sc_hd__decap_3
X_5765_ _5325_/X _5481_/X _5615_/X _5764_/X _5947_/S _5239_/X VGND VGND VPWR VPWR
+ _5765_/X sky130_fd_sc_hd__mux4_2
X_5696_ _5696_/A _5696_/B VGND VGND VPWR VPWR _5707_/B sky130_fd_sc_hd__nor2_2
X_4716_ _6247_/A _5180_/B VGND VGND VPWR VPWR _4716_/Y sky130_fd_sc_hd__nand2_2
X_4647_ _5352_/C VGND VGND VPWR VPWR _4945_/A sky130_fd_sc_hd__clkbuf_1
X_6317_ _6333_/B _6316_/Y _6317_/S VGND VGND VPWR VPWR _6317_/X sky130_fd_sc_hd__mux2_2
X_4578_ _4614_/B _4578_/B VGND VGND VPWR VPWR _6194_/A sky130_fd_sc_hd__or2_2
X_3529_ _3274_/X _3528_/X _3529_/S VGND VGND VPWR VPWR _3529_/X sky130_fd_sc_hd__mux2_2
XPHY_EDGE_ROW_55_Left_138 VGND VGND VPWR VPWR sky130_fd_sc_hd__decap_3
X_6248_ _6244_/B _6246_/Y _6247_/Y _4751_/A VGND VGND VPWR VPWR _6248_/X sky130_fd_sc_hd__o22a_2
X_6179_ _6171_/A _6067_/C _6171_/B VGND VGND VPWR VPWR _6179_/X sky130_fd_sc_hd__a21o_2
XTAP_TAPCELL_ROW_4_211 VGND VPWR sky130_fd_sc_hd__tapvpwrvgnd_1
XFILLER_76_229 VGND VGND VPWR VPWR sky130_fd_sc_hd__decap_3
XFILLER_29_156 VGND VGND VPWR VPWR sky130_fd_sc_hd__decap_3
XFILLER_29_178 VGND VGND VPWR VPWR sky130_fd_sc_hd__decap_3
XFILLER_44_104 VGND VGND VPWR VPWR sky130_fd_sc_hd__decap_3
XFILLER_44_126 VGND VGND VPWR VPWR sky130_fd_sc_hd__decap_3
XFILLER_55_57 VGND VGND VPWR VPWR sky130_fd_sc_hd__decap_3
XFILLER_72_446 VGND VGND VPWR VPWR sky130_fd_sc_hd__fill_2
XFILLER_44_159 VGND VGND VPWR VPWR sky130_fd_sc_hd__decap_3
XTAP_TAPCELL_ROW_55_677 VGND VPWR sky130_fd_sc_hd__tapvpwrvgnd_1
XPHY_EDGE_ROW_64_Left_147 VGND VGND VPWR VPWR sky130_fd_sc_hd__decap_3
XFILLER_13_513 VGND VGND VPWR VPWR sky130_fd_sc_hd__decap_3
XFILLER_25_373 VGND VGND VPWR VPWR sky130_fd_sc_hd__fill_2
XFILLER_40_321 VGND VGND VPWR VPWR sky130_fd_sc_hd__decap_3
XFILLER_40_365 VGND VGND VPWR VPWR sky130_fd_sc_hd__decap_3
XFILLER_40_398 VGND VGND VPWR VPWR sky130_fd_sc_hd__decap_3
XTAP_TAPCELL_ROW_10_268 VGND VPWR sky130_fd_sc_hd__tapvpwrvgnd_1
XPHY_EDGE_ROW_73_Left_156 VGND VGND VPWR VPWR sky130_fd_sc_hd__decap_3
XFILLER_48_410 VGND VGND VPWR VPWR sky130_fd_sc_hd__decap_3
XFILLER_48_421 VGND VGND VPWR VPWR sky130_fd_sc_hd__fill_1
XFILLER_75_262 VGND VGND VPWR VPWR sky130_fd_sc_hd__decap_3
XFILLER_63_402 VGND VGND VPWR VPWR sky130_fd_sc_hd__fill_1
XPHY_EDGE_ROW_82_Left_165 VGND VGND VPWR VPWR sky130_fd_sc_hd__decap_3
XFILLER_63_424 VGND VGND VPWR VPWR sky130_fd_sc_hd__decap_3
XFILLER_35_148 VGND VGND VPWR VPWR sky130_fd_sc_hd__decap_3
XFILLER_16_362 VGND VGND VPWR VPWR sky130_fd_sc_hd__fill_2
XFILLER_50_118 VGND VGND VPWR VPWR sky130_fd_sc_hd__decap_3
XFILLER_31_343 VGND VGND VPWR VPWR sky130_fd_sc_hd__decap_3
X_3880_ _3470_/B _3501_/Y _3879_/X _4462_/S VGND VGND VPWR VPWR _3880_/X sky130_fd_sc_hd__a22o_2
X_5550_ _5739_/B _5550_/B VGND VGND VPWR VPWR _5550_/Y sky130_fd_sc_hd__nor2_2
X_5481_ _5476_/S _5460_/A _5388_/S _5352_/A _5801_/S0 _5801_/S1 VGND VGND VPWR VPWR
+ _5481_/X sky130_fd_sc_hd__mux4_2
X_4501_ _6221_/B _4539_/A _4539_/B VGND VGND VPWR VPWR _4501_/X sky130_fd_sc_hd__mux2_2
X_4432_ _4258_/A _4251_/Y _4252_/X _4431_/B _4238_/B VGND VGND VPWR VPWR _4432_/X
+ sky130_fd_sc_hd__a311o_2
X_4363_ _5534_/A _5534_/B VGND VGND VPWR VPWR _4544_/A sky130_fd_sc_hd__or2_2
X_6102_ _6109_/A _6102_/B _6113_/C VGND VGND VPWR VPWR _6102_/X sky130_fd_sc_hd__or3_2
Xfanout507 input47/X VGND VGND VPWR VPWR _6449_/A2 sky130_fd_sc_hd__clkdlybuf4s25_1
Xfanout518 input42/X VGND VGND VPWR VPWR _5225_/S sky130_fd_sc_hd__clkdlybuf4s25_1
Xfanout529 input39/X VGND VGND VPWR VPWR _6109_/B sky130_fd_sc_hd__clkdlybuf4s25_1
X_4294_ _4606_/A _4284_/Y _4287_/Y _3947_/A _4293_/X VGND VGND VPWR VPWR _4294_/X
+ sky130_fd_sc_hd__o221a_2
X_3314_ _6458_/A1 _4355_/A _6199_/C _4429_/A _4504_/S _3948_/S1 VGND VGND VPWR VPWR
+ _3314_/X sky130_fd_sc_hd__mux4_2
X_6033_ _6051_/A _6033_/B _6051_/B VGND VGND VPWR VPWR _6401_/A sky130_fd_sc_hd__and3_2
X_3245_ _5732_/A _4095_/A VGND VGND VPWR VPWR _3947_/A sky130_fd_sc_hd__nand2_2
XFILLER_54_402 VGND VGND VPWR VPWR sky130_fd_sc_hd__decap_3
XFILLER_66_262 VGND VGND VPWR VPWR sky130_fd_sc_hd__decap_3
XFILLER_54_424 VGND VGND VPWR VPWR sky130_fd_sc_hd__fill_2
XFILLER_26_159 VGND VGND VPWR VPWR sky130_fd_sc_hd__decap_3
XTAP_TAPCELL_ROW_80_901 VGND VPWR sky130_fd_sc_hd__tapvpwrvgnd_1
XFILLER_41_118 VGND VGND VPWR VPWR sky130_fd_sc_hd__decap_3
XFILLER_81_276 VGND VGND VPWR VPWR sky130_fd_sc_hd__decap_3
XFILLER_34_181 VGND VGND VPWR VPWR sky130_fd_sc_hd__decap_3
XTAP_TAPCELL_ROW_52_647 VGND VPWR sky130_fd_sc_hd__tapvpwrvgnd_1
X_5817_ _5814_/Y _5815_/X _5817_/S VGND VGND VPWR VPWR _6493_/B sky130_fd_sc_hd__mux2_2
X_5748_ _5748_/A VGND VGND VPWR VPWR _5750_/A sky130_fd_sc_hd__inv_2
X_5679_ _5533_/B _5710_/A _5675_/X _5678_/Y _6374_/A VGND VGND VPWR VPWR _5679_/X
+ sky130_fd_sc_hd__o311a_2
Xmax_cap280 _5051_/A VGND VGND VPWR VPWR _5109_/A sky130_fd_sc_hd__clkbuf_2
Xmax_cap291 _3563_/X VGND VGND VPWR VPWR _3993_/A sky130_fd_sc_hd__buf_2
XFILLER_49_207 VGND VGND VPWR VPWR sky130_fd_sc_hd__decap_3
XFILLER_45_402 VGND VGND VPWR VPWR sky130_fd_sc_hd__fill_1
XFILLER_57_251 VGND VGND VPWR VPWR sky130_fd_sc_hd__decap_3
XTAP_TAPCELL_ROW_68_791 VGND VPWR sky130_fd_sc_hd__tapvpwrvgnd_1
XTAP_TAPCELL_ROW_15_316 VGND VPWR sky130_fd_sc_hd__tapvpwrvgnd_1
XFILLER_13_321 VGND VGND VPWR VPWR sky130_fd_sc_hd__fill_2
XFILLER_25_181 VGND VGND VPWR VPWR sky130_fd_sc_hd__decap_3
XFILLER_13_387 VGND VGND VPWR VPWR sky130_fd_sc_hd__decap_3
XFILLER_40_195 VGND VGND VPWR VPWR sky130_fd_sc_hd__fill_1
XTAP_TAPCELL_ROW_23_382 VGND VPWR sky130_fd_sc_hd__tapvpwrvgnd_1
XFILLER_48_240 VGND VGND VPWR VPWR sky130_fd_sc_hd__decap_3
XFILLER_63_210 VGND VGND VPWR VPWR sky130_fd_sc_hd__decap_3
XFILLER_63_243 VGND VGND VPWR VPWR sky130_fd_sc_hd__decap_3
XFILLER_63_232 VGND VGND VPWR VPWR sky130_fd_sc_hd__decap_3
XFILLER_51_405 VGND VGND VPWR VPWR sky130_fd_sc_hd__decap_3
X_4981_ _5004_/B _5004_/C VGND VGND VPWR VPWR _5042_/A sky130_fd_sc_hd__and2_2
XFILLER_51_449 VGND VGND VPWR VPWR sky130_fd_sc_hd__decap_3
X_3932_ _3932_/A VGND VGND VPWR VPWR _3932_/Y sky130_fd_sc_hd__inv_2
X_3863_ _6129_/A _3864_/B VGND VGND VPWR VPWR _3863_/Y sky130_fd_sc_hd__nor2_2
X_5602_ _5566_/B _5583_/B _5601_/X VGND VGND VPWR VPWR _5603_/B sky130_fd_sc_hd__a21oi_2
X_5533_ _6318_/S _5533_/B VGND VGND VPWR VPWR _5538_/B sky130_fd_sc_hd__xnor2_2
X_3794_ _4465_/S _4010_/B _3794_/C VGND VGND VPWR VPWR _3794_/X sky130_fd_sc_hd__and3_2
X_5464_ _5117_/A _5117_/B _5530_/B _5501_/B _5458_/A VGND VGND VPWR VPWR _5464_/X
+ sky130_fd_sc_hd__a2111o_2
X_5395_ _5322_/B _5393_/Y _6365_/A _5418_/B VGND VGND VPWR VPWR _5395_/X sky130_fd_sc_hd__a22o_2
X_4415_ _3878_/X _4053_/X _4221_/X _4414_/X _4461_/S _4140_/A VGND VGND VPWR VPWR
+ _4416_/B sky130_fd_sc_hd__mux4_2
X_4346_ _6176_/A _6059_/A VGND VGND VPWR VPWR _4449_/A sky130_fd_sc_hd__xor2_2
Xfanout337 _4854_/A VGND VGND VPWR VPWR _6071_/B sky130_fd_sc_hd__clkdlybuf4s25_1
Xfanout348 _6013_/C VGND VGND VPWR VPWR _3631_/S1 sky130_fd_sc_hd__clkdlybuf4s25_1
XFILLER_59_505 VGND VGND VPWR VPWR sky130_fd_sc_hd__fill_2
Xfanout359 input9/X VGND VGND VPWR VPWR _3965_/A sky130_fd_sc_hd__clkdlybuf4s25_1
X_4277_ input18/X _6458_/A1 _4504_/S VGND VGND VPWR VPWR _4277_/X sky130_fd_sc_hd__mux2_2
XFILLER_39_240 VGND VGND VPWR VPWR sky130_fd_sc_hd__decap_3
XFILLER_39_262 VGND VGND VPWR VPWR sky130_fd_sc_hd__decap_3
X_6016_ _6016_/A VGND VGND VPWR VPWR _6089_/B sky130_fd_sc_hd__clkbuf_1
X_3228_ _3225_/X _3226_/X _3596_/S VGND VGND VPWR VPWR _3228_/X sky130_fd_sc_hd__mux2_2
XFILLER_39_273 VGND VGND VPWR VPWR sky130_fd_sc_hd__decap_3
XFILLER_54_287 VGND VGND VPWR VPWR sky130_fd_sc_hd__decap_3
XTAP_TAPCELL_ROW_65_761 VGND VPWR sky130_fd_sc_hd__tapvpwrvgnd_1
XTAP_TAPCELL_ROW_20_363 VGND VPWR sky130_fd_sc_hd__tapvpwrvgnd_1
XFILLER_77_346 VGND VGND VPWR VPWR sky130_fd_sc_hd__fill_2
XFILLER_45_221 VGND VGND VPWR VPWR sky130_fd_sc_hd__decap_3
XFILLER_45_243 VGND VGND VPWR VPWR sky130_fd_sc_hd__decap_3
XTAP_TAPCELL_ROW_28_430 VGND VPWR sky130_fd_sc_hd__tapvpwrvgnd_1
XFILLER_45_265 VGND VGND VPWR VPWR sky130_fd_sc_hd__decap_3
XFILLER_45_287 VGND VGND VPWR VPWR sky130_fd_sc_hd__fill_1
XFILLER_60_213 VGND VGND VPWR VPWR sky130_fd_sc_hd__fill_1
XFILLER_26_81 VGND VGND VPWR VPWR sky130_fd_sc_hd__decap_3
XFILLER_60_224 VGND VGND VPWR VPWR sky130_fd_sc_hd__decap_3
XFILLER_9_188 VGND VGND VPWR VPWR sky130_fd_sc_hd__decap_3
X_4200_ _4200_/A VGND VGND VPWR VPWR _4200_/X sky130_fd_sc_hd__clkbuf_1
X_5180_ _5180_/A _5180_/B VGND VGND VPWR VPWR _5180_/Y sky130_fd_sc_hd__nand2_2
XFILLER_68_302 VGND VGND VPWR VPWR sky130_fd_sc_hd__decap_3
X_4131_ _4175_/A _4075_/B _4130_/X input77/X _4136_/A VGND VGND VPWR VPWR _4131_/X
+ sky130_fd_sc_hd__a221o_2
XFILLER_68_324 VGND VGND VPWR VPWR sky130_fd_sc_hd__decap_3
X_4062_ _4060_/X _4061_/X _4233_/A VGND VGND VPWR VPWR _4062_/X sky130_fd_sc_hd__mux2_2
XTAP_TAPCELL_ROW_79_886 VGND VPWR sky130_fd_sc_hd__tapvpwrvgnd_1
XFILLER_68_368 VGND VGND VPWR VPWR sky130_fd_sc_hd__decap_3
XFILLER_36_221 VGND VGND VPWR VPWR sky130_fd_sc_hd__decap_3
XFILLER_24_405 VGND VGND VPWR VPWR sky130_fd_sc_hd__decap_3
XFILLER_51_202 VGND VGND VPWR VPWR sky130_fd_sc_hd__decap_3
XFILLER_51_246 VGND VGND VPWR VPWR sky130_fd_sc_hd__decap_3
X_4964_ _5038_/A _4964_/B VGND VGND VPWR VPWR _4964_/Y sky130_fd_sc_hd__nand2_2
XFILLER_51_279 VGND VGND VPWR VPWR sky130_fd_sc_hd__fill_1
X_3915_ _6144_/B _3891_/X _3913_/X VGND VGND VPWR VPWR _3915_/Y sky130_fd_sc_hd__a21oi_2
X_4895_ _4942_/A _6077_/B VGND VGND VPWR VPWR _5429_/A sky130_fd_sc_hd__nor2b_2
XTAP_TAPCELL_ROW_34_488 VGND VPWR sky130_fd_sc_hd__tapvpwrvgnd_1
X_3846_ _4199_/A _4200_/A _6130_/S VGND VGND VPWR VPWR _3846_/X sky130_fd_sc_hd__mux2_2
X_3777_ _3735_/B _3856_/C _3777_/C _3777_/D VGND VGND VPWR VPWR _3928_/B sky130_fd_sc_hd__and4b_2
X_6496_ _6493_/Y _6496_/B _6496_/C _6496_/D VGND VGND VPWR VPWR _6497_/B sky130_fd_sc_hd__and4b_2
X_5516_ _5530_/A _5658_/C _6317_/S VGND VGND VPWR VPWR _5516_/X sky130_fd_sc_hd__and3b_2
X_5447_ _4846_/A _5224_/A _5466_/A VGND VGND VPWR VPWR _5447_/X sky130_fd_sc_hd__mux2_2
X_5378_ _6453_/B _4057_/Y _4056_/X _5381_/S VGND VGND VPWR VPWR _5378_/X sky130_fd_sc_hd__a2bb2o_2
X_4329_ _4099_/X _4138_/X _4277_/X _4328_/X _4674_/S _4191_/X VGND VGND VPWR VPWR
+ _4329_/X sky130_fd_sc_hd__mux4_2
XFILLER_59_346 VGND VGND VPWR VPWR sky130_fd_sc_hd__decap_3
XFILLER_59_379 VGND VGND VPWR VPWR sky130_fd_sc_hd__decap_3
XFILLER_27_210 VGND VGND VPWR VPWR sky130_fd_sc_hd__decap_3
XFILLER_74_327 VGND VGND VPWR VPWR sky130_fd_sc_hd__fill_1
XFILLER_15_405 VGND VGND VPWR VPWR sky130_fd_sc_hd__decap_3
XFILLER_27_265 VGND VGND VPWR VPWR sky130_fd_sc_hd__fill_1
XTAP_TAPCELL_ROW_25_400 VGND VPWR sky130_fd_sc_hd__tapvpwrvgnd_1
Xfanout690 _5099_/A VGND VGND VPWR VPWR _6306_/A sky130_fd_sc_hd__clkdlybuf4s25_1
XTAP_TAPCELL_ROW_76_867 VGND VPWR sky130_fd_sc_hd__tapvpwrvgnd_1
XFILLER_21_408 VGND VGND VPWR VPWR sky130_fd_sc_hd__decap_3
XFILLER_33_246 VGND VGND VPWR VPWR sky130_fd_sc_hd__decap_3
X_3700_ _3697_/X _3699_/X _3750_/A VGND VGND VPWR VPWR _3700_/X sky130_fd_sc_hd__mux2_2
XFILLER_41_290 VGND VGND VPWR VPWR sky130_fd_sc_hd__decap_3
X_4680_ _4768_/B _4670_/Y _4679_/X VGND VGND VPWR VPWR _4680_/X sky130_fd_sc_hd__a21o_2
XTAP_TAPCELL_ROW_31_458 VGND VPWR sky130_fd_sc_hd__tapvpwrvgnd_1
X_3631_ _6449_/A2 _6439_/A3 _6439_/A2 _6440_/A3 _3631_/S0 _3631_/S1 VGND VGND VPWR
+ VPWR _3631_/X sky130_fd_sc_hd__mux4_2
X_6350_ _5658_/B _6374_/D _6347_/X _6349_/X _5658_/A VGND VGND VPWR VPWR _6350_/X
+ sky130_fd_sc_hd__o311a_2
X_3562_ _4132_/A _3856_/A VGND VGND VPWR VPWR _3562_/Y sky130_fd_sc_hd__nor2_2
X_5301_ _5624_/A _5624_/B _5624_/C VGND VGND VPWR VPWR _5499_/A sky130_fd_sc_hd__or3_2
X_6281_ _6084_/X _6263_/X _6280_/X VGND VGND VPWR VPWR _6281_/X sky130_fd_sc_hd__a21o_2
X_3493_ _6114_/A _6108_/B VGND VGND VPWR VPWR _3679_/C sky130_fd_sc_hd__xor2_2
X_5232_ _5628_/A _5209_/X _5231_/X VGND VGND VPWR VPWR _5984_/B sky130_fd_sc_hd__o21ai_2
X_5163_ _4440_/X _4442_/X _4784_/X _5162_/B VGND VGND VPWR VPWR _5421_/B sky130_fd_sc_hd__a211oi_2
X_4114_ _4110_/X _4113_/Y _4211_/A VGND VGND VPWR VPWR _4114_/Y sky130_fd_sc_hd__a21oi_2
XFILLER_56_327 VGND VGND VPWR VPWR sky130_fd_sc_hd__decap_3
X_5094_ _4606_/A _5092_/Y _5093_/Y _5038_/A _6450_/A1 VGND VGND VPWR VPWR _5094_/X
+ sky130_fd_sc_hd__o221a_2
XFILLER_49_390 VGND VGND VPWR VPWR sky130_fd_sc_hd__fill_2
X_4045_ _4042_/Y _4076_/D _4043_/X _4044_/X VGND VGND VPWR VPWR _4046_/C sky130_fd_sc_hd__a211o_2
XFILLER_24_224 VGND VGND VPWR VPWR sky130_fd_sc_hd__fill_2
XFILLER_64_393 VGND VGND VPWR VPWR sky130_fd_sc_hd__decap_3
XFILLER_24_268 VGND VGND VPWR VPWR sky130_fd_sc_hd__fill_2
X_5996_ _5996_/A _5996_/B _5996_/C _5996_/D VGND VGND VPWR VPWR _5998_/C sky130_fd_sc_hd__or4_4
X_4947_ _5058_/B VGND VGND VPWR VPWR _4987_/B sky130_fd_sc_hd__clkbuf_1
X_4878_ _4377_/X _4551_/X _4720_/X _4877_/X _4971_/S _5175_/S VGND VGND VPWR VPWR
+ _4878_/X sky130_fd_sc_hd__mux4_2
X_3829_ _3319_/X _3324_/X _3459_/B _3383_/X _3633_/A _4506_/S VGND VGND VPWR VPWR
+ _3830_/B sky130_fd_sc_hd__mux4_2
X_6479_ _6479_/A _6479_/B _6491_/B VGND VGND VPWR VPWR _6479_/X sky130_fd_sc_hd__or3b_2
XFILLER_59_154 VGND VGND VPWR VPWR sky130_fd_sc_hd__decap_3
XFILLER_59_132 VGND VGND VPWR VPWR sky130_fd_sc_hd__fill_1
XFILLER_47_327 VGND VGND VPWR VPWR sky130_fd_sc_hd__decap_3
XFILLER_59_187 VGND VGND VPWR VPWR sky130_fd_sc_hd__decap_3
XFILLER_47_349 VGND VGND VPWR VPWR sky130_fd_sc_hd__decap_3
XFILLER_55_360 VGND VGND VPWR VPWR sky130_fd_sc_hd__decap_3
XFILLER_55_393 VGND VGND VPWR VPWR sky130_fd_sc_hd__decap_3
XTAP_TAPCELL_ROW_73_837 VGND VPWR sky130_fd_sc_hd__tapvpwrvgnd_1
XTAP_TAPCELL_ROW_2_194 VGND VPWR sky130_fd_sc_hd__tapvpwrvgnd_1
XFILLER_70_352 VGND VGND VPWR VPWR sky130_fd_sc_hd__decap_3
XFILLER_30_205 VGND VGND VPWR VPWR sky130_fd_sc_hd__decap_3
XFILLER_30_238 VGND VGND VPWR VPWR sky130_fd_sc_hd__decap_3
XFILLER_7_456 VGND VGND VPWR VPWR sky130_fd_sc_hd__fill_1
XFILLER_2_161 VGND VGND VPWR VPWR sky130_fd_sc_hd__fill_1
XFILLER_38_349 VGND VGND VPWR VPWR sky130_fd_sc_hd__decap_3
XFILLER_48_90 VGND VGND VPWR VPWR sky130_fd_sc_hd__fill_2
XFILLER_53_308 VGND VGND VPWR VPWR sky130_fd_sc_hd__decap_3
XTAP_TAPCELL_ROW_36_506 VGND VPWR sky130_fd_sc_hd__tapvpwrvgnd_1
XFILLER_46_371 VGND VGND VPWR VPWR sky130_fd_sc_hd__decap_3
XFILLER_46_382 VGND VGND VPWR VPWR sky130_fd_sc_hd__decap_3
X_5850_ _5847_/B _5849_/Y _5869_/A VGND VGND VPWR VPWR _5851_/B sky130_fd_sc_hd__a21o_2
XFILLER_61_352 VGND VGND VPWR VPWR sky130_fd_sc_hd__decap_3
X_5781_ _5874_/A _5809_/B VGND VGND VPWR VPWR _6400_/B sky130_fd_sc_hd__nor2_2
X_4801_ _4801_/A VGND VGND VPWR VPWR _5061_/A sky130_fd_sc_hd__clkbuf_2
XTAP_TAPCELL_ROW_44_572 VGND VPWR sky130_fd_sc_hd__tapvpwrvgnd_1
XFILLER_61_385 VGND VGND VPWR VPWR sky130_fd_sc_hd__fill_1
XFILLER_14_290 VGND VGND VPWR VPWR sky130_fd_sc_hd__fill_1
X_4732_ _4734_/A _6247_/A VGND VGND VPWR VPWR _4733_/B sky130_fd_sc_hd__nor2_2
X_4663_ _6252_/A _4679_/B _6243_/C VGND VGND VPWR VPWR _4663_/X sky130_fd_sc_hd__and3_2
X_6402_ _6051_/A _6051_/B _6033_/B VGND VGND VPWR VPWR _6402_/Y sky130_fd_sc_hd__a21oi_2
X_3614_ _3685_/A _3685_/B VGND VGND VPWR VPWR _3615_/C sky130_fd_sc_hd__and2_2
X_4594_ _4222_/X _4593_/X _6108_/A VGND VGND VPWR VPWR _4594_/X sky130_fd_sc_hd__mux2_2
X_6333_ _6333_/A _6333_/B VGND VGND VPWR VPWR _6333_/Y sky130_fd_sc_hd__nand2_2
X_3545_ _3620_/A _3498_/Y _3536_/X _3544_/X VGND VGND VPWR VPWR _3545_/Y sky130_fd_sc_hd__o211ai_2
X_6264_ _6275_/A _6264_/B VGND VGND VPWR VPWR _6264_/X sky130_fd_sc_hd__or2_2
X_3476_ _3473_/X _3474_/Y _3475_/X wire500/A VGND VGND VPWR VPWR _3476_/X sky130_fd_sc_hd__a31o_2
X_5215_ _5696_/A VGND VGND VPWR VPWR _5215_/X sky130_fd_sc_hd__clkbuf_1
X_6195_ _6232_/A _6192_/A _6194_/A _6233_/C _6194_/Y VGND VGND VPWR VPWR _6195_/X
+ sky130_fd_sc_hd__a41o_2
XFILLER_28_27 VGND VGND VPWR VPWR sky130_fd_sc_hd__fill_1
X_5146_ _5191_/A VGND VGND VPWR VPWR _5188_/S sky130_fd_sc_hd__inv_2
X_5077_ _6275_/A _6274_/A VGND VGND VPWR VPWR _5078_/B sky130_fd_sc_hd__or2_2
XFILLER_56_179 VGND VGND VPWR VPWR sky130_fd_sc_hd__decap_3
X_4028_ _5010_/S _4025_/X _4027_/X _3976_/A VGND VGND VPWR VPWR _4028_/X sky130_fd_sc_hd__o211a_2
XFILLER_37_382 VGND VGND VPWR VPWR sky130_fd_sc_hd__decap_3
XTAP_TAPCELL_ROW_70_807 VGND VPWR sky130_fd_sc_hd__tapvpwrvgnd_1
XFILLER_52_363 VGND VGND VPWR VPWR sky130_fd_sc_hd__fill_1
X_5979_ _5975_/X _5976_/Y _6422_/A VGND VGND VPWR VPWR _5979_/X sky130_fd_sc_hd__mux2_2
XFILLER_20_293 VGND VGND VPWR VPWR sky130_fd_sc_hd__decap_3
XFILLER_69_23 VGND VGND VPWR VPWR sky130_fd_sc_hd__fill_1
XFILLER_79_205 VGND VGND VPWR VPWR sky130_fd_sc_hd__decap_3
XTAP_TAPCELL_ROW_7_242 VGND VPWR sky130_fd_sc_hd__tapvpwrvgnd_1
XFILLER_28_360 VGND VGND VPWR VPWR sky130_fd_sc_hd__decap_3
XFILLER_35_319 VGND VGND VPWR VPWR sky130_fd_sc_hd__decap_3
XFILLER_28_371 VGND VGND VPWR VPWR sky130_fd_sc_hd__decap_3
XTAP_TAPCELL_ROW_58_697 VGND VPWR sky130_fd_sc_hd__tapvpwrvgnd_1
XFILLER_62_138 VGND VGND VPWR VPWR sky130_fd_sc_hd__fill_2
XFILLER_55_190 VGND VGND VPWR VPWR sky130_fd_sc_hd__decap_3
XFILLER_43_363 VGND VGND VPWR VPWR sky130_fd_sc_hd__decap_3
XFILLER_43_385 VGND VGND VPWR VPWR sky130_fd_sc_hd__decap_3
XFILLER_43_396 VGND VGND VPWR VPWR sky130_fd_sc_hd__decap_3
XTAP_TAPCELL_ROW_13_299 VGND VPWR sky130_fd_sc_hd__tapvpwrvgnd_1
XFILLER_50_91 VGND VGND VPWR VPWR sky130_fd_sc_hd__fill_2
X_3330_ _3282_/X _3329_/X _3800_/A VGND VGND VPWR VPWR _3799_/B sky130_fd_sc_hd__mux2_2
X_5000_ _5000_/A VGND VGND VPWR VPWR _5120_/C sky130_fd_sc_hd__buf_1
X_3261_ _3349_/A _4849_/B _3259_/X _3410_/B _3260_/X VGND VGND VPWR VPWR _3261_/X
+ sky130_fd_sc_hd__o221a_2
XFILLER_22_3 VGND VGND VPWR VPWR sky130_fd_sc_hd__fill_1
XFILLER_78_271 VGND VGND VPWR VPWR sky130_fd_sc_hd__decap_3
XFILLER_66_400 VGND VGND VPWR VPWR sky130_fd_sc_hd__decap_3
XTAP_TAPCELL_ROW_49_620 VGND VPWR sky130_fd_sc_hd__tapvpwrvgnd_1
XFILLER_66_455 VGND VGND VPWR VPWR sky130_fd_sc_hd__fill_1
XFILLER_38_157 VGND VGND VPWR VPWR sky130_fd_sc_hd__decap_3
XFILLER_19_393 VGND VGND VPWR VPWR sky130_fd_sc_hd__decap_3
XFILLER_53_116 VGND VGND VPWR VPWR sky130_fd_sc_hd__decap_3
XFILLER_53_138 VGND VGND VPWR VPWR sky130_fd_sc_hd__decap_3
XFILLER_46_190 VGND VGND VPWR VPWR sky130_fd_sc_hd__decap_3
X_5902_ _5481_/X _5615_/X _5764_/X _5901_/X _5947_/S _5239_/X VGND VGND VPWR VPWR
+ _5902_/X sky130_fd_sc_hd__mux4_2
X_5833_ _5968_/A _6400_/A _5832_/X VGND VGND VPWR VPWR _5833_/X sky130_fd_sc_hd__o21a_2
XFILLER_61_193 VGND VGND VPWR VPWR sky130_fd_sc_hd__decap_3
X_5764_ _6050_/A _5752_/A _6349_/A _6440_/A1 _5764_/S0 _5801_/S1 VGND VGND VPWR VPWR
+ _5764_/X sky130_fd_sc_hd__mux4_2
X_5695_ _5695_/A _5695_/B VGND VGND VPWR VPWR _5696_/B sky130_fd_sc_hd__xnor2_2
X_4715_ _4940_/A _4941_/A _4715_/S VGND VGND VPWR VPWR _4715_/X sky130_fd_sc_hd__mux2_2
XFILLER_30_17 VGND VGND VPWR VPWR sky130_fd_sc_hd__fill_2
X_4646_ _5906_/A1 _6243_/B _4645_/X VGND VGND VPWR VPWR _4646_/X sky130_fd_sc_hd__a21o_2
X_4577_ _6233_/A _4582_/S VGND VGND VPWR VPWR _4577_/X sky130_fd_sc_hd__and2_2
X_6316_ _6330_/B _6330_/D VGND VGND VPWR VPWR _6316_/Y sky130_fd_sc_hd__xnor2_2
X_3528_ _4355_/A _6199_/B _6199_/C _6208_/A _4025_/S1 _3695_/S0 VGND VGND VPWR VPWR
+ _3528_/X sky130_fd_sc_hd__mux4_2
X_6247_ _6247_/A _6247_/B VGND VGND VPWR VPWR _6247_/Y sky130_fd_sc_hd__xnor2_2
X_3459_ _3625_/A _3459_/B VGND VGND VPWR VPWR _3459_/X sky130_fd_sc_hd__or2_2
XFILLER_29_102 VGND VGND VPWR VPWR sky130_fd_sc_hd__fill_1
X_6178_ _6178_/A _6178_/B _6200_/C VGND VGND VPWR VPWR _6178_/X sky130_fd_sc_hd__and3_2
XTAP_TAPCELL_ROW_4_212 VGND VPWR sky130_fd_sc_hd__tapvpwrvgnd_1
XFILLER_76_208 VGND VGND VPWR VPWR sky130_fd_sc_hd__decap_3
XFILLER_69_260 VGND VGND VPWR VPWR sky130_fd_sc_hd__decap_3
XFILLER_57_411 VGND VGND VPWR VPWR sky130_fd_sc_hd__fill_2
XFILLER_29_124 VGND VGND VPWR VPWR sky130_fd_sc_hd__decap_3
X_5129_ _5078_/B _5124_/X _5127_/X _5128_/X VGND VGND VPWR VPWR _5129_/Y sky130_fd_sc_hd__o211ai_2
XTAP_TAPCELL_ROW_55_678 VGND VPWR sky130_fd_sc_hd__tapvpwrvgnd_1
XFILLER_25_396 VGND VGND VPWR VPWR sky130_fd_sc_hd__decap_3
XFILLER_40_333 VGND VGND VPWR VPWR sky130_fd_sc_hd__decap_3
XFILLER_40_377 VGND VGND VPWR VPWR sky130_fd_sc_hd__decap_3
XTAP_TAPCELL_ROW_10_269 VGND VPWR sky130_fd_sc_hd__tapvpwrvgnd_1
XFILLER_29_70 VGND VGND VPWR VPWR sky130_fd_sc_hd__fill_2
XFILLER_75_296 VGND VGND VPWR VPWR sky130_fd_sc_hd__fill_1
XFILLER_75_274 VGND VGND VPWR VPWR sky130_fd_sc_hd__fill_1
XFILLER_16_330 VGND VGND VPWR VPWR sky130_fd_sc_hd__fill_2
XFILLER_28_190 VGND VGND VPWR VPWR sky130_fd_sc_hd__decap_3
XFILLER_43_193 VGND VGND VPWR VPWR sky130_fd_sc_hd__decap_3
XFILLER_31_399 VGND VGND VPWR VPWR sky130_fd_sc_hd__decap_3
X_5480_ _3594_/B _4151_/Y _5375_/X VGND VGND VPWR VPWR _5480_/Y sky130_fd_sc_hd__a21oi_2
X_4500_ _4498_/B _4541_/S _4320_/A VGND VGND VPWR VPWR _4500_/Y sky130_fd_sc_hd__a21oi_2
XANTENNA_1 _5628_/A VGND VGND VPWR VPWR sky130_fd_sc_hd__diode_2
X_4431_ _4431_/A _4431_/B VGND VGND VPWR VPWR _4431_/Y sky130_fd_sc_hd__nor2_2
X_4362_ _4362_/A VGND VGND VPWR VPWR _5534_/B sky130_fd_sc_hd__buf_1
X_6101_ _6102_/B _6113_/C VGND VGND VPWR VPWR _6101_/Y sky130_fd_sc_hd__nand2_2
Xfanout508 _6449_/A1 VGND VGND VPWR VPWR _6363_/A sky130_fd_sc_hd__clkdlybuf4s25_1
Xfanout519 _5281_/A3 VGND VGND VPWR VPWR _6391_/B sky130_fd_sc_hd__clkdlybuf4s25_1
X_4293_ _4290_/Y _4292_/X _4211_/A VGND VGND VPWR VPWR _4293_/X sky130_fd_sc_hd__a21o_2
X_3313_ _3299_/X _3303_/Y _3780_/B _3312_/X VGND VGND VPWR VPWR _3313_/X sky130_fd_sc_hd__a31o_2
X_6032_ _6032_/A VGND VGND VPWR VPWR _6354_/B sky130_fd_sc_hd__clkbuf_1
X_3244_ _4884_/B _4372_/B VGND VGND VPWR VPWR _4095_/A sky130_fd_sc_hd__nand2_2
XFILLER_39_422 VGND VGND VPWR VPWR sky130_fd_sc_hd__fill_2
XFILLER_39_444 VGND VGND VPWR VPWR sky130_fd_sc_hd__decap_3
XFILLER_66_230 VGND VGND VPWR VPWR sky130_fd_sc_hd__decap_3
XFILLER_26_105 VGND VGND VPWR VPWR sky130_fd_sc_hd__decap_3
XFILLER_54_414 VGND VGND VPWR VPWR sky130_fd_sc_hd__fill_2
XFILLER_54_436 VGND VGND VPWR VPWR sky130_fd_sc_hd__fill_1
XPHY_EDGE_ROW_16_Left_99 VGND VGND VPWR VPWR sky130_fd_sc_hd__decap_3
XFILLER_66_274 VGND VGND VPWR VPWR sky130_fd_sc_hd__decap_3
XFILLER_26_138 VGND VGND VPWR VPWR sky130_fd_sc_hd__fill_2
XTAP_TAPCELL_ROW_80_902 VGND VPWR sky130_fd_sc_hd__tapvpwrvgnd_1
XFILLER_34_160 VGND VGND VPWR VPWR sky130_fd_sc_hd__decap_3
XFILLER_34_193 VGND VGND VPWR VPWR sky130_fd_sc_hd__decap_3
XTAP_TAPCELL_ROW_52_648 VGND VPWR sky130_fd_sc_hd__tapvpwrvgnd_1
X_5816_ _5816_/A _5816_/B VGND VGND VPWR VPWR _5817_/S sky130_fd_sc_hd__and2_2
X_5747_ _6033_/B _6050_/A VGND VGND VPWR VPWR _5748_/A sky130_fd_sc_hd__or2b_2
X_5678_ _5678_/A VGND VGND VPWR VPWR _5678_/Y sky130_fd_sc_hd__inv_2
X_4629_ _4687_/C _4629_/B VGND VGND VPWR VPWR _4630_/B sky130_fd_sc_hd__nand2b_2
Xmax_cap270 _4687_/D VGND VGND VPWR VPWR _4124_/A sky130_fd_sc_hd__buf_2
Xmax_cap292 _4102_/A VGND VGND VPWR VPWR _4233_/A sky130_fd_sc_hd__buf_2
XFILLER_49_219 VGND VGND VPWR VPWR sky130_fd_sc_hd__decap_3
XFILLER_57_263 VGND VGND VPWR VPWR sky130_fd_sc_hd__decap_3
XTAP_TAPCELL_ROW_68_792 VGND VPWR sky130_fd_sc_hd__tapvpwrvgnd_1
XFILLER_17_149 VGND VGND VPWR VPWR sky130_fd_sc_hd__decap_3
XTAP_TAPCELL_ROW_15_317 VGND VPWR sky130_fd_sc_hd__tapvpwrvgnd_1
XFILLER_72_277 VGND VGND VPWR VPWR sky130_fd_sc_hd__decap_3
XFILLER_40_141 VGND VGND VPWR VPWR sky130_fd_sc_hd__decap_3
XFILLER_40_174 VGND VGND VPWR VPWR sky130_fd_sc_hd__decap_3
XTAP_TAPCELL_ROW_23_383 VGND VPWR sky130_fd_sc_hd__tapvpwrvgnd_1
XFILLER_36_403 VGND VGND VPWR VPWR sky130_fd_sc_hd__decap_3
XFILLER_36_436 VGND VGND VPWR VPWR sky130_fd_sc_hd__decap_3
XFILLER_48_274 VGND VGND VPWR VPWR sky130_fd_sc_hd__decap_3
XFILLER_63_255 VGND VGND VPWR VPWR sky130_fd_sc_hd__fill_1
X_4980_ _4939_/Y _4978_/X _4979_/X VGND VGND VPWR VPWR _5004_/C sky130_fd_sc_hd__o21a_2
XFILLER_63_277 VGND VGND VPWR VPWR sky130_fd_sc_hd__decap_3
X_3931_ _3711_/X _3758_/X _3877_/X _3930_/X _3842_/S _3942_/A VGND VGND VPWR VPWR
+ _3932_/A sky130_fd_sc_hd__mux4_2
X_3862_ _3921_/B VGND VGND VPWR VPWR _3864_/B sky130_fd_sc_hd__clkbuf_1
X_5601_ _5566_/B _5583_/B _5591_/S VGND VGND VPWR VPWR _5601_/X sky130_fd_sc_hd__o21a_2
XFILLER_31_196 VGND VGND VPWR VPWR sky130_fd_sc_hd__decap_3
X_5532_ _5532_/A _5532_/B _5532_/C VGND VGND VPWR VPWR _5533_/B sky130_fd_sc_hd__and3_2
X_3793_ _3790_/X _3792_/X _4221_/S VGND VGND VPWR VPWR _3793_/X sky130_fd_sc_hd__mux2_2
X_5463_ _5466_/A _5458_/A _5434_/X _5501_/B VGND VGND VPWR VPWR _5465_/C sky130_fd_sc_hd__a211oi_2
X_5394_ _5394_/A _5394_/B VGND VGND VPWR VPWR _5418_/B sky130_fd_sc_hd__nor2_2
X_4414_ _4376_/X _4413_/X _4460_/S VGND VGND VPWR VPWR _4414_/X sky130_fd_sc_hd__mux2_2
X_4345_ _4309_/Y _4313_/X _4319_/Y _4344_/X VGND VGND VPWR VPWR _5999_/A sky130_fd_sc_hd__a211o_2
Xfanout338 _6247_/B VGND VGND VPWR VPWR _6244_/A sky130_fd_sc_hd__clkdlybuf4s25_1
Xfanout349 _3394_/B VGND VGND VPWR VPWR _3780_/A sky130_fd_sc_hd__clkdlybuf4s25_1
X_4276_ _3508_/B _4275_/X _4502_/S VGND VGND VPWR VPWR _4276_/X sky130_fd_sc_hd__mux2_2
XFILLER_39_252 VGND VGND VPWR VPWR sky130_fd_sc_hd__fill_2
X_6015_ _6015_/A _6098_/B _6090_/C _6015_/D VGND VGND VPWR VPWR _6016_/A sky130_fd_sc_hd__and4_2
X_3227_ _3262_/A VGND VGND VPWR VPWR _3596_/S sky130_fd_sc_hd__inv_2
XFILLER_36_27 VGND VGND VPWR VPWR sky130_fd_sc_hd__fill_1
XFILLER_39_285 VGND VGND VPWR VPWR sky130_fd_sc_hd__decap_3
XFILLER_27_436 VGND VGND VPWR VPWR sky130_fd_sc_hd__decap_3
XFILLER_27_447 VGND VGND VPWR VPWR sky130_fd_sc_hd__fill_1
XFILLER_42_417 VGND VGND VPWR VPWR sky130_fd_sc_hd__decap_3
XTAP_TAPCELL_ROW_65_762 VGND VPWR sky130_fd_sc_hd__tapvpwrvgnd_1
XFILLER_22_141 VGND VGND VPWR VPWR sky130_fd_sc_hd__fill_1
XFILLER_50_450 VGND VGND VPWR VPWR sky130_fd_sc_hd__fill_2
XFILLER_10_347 VGND VGND VPWR VPWR sky130_fd_sc_hd__fill_2
XFILLER_10_358 VGND VGND VPWR VPWR sky130_fd_sc_hd__decap_3
XTAP_TAPCELL_ROW_28_431 VGND VPWR sky130_fd_sc_hd__tapvpwrvgnd_1
XFILLER_45_277 VGND VGND VPWR VPWR sky130_fd_sc_hd__decap_3
XFILLER_45_299 VGND VGND VPWR VPWR sky130_fd_sc_hd__decap_3
XFILLER_60_236 VGND VGND VPWR VPWR sky130_fd_sc_hd__decap_3
XFILLER_13_130 VGND VGND VPWR VPWR sky130_fd_sc_hd__decap_3
XFILLER_13_185 VGND VGND VPWR VPWR sky130_fd_sc_hd__decap_3
XFILLER_5_351 VGND VGND VPWR VPWR sky130_fd_sc_hd__fill_1
X_4130_ _3912_/B _4069_/B _6167_/A VGND VGND VPWR VPWR _4130_/X sky130_fd_sc_hd__a21o_2
XFILLER_3_64 VGND VGND VPWR VPWR sky130_fd_sc_hd__fill_1
XFILLER_68_336 VGND VGND VPWR VPWR sky130_fd_sc_hd__decap_3
X_4061_ _3278_/X _3654_/X _3695_/X _3649_/X _4460_/S _4061_/S1 VGND VGND VPWR VPWR
+ _4061_/X sky130_fd_sc_hd__mux4_2
XFILLER_36_200 VGND VGND VPWR VPWR sky130_fd_sc_hd__decap_3
XTAP_TAPCELL_ROW_79_887 VGND VPWR sky130_fd_sc_hd__tapvpwrvgnd_1
XFILLER_36_266 VGND VGND VPWR VPWR sky130_fd_sc_hd__decap_3
XFILLER_51_214 VGND VGND VPWR VPWR sky130_fd_sc_hd__decap_3
XFILLER_51_225 VGND VGND VPWR VPWR sky130_fd_sc_hd__decap_3
X_4963_ _4874_/B _5535_/A _4526_/A VGND VGND VPWR VPWR _4964_/B sky130_fd_sc_hd__o21ai_2
X_3914_ _3913_/X _3921_/A VGND VGND VPWR VPWR _3914_/X sky130_fd_sc_hd__and2b_2
X_4894_ _6077_/B _4942_/A VGND VGND VPWR VPWR _4946_/B sky130_fd_sc_hd__and2b_2
XTAP_TAPCELL_ROW_34_489 VGND VPWR sky130_fd_sc_hd__tapvpwrvgnd_1
X_3845_ _6062_/C VGND VGND VPWR VPWR _6129_/A sky130_fd_sc_hd__inv_2
X_3776_ _3776_/A _3776_/B VGND VGND VPWR VPWR _3928_/A sky130_fd_sc_hd__nand2_2
X_6495_ _6495_/A _6495_/B _6495_/C _6495_/D VGND VGND VPWR VPWR _6496_/B sky130_fd_sc_hd__and4_2
X_5515_ _4846_/A _5224_/A _6330_/A VGND VGND VPWR VPWR _5515_/X sky130_fd_sc_hd__mux2_2
X_5446_ _5466_/A _5458_/A VGND VGND VPWR VPWR _5446_/Y sky130_fd_sc_hd__nor2_2
X_5377_ _5381_/S _5664_/B1 _4054_/X _4937_/A VGND VGND VPWR VPWR _5377_/X sky130_fd_sc_hd__a31o_2
X_4328_ _6461_/A3 _4241_/C _4504_/S VGND VGND VPWR VPWR _4328_/X sky130_fd_sc_hd__mux2_2
XFILLER_47_15 VGND VGND VPWR VPWR sky130_fd_sc_hd__fill_2
X_4259_ _4259_/A _4259_/B VGND VGND VPWR VPWR _4259_/Y sky130_fd_sc_hd__nor2_2
XFILLER_59_358 VGND VGND VPWR VPWR sky130_fd_sc_hd__decap_3
XFILLER_27_222 VGND VGND VPWR VPWR sky130_fd_sc_hd__fill_2
XFILLER_67_380 VGND VGND VPWR VPWR sky130_fd_sc_hd__fill_1
XFILLER_15_417 VGND VGND VPWR VPWR sky130_fd_sc_hd__fill_1
XTAP_TAPCELL_ROW_25_401 VGND VPWR sky130_fd_sc_hd__tapvpwrvgnd_1
XFILLER_23_483 VGND VGND VPWR VPWR sky130_fd_sc_hd__fill_1
XFILLER_50_280 VGND VGND VPWR VPWR sky130_fd_sc_hd__decap_3
XFILLER_10_166 VGND VGND VPWR VPWR sky130_fd_sc_hd__decap_3
XFILLER_10_188 VGND VGND VPWR VPWR sky130_fd_sc_hd__fill_1
XFILLER_12_62 VGND VGND VPWR VPWR sky130_fd_sc_hd__fill_2
XFILLER_2_332 VGND VGND VPWR VPWR sky130_fd_sc_hd__fill_1
XFILLER_2_365 VGND VGND VPWR VPWR sky130_fd_sc_hd__decap_3
Xfanout680 _4465_/S VGND VGND VPWR VPWR _4931_/B2 sky130_fd_sc_hd__clkdlybuf4s25_1
Xfanout691 input102/X VGND VGND VPWR VPWR _5099_/A sky130_fd_sc_hd__clkdlybuf4s25_1
XFILLER_33_214 VGND VGND VPWR VPWR sky130_fd_sc_hd__decap_3
XFILLER_33_225 VGND VGND VPWR VPWR sky130_fd_sc_hd__decap_3
XFILLER_33_258 VGND VGND VPWR VPWR sky130_fd_sc_hd__decap_3
XTAP_TAPCELL_ROW_31_459 VGND VPWR sky130_fd_sc_hd__tapvpwrvgnd_1
X_3630_ _3305_/Y _3627_/X _3629_/X _4146_/A VGND VGND VPWR VPWR _3630_/X sky130_fd_sc_hd__a22o_2
X_3561_ _3856_/A _3856_/B VGND VGND VPWR VPWR _3561_/Y sky130_fd_sc_hd__xnor2_2
X_5300_ _5298_/Y _5302_/B _5359_/C _5302_/D VGND VGND VPWR VPWR _5300_/Y sky130_fd_sc_hd__a31oi_2
X_6280_ _5128_/A _6273_/X _6275_/X _6276_/X _6279_/Y VGND VGND VPWR VPWR _6280_/X
+ sky130_fd_sc_hd__a32o_2
X_3492_ _3448_/X _5988_/C _5988_/D VGND VGND VPWR VPWR _3492_/Y sky130_fd_sc_hd__nand3b_2
X_5231_ _6497_/A _5262_/A _5214_/X _5215_/X _5230_/X VGND VGND VPWR VPWR _5231_/X
+ sky130_fd_sc_hd__o221a_2
X_5162_ _5162_/A _5162_/B VGND VGND VPWR VPWR _5421_/A sky130_fd_sc_hd__nor2_2
X_5093_ _6080_/A _5110_/B VGND VGND VPWR VPWR _5093_/Y sky130_fd_sc_hd__nand2_2
X_4113_ _6164_/A _4202_/A _3981_/X _4251_/B VGND VGND VPWR VPWR _4113_/Y sky130_fd_sc_hd__a22oi_2
XTAP_TAPCELL_ROW_39_526 VGND VPWR sky130_fd_sc_hd__tapvpwrvgnd_1
XFILLER_56_339 VGND VGND VPWR VPWR sky130_fd_sc_hd__decap_3
X_4044_ _4044_/A _4044_/B _4044_/C VGND VGND VPWR VPWR _4044_/X sky130_fd_sc_hd__and3_2
XFILLER_24_203 VGND VGND VPWR VPWR sky130_fd_sc_hd__decap_3
X_5995_ _5995_/A _5995_/B _5995_/C _5995_/D VGND VGND VPWR VPWR _5998_/B sky130_fd_sc_hd__or4_4
X_4946_ _4946_/A _4946_/B VGND VGND VPWR VPWR _4946_/Y sky130_fd_sc_hd__nand2_2
XFILLER_32_280 VGND VGND VPWR VPWR sky130_fd_sc_hd__decap_3
XFILLER_32_291 VGND VGND VPWR VPWR sky130_fd_sc_hd__decap_3
X_4877_ _4900_/A _4849_/A _4923_/A _6460_/A2 wire423/X wire374/X VGND VGND VPWR VPWR
+ _4877_/X sky130_fd_sc_hd__mux4_2
X_3828_ _3825_/Y _3827_/X _3876_/S VGND VGND VPWR VPWR _3828_/X sky130_fd_sc_hd__mux2_2
X_3759_ _3468_/X _3520_/X _3711_/X _3758_/X _3469_/S _3799_/A VGND VGND VPWR VPWR
+ _3759_/X sky130_fd_sc_hd__mux4_2
X_6478_ _6486_/A _6486_/B _6486_/C _6485_/B _6477_/Y VGND VGND VPWR VPWR _6478_/X
+ sky130_fd_sc_hd__a41o_2
X_5429_ _5429_/A _5429_/B _5429_/C _5429_/D VGND VGND VPWR VPWR _5429_/X sky130_fd_sc_hd__or4_2
XFILLER_47_306 VGND VGND VPWR VPWR sky130_fd_sc_hd__decap_3
XFILLER_74_158 VGND VGND VPWR VPWR sky130_fd_sc_hd__decap_3
XFILLER_62_309 VGND VGND VPWR VPWR sky130_fd_sc_hd__decap_3
XFILLER_55_372 VGND VGND VPWR VPWR sky130_fd_sc_hd__decap_3
XTAP_TAPCELL_ROW_73_838 VGND VPWR sky130_fd_sc_hd__tapvpwrvgnd_1
XTAP_TAPCELL_ROW_2_195 VGND VPWR sky130_fd_sc_hd__tapvpwrvgnd_1
XFILLER_15_247 VGND VGND VPWR VPWR sky130_fd_sc_hd__decap_3
XPHY_EDGE_ROW_4_Left_87 VGND VGND VPWR VPWR sky130_fd_sc_hd__decap_3
XFILLER_11_420 VGND VGND VPWR VPWR sky130_fd_sc_hd__decap_3
XFILLER_46_350 VGND VGND VPWR VPWR sky130_fd_sc_hd__decap_3
XTAP_TAPCELL_ROW_36_507 VGND VPWR sky130_fd_sc_hd__tapvpwrvgnd_1
XFILLER_46_394 VGND VGND VPWR VPWR sky130_fd_sc_hd__decap_3
XFILLER_61_320 VGND VGND VPWR VPWR sky130_fd_sc_hd__decap_3
X_4800_ _4800_/A _4800_/B VGND VGND VPWR VPWR _4801_/A sky130_fd_sc_hd__nand2_2
XFILLER_73_191 VGND VGND VPWR VPWR sky130_fd_sc_hd__decap_3
XFILLER_21_206 VGND VGND VPWR VPWR sky130_fd_sc_hd__fill_2
X_5780_ _5885_/A VGND VGND VPWR VPWR _5809_/B sky130_fd_sc_hd__inv_2
XTAP_TAPCELL_ROW_44_573 VGND VPWR sky130_fd_sc_hd__tapvpwrvgnd_1
XFILLER_61_364 VGND VGND VPWR VPWR sky130_fd_sc_hd__decap_3
X_4731_ _4731_/A VGND VGND VPWR VPWR _4783_/B sky130_fd_sc_hd__inv_2
XFILLER_9_41 VGND VGND VPWR VPWR sky130_fd_sc_hd__fill_1
X_4662_ _6252_/A _4679_/B _4621_/B _4783_/A _6243_/C VGND VGND VPWR VPWR _4662_/X
+ sky130_fd_sc_hd__o2111a_2
X_6401_ _6401_/A VGND VGND VPWR VPWR _6401_/Y sky130_fd_sc_hd__inv_2
X_3613_ _3612_/A _3612_/B _3301_/A VGND VGND VPWR VPWR _3685_/B sky130_fd_sc_hd__o21ai_2
X_4593_ _4414_/X _4592_/X _4721_/S VGND VGND VPWR VPWR _4593_/X sky130_fd_sc_hd__mux2_2
X_6332_ _6332_/A _6332_/B VGND VGND VPWR VPWR _6332_/Y sky130_fd_sc_hd__xnor2_2
X_3544_ _3418_/X _3539_/X _3540_/Y _3542_/X _3704_/A VGND VGND VPWR VPWR _3544_/X
+ sky130_fd_sc_hd__o32a_2
X_6263_ _4751_/A _6256_/X _6257_/X _4734_/A _6262_/X VGND VGND VPWR VPWR _6263_/X
+ sky130_fd_sc_hd__a221o_2
X_3475_ _3761_/S _3679_/A _4473_/A VGND VGND VPWR VPWR _3475_/X sky130_fd_sc_hd__or3_2
X_5214_ _5214_/A _5214_/B VGND VGND VPWR VPWR _5214_/X sky130_fd_sc_hd__xor2_2
X_6194_ _6194_/A _6194_/B VGND VGND VPWR VPWR _6194_/Y sky130_fd_sc_hd__nor2_2
XFILLER_29_328 VGND VGND VPWR VPWR sky130_fd_sc_hd__decap_3
X_5145_ _5348_/A _5191_/B VGND VGND VPWR VPWR _5145_/Y sky130_fd_sc_hd__nor2_2
XFILLER_56_125 VGND VGND VPWR VPWR sky130_fd_sc_hd__fill_1
XFILLER_56_147 VGND VGND VPWR VPWR sky130_fd_sc_hd__decap_3
X_5076_ _5624_/A _5076_/B _5624_/C VGND VGND VPWR VPWR _5076_/X sky130_fd_sc_hd__or3_2
XFILLER_44_309 VGND VGND VPWR VPWR sky130_fd_sc_hd__decap_3
X_4027_ _4027_/A _4027_/B VGND VGND VPWR VPWR _4027_/X sky130_fd_sc_hd__or2_2
XFILLER_44_27 VGND VGND VPWR VPWR sky130_fd_sc_hd__fill_1
XTAP_TAPCELL_ROW_70_808 VGND VPWR sky130_fd_sc_hd__tapvpwrvgnd_1
X_5978_ _5934_/Y _5977_/X _5918_/A _6410_/A VGND VGND VPWR VPWR _6422_/A sky130_fd_sc_hd__o2bb2a_2
X_4929_ _5440_/A _5176_/S _4973_/A VGND VGND VPWR VPWR _4929_/X sky130_fd_sc_hd__and3_2
XFILLER_20_272 VGND VGND VPWR VPWR sky130_fd_sc_hd__decap_3
XTAP_TAPCELL_ROW_7_243 VGND VPWR sky130_fd_sc_hd__tapvpwrvgnd_1
XFILLER_75_434 VGND VGND VPWR VPWR sky130_fd_sc_hd__fill_1
XFILLER_47_169 VGND VGND VPWR VPWR sky130_fd_sc_hd__decap_3
XTAP_TAPCELL_ROW_58_698 VGND VPWR sky130_fd_sc_hd__tapvpwrvgnd_1
XFILLER_43_331 VGND VGND VPWR VPWR sky130_fd_sc_hd__decap_3
XFILLER_70_150 VGND VGND VPWR VPWR sky130_fd_sc_hd__fill_2
XFILLER_34_71 VGND VGND VPWR VPWR sky130_fd_sc_hd__fill_1
XFILLER_70_183 VGND VGND VPWR VPWR sky130_fd_sc_hd__decap_3
X_3260_ _3367_/A _3361_/C _3260_/C VGND VGND VPWR VPWR _3260_/X sky130_fd_sc_hd__or3_2
XFILLER_15_3 VGND VGND VPWR VPWR sky130_fd_sc_hd__fill_2
XTAP_TAPCELL_ROW_49_621 VGND VPWR sky130_fd_sc_hd__tapvpwrvgnd_1
XFILLER_19_361 VGND VGND VPWR VPWR sky130_fd_sc_hd__decap_3
X_5901_ _5932_/A _5923_/A _5946_/A3 _5874_/A _5963_/S0 _5963_/S1 VGND VGND VPWR VPWR
+ _5901_/X sky130_fd_sc_hd__mux4_2
X_5832_ _5938_/A1 wire263/X _5866_/A VGND VGND VPWR VPWR _5832_/X sky130_fd_sc_hd__mux2_2
X_5763_ _5763_/A _5763_/B VGND VGND VPWR VPWR _5763_/Y sky130_fd_sc_hd__xnor2_2
X_4714_ _4734_/A VGND VGND VPWR VPWR _4715_/S sky130_fd_sc_hd__inv_2
X_5694_ _5688_/X _5692_/X _5693_/X _5658_/A VGND VGND VPWR VPWR _5695_/B sky130_fd_sc_hd__a22oi_2
X_4645_ _4940_/A _4941_/A _6252_/A VGND VGND VPWR VPWR _4645_/X sky130_fd_sc_hd__mux2_2
X_4576_ _4443_/A _4443_/B _4616_/B _4582_/S _6232_/A VGND VGND VPWR VPWR _4576_/Y
+ sky130_fd_sc_hd__a2111oi_2
X_6315_ _6330_/B _6330_/D VGND VGND VPWR VPWR _6333_/B sky130_fd_sc_hd__or2_2
X_3527_ _3273_/X _3526_/X _3527_/S VGND VGND VPWR VPWR _3527_/X sky130_fd_sc_hd__mux2_2
X_6246_ _6067_/B _6067_/C _6247_/A VGND VGND VPWR VPWR _6246_/Y sky130_fd_sc_hd__a21oi_2
X_3458_ _6440_/A0 _6440_/A1 _6428_/A0 _6429_/B _3499_/S1 _3631_/S1 VGND VGND VPWR
+ VPWR _3458_/X sky130_fd_sc_hd__mux4_2
X_6177_ _6175_/Y _6176_/X _6178_/B VGND VGND VPWR VPWR _6177_/Y sky130_fd_sc_hd__a21oi_2
X_3389_ _3316_/X _3314_/X _3387_/X _3388_/X _3559_/D _3881_/S1 VGND VGND VPWR VPWR
+ _3389_/X sky130_fd_sc_hd__mux4_2
XTAP_TAPCELL_ROW_4_213 VGND VPWR sky130_fd_sc_hd__tapvpwrvgnd_1
XFILLER_69_250 VGND VGND VPWR VPWR sky130_fd_sc_hd__decap_3
X_5128_ _5128_/A _6275_/B VGND VGND VPWR VPWR _5128_/X sky130_fd_sc_hd__or2_2
XFILLER_29_169 VGND VGND VPWR VPWR sky130_fd_sc_hd__decap_3
XFILLER_44_117 VGND VGND VPWR VPWR sky130_fd_sc_hd__decap_3
X_5059_ _4797_/X _5071_/A _5055_/Y _5057_/X _5058_/Y VGND VGND VPWR VPWR _5059_/X
+ sky130_fd_sc_hd__o221a_2
XFILLER_25_331 VGND VGND VPWR VPWR sky130_fd_sc_hd__decap_3
XFILLER_52_150 VGND VGND VPWR VPWR sky130_fd_sc_hd__decap_3
XFILLER_40_312 VGND VGND VPWR VPWR sky130_fd_sc_hd__decap_3
XFILLER_52_194 VGND VGND VPWR VPWR sky130_fd_sc_hd__fill_2
XFILLER_40_345 VGND VGND VPWR VPWR sky130_fd_sc_hd__fill_2
XFILLER_40_356 VGND VGND VPWR VPWR sky130_fd_sc_hd__decap_3
XFILLER_40_389 VGND VGND VPWR VPWR sky130_fd_sc_hd__decap_3
XFILLER_48_401 VGND VGND VPWR VPWR sky130_fd_sc_hd__decap_3
XFILLER_67_209 VGND VGND VPWR VPWR sky130_fd_sc_hd__decap_3
XFILLER_48_445 VGND VGND VPWR VPWR sky130_fd_sc_hd__decap_3
XFILLER_29_93 VGND VGND VPWR VPWR sky130_fd_sc_hd__fill_1
XFILLER_75_253 VGND VGND VPWR VPWR sky130_fd_sc_hd__decap_3
XFILLER_75_231 VGND VGND VPWR VPWR sky130_fd_sc_hd__decap_3
XFILLER_35_139 VGND VGND VPWR VPWR sky130_fd_sc_hd__decap_3
XTAP_TAPCELL_ROW_18_337 VGND VPWR sky130_fd_sc_hd__tapvpwrvgnd_1
XFILLER_43_150 VGND VGND VPWR VPWR sky130_fd_sc_hd__decap_3
XFILLER_45_92 VGND VGND VPWR VPWR sky130_fd_sc_hd__decap_3
XFILLER_50_109 VGND VGND VPWR VPWR sky130_fd_sc_hd__decap_3
XFILLER_16_386 VGND VGND VPWR VPWR sky130_fd_sc_hd__decap_3
XPHY_EDGE_ROW_7_Left_90 VGND VGND VPWR VPWR sky130_fd_sc_hd__decap_3
XANTENNA_2 _4199_/A VGND VGND VPWR VPWR sky130_fd_sc_hd__diode_2
X_4430_ _4430_/A _4430_/B _4449_/A _4449_/C VGND VGND VPWR VPWR _4431_/B sky130_fd_sc_hd__or4_2
X_6100_ _6100_/A _6100_/B _6100_/C input1/X VGND VGND VPWR VPWR _6113_/C sky130_fd_sc_hd__and4_2
X_4361_ _4361_/A _4709_/B _4709_/C VGND VGND VPWR VPWR _4362_/A sky130_fd_sc_hd__or3_2
Xfanout509 _6449_/A1 VGND VGND VPWR VPWR _5352_/A sky130_fd_sc_hd__clkdlybuf4s25_1
X_4292_ _4355_/B _4202_/A _4370_/A _4356_/A VGND VGND VPWR VPWR _4292_/X sky130_fd_sc_hd__o2bb2a_2
X_3312_ _3780_/A _3312_/B VGND VGND VPWR VPWR _3312_/X sky130_fd_sc_hd__and2_2
X_6031_ _6374_/B _6374_/C _6374_/D VGND VGND VPWR VPWR _6032_/A sky130_fd_sc_hd__and3_2
X_3243_ _5853_/A _6486_/B _6486_/A _5968_/A VGND VGND VPWR VPWR _4372_/B sky130_fd_sc_hd__nand4b_2
XFILLER_58_209 VGND VGND VPWR VPWR sky130_fd_sc_hd__decap_3
XFILLER_66_253 VGND VGND VPWR VPWR sky130_fd_sc_hd__decap_3
XFILLER_66_242 VGND VGND VPWR VPWR sky130_fd_sc_hd__decap_3
XTAP_TAPCELL_ROW_80_903 VGND VPWR sky130_fd_sc_hd__tapvpwrvgnd_1
XFILLER_22_312 VGND VGND VPWR VPWR sky130_fd_sc_hd__fill_1
XFILLER_34_172 VGND VGND VPWR VPWR sky130_fd_sc_hd__decap_3
X_5815_ _6400_/B _5822_/B VGND VGND VPWR VPWR _5815_/X sky130_fd_sc_hd__or2_2
XTAP_TAPCELL_ROW_52_649 VGND VPWR sky130_fd_sc_hd__tapvpwrvgnd_1
XFILLER_22_389 VGND VGND VPWR VPWR sky130_fd_sc_hd__decap_3
X_5746_ _5627_/A _5726_/Y _5745_/X VGND VGND VPWR VPWR _5983_/B sky130_fd_sc_hd__a21o_2
X_5677_ _5714_/A _5714_/B VGND VGND VPWR VPWR _5678_/A sky130_fd_sc_hd__nor2_2
X_4628_ _4774_/A _4455_/B VGND VGND VPWR VPWR _4629_/B sky130_fd_sc_hd__or2b_2
Xmax_cap260 _5224_/X VGND VGND VPWR VPWR _5938_/A1 sky130_fd_sc_hd__clkbuf_2
X_4559_ _5216_/A _4557_/Y _4558_/Y _4235_/A VGND VGND VPWR VPWR _4560_/A sky130_fd_sc_hd__o31a_2
Xmax_cap293 _3400_/Y VGND VGND VPWR VPWR _5510_/A sky130_fd_sc_hd__buf_2
X_6229_ _6233_/C _6232_/C VGND VGND VPWR VPWR _6229_/X sky130_fd_sc_hd__and2_2
XFILLER_57_242 VGND VGND VPWR VPWR sky130_fd_sc_hd__decap_3
XFILLER_57_275 VGND VGND VPWR VPWR sky130_fd_sc_hd__decap_3
XTAP_TAPCELL_ROW_68_793 VGND VPWR sky130_fd_sc_hd__tapvpwrvgnd_1
XFILLER_82_24 VGND VGND VPWR VPWR sky130_fd_sc_hd__decap_3
XFILLER_72_267 VGND VGND VPWR VPWR sky130_fd_sc_hd__fill_1
XFILLER_60_407 VGND VGND VPWR VPWR sky130_fd_sc_hd__decap_3
XFILLER_13_312 VGND VGND VPWR VPWR sky130_fd_sc_hd__decap_3
XFILLER_25_161 VGND VGND VPWR VPWR sky130_fd_sc_hd__decap_3
XTAP_TAPCELL_ROW_15_318 VGND VPWR sky130_fd_sc_hd__tapvpwrvgnd_1
XFILLER_15_95 VGND VGND VPWR VPWR sky130_fd_sc_hd__decap_3
XFILLER_40_186 VGND VGND VPWR VPWR sky130_fd_sc_hd__decap_3
XFILLER_9_327 VGND VGND VPWR VPWR sky130_fd_sc_hd__decap_3
XFILLER_40_197 VGND VGND VPWR VPWR sky130_fd_sc_hd__decap_3
XTAP_TAPCELL_ROW_23_384 VGND VPWR sky130_fd_sc_hd__tapvpwrvgnd_1
XFILLER_31_83 VGND VGND VPWR VPWR sky130_fd_sc_hd__fill_1
XFILLER_48_253 VGND VGND VPWR VPWR sky130_fd_sc_hd__decap_3
XFILLER_36_426 VGND VGND VPWR VPWR sky130_fd_sc_hd__fill_1
XFILLER_48_264 VGND VGND VPWR VPWR sky130_fd_sc_hd__fill_2
XFILLER_48_286 VGND VGND VPWR VPWR sky130_fd_sc_hd__fill_1
X_3930_ input9/X _6464_/A1 _4014_/S VGND VGND VPWR VPWR _3930_/X sky130_fd_sc_hd__mux2_2
XFILLER_63_267 VGND VGND VPWR VPWR sky130_fd_sc_hd__decap_3
XFILLER_31_120 VGND VGND VPWR VPWR sky130_fd_sc_hd__decap_3
X_3861_ _3908_/A _6062_/D VGND VGND VPWR VPWR _3921_/B sky130_fd_sc_hd__xnor2_2
XFILLER_31_164 VGND VGND VPWR VPWR sky130_fd_sc_hd__decap_3
X_5600_ _5648_/A _5647_/B VGND VGND VPWR VPWR _5712_/C sky130_fd_sc_hd__nor2_2
X_3792_ _3595_/X _3791_/X _3799_/A VGND VGND VPWR VPWR _3792_/X sky130_fd_sc_hd__mux2_2
X_5531_ _5117_/A _5117_/B _5527_/X _5530_/X VGND VGND VPWR VPWR _5532_/C sky130_fd_sc_hd__a22o_2
XFILLER_8_371 VGND VGND VPWR VPWR sky130_fd_sc_hd__fill_1
X_5462_ _5458_/X _5460_/Y _5530_/B _5434_/X VGND VGND VPWR VPWR _5465_/B sky130_fd_sc_hd__o211a_2
X_5393_ _6358_/A _6359_/A VGND VGND VPWR VPWR _5393_/Y sky130_fd_sc_hd__nand2_2
X_4413_ _6461_/A2 _6461_/A3 _4504_/S VGND VGND VPWR VPWR _4413_/X sky130_fd_sc_hd__mux2_2
X_4344_ _4355_/A _4322_/X _4323_/X _4325_/Y _4343_/X VGND VGND VPWR VPWR _4344_/X
+ sky130_fd_sc_hd__a221o_2
Xfanout339 input93/X VGND VGND VPWR VPWR _6247_/A sky130_fd_sc_hd__clkdlybuf4s25_1
X_6014_ _6090_/A _6014_/B VGND VGND VPWR VPWR _6015_/D sky130_fd_sc_hd__and2_2
X_4275_ _3527_/X _3529_/X _6108_/A VGND VGND VPWR VPWR _4275_/X sky130_fd_sc_hd__mux2_2
XFILLER_39_231 VGND VGND VPWR VPWR sky130_fd_sc_hd__decap_3
X_3226_ _5460_/A _5615_/A3 _6440_/A0 _6440_/A1 _3499_/S1 _3631_/S1 VGND VGND VPWR
+ VPWR _3226_/X sky130_fd_sc_hd__mux4_2
XFILLER_54_234 VGND VGND VPWR VPWR sky130_fd_sc_hd__fill_2
XFILLER_54_245 VGND VGND VPWR VPWR sky130_fd_sc_hd__decap_3
XFILLER_54_256 VGND VGND VPWR VPWR sky130_fd_sc_hd__decap_3
XTAP_TAPCELL_ROW_65_763 VGND VPWR sky130_fd_sc_hd__tapvpwrvgnd_1
XFILLER_52_27 VGND VGND VPWR VPWR sky130_fd_sc_hd__fill_1
XFILLER_22_197 VGND VGND VPWR VPWR sky130_fd_sc_hd__decap_3
X_5729_ _6349_/A _5688_/X _5692_/X _5728_/X VGND VGND VPWR VPWR _5729_/X sky130_fd_sc_hd__a31o_2
XFILLER_77_326 VGND VGND VPWR VPWR sky130_fd_sc_hd__decap_3
XFILLER_45_212 VGND VGND VPWR VPWR sky130_fd_sc_hd__decap_3
XFILLER_45_234 VGND VGND VPWR VPWR sky130_fd_sc_hd__decap_3
XTAP_TAPCELL_ROW_28_432 VGND VPWR sky130_fd_sc_hd__tapvpwrvgnd_1
XFILLER_33_407 VGND VGND VPWR VPWR sky130_fd_sc_hd__decap_3
XFILLER_45_256 VGND VGND VPWR VPWR sky130_fd_sc_hd__decap_3
XFILLER_13_142 VGND VGND VPWR VPWR sky130_fd_sc_hd__decap_3
XFILLER_60_248 VGND VGND VPWR VPWR sky130_fd_sc_hd__decap_3
XFILLER_9_102 VGND VGND VPWR VPWR sky130_fd_sc_hd__decap_3
XFILLER_13_197 VGND VGND VPWR VPWR sky130_fd_sc_hd__fill_2
XFILLER_41_495 VGND VGND VPWR VPWR sky130_fd_sc_hd__fill_1
XFILLER_47_6 VGND VGND VPWR VPWR sky130_fd_sc_hd__fill_1
XPHY_EDGE_ROW_79_Left_162 VGND VGND VPWR VPWR sky130_fd_sc_hd__decap_3
X_4060_ _3235_/X _3236_/X _3632_/X _3648_/X _4462_/S _4674_/S VGND VGND VPWR VPWR
+ _4060_/X sky130_fd_sc_hd__mux4_2
XFILLER_68_359 VGND VGND VPWR VPWR sky130_fd_sc_hd__decap_3
XTAP_TAPCELL_ROW_79_888 VGND VPWR sky130_fd_sc_hd__tapvpwrvgnd_1
XFILLER_36_212 VGND VGND VPWR VPWR sky130_fd_sc_hd__decap_3
XFILLER_36_245 VGND VGND VPWR VPWR sky130_fd_sc_hd__decap_3
XFILLER_36_256 VGND VGND VPWR VPWR sky130_fd_sc_hd__fill_1
XFILLER_36_278 VGND VGND VPWR VPWR sky130_fd_sc_hd__decap_3
XFILLER_51_237 VGND VGND VPWR VPWR sky130_fd_sc_hd__decap_3
X_4962_ _4962_/A _4962_/B VGND VGND VPWR VPWR _4962_/X sky130_fd_sc_hd__and2_2
XTAP_TAPCELL_ROW_62_733 VGND VPWR sky130_fd_sc_hd__tapvpwrvgnd_1
X_4893_ _4813_/X _4866_/Y _4874_/Y _4527_/A _4892_/X VGND VGND VPWR VPWR _6000_/A
+ sky130_fd_sc_hd__a221o_2
X_3913_ input8/X _6062_/D VGND VGND VPWR VPWR _3913_/X sky130_fd_sc_hd__and2b_2
XFILLER_32_473 VGND VGND VPWR VPWR sky130_fd_sc_hd__decap_3
X_3844_ _3427_/B _3501_/Y _3843_/X _3949_/S VGND VGND VPWR VPWR _3844_/Y sky130_fd_sc_hd__a22oi_2
X_3775_ _3774_/B _3774_/C _3860_/A VGND VGND VPWR VPWR _3776_/B sky130_fd_sc_hd__a21o_2
X_6494_ _6494_/A _6494_/B _6494_/C VGND VGND VPWR VPWR _6495_/A sky130_fd_sc_hd__and3_2
X_5514_ _6317_/S VGND VGND VPWR VPWR _6330_/A sky130_fd_sc_hd__inv_2
X_5445_ _3232_/X _5485_/B _5444_/X _5136_/A VGND VGND VPWR VPWR _5445_/X sky130_fd_sc_hd__a22o_2
X_5376_ _3594_/B _4056_/X _5375_/X VGND VGND VPWR VPWR _5376_/X sky130_fd_sc_hd__a21o_2
X_4327_ _3578_/B _5013_/B _6453_/A VGND VGND VPWR VPWR _4327_/X sky130_fd_sc_hd__mux2_2
XFILLER_59_337 VGND VGND VPWR VPWR sky130_fd_sc_hd__decap_3
X_4258_ _4258_/A _4263_/C VGND VGND VPWR VPWR _4258_/Y sky130_fd_sc_hd__nor2_2
XFILLER_27_234 VGND VGND VPWR VPWR sky130_fd_sc_hd__decap_3
X_4189_ _6458_/A1 _4175_/A _4189_/S VGND VGND VPWR VPWR _4189_/X sky130_fd_sc_hd__mux2_2
XFILLER_27_256 VGND VGND VPWR VPWR sky130_fd_sc_hd__decap_3
XFILLER_42_215 VGND VGND VPWR VPWR sky130_fd_sc_hd__decap_3
XTAP_TAPCELL_ROW_25_402 VGND VPWR sky130_fd_sc_hd__tapvpwrvgnd_1
XFILLER_42_259 VGND VGND VPWR VPWR sky130_fd_sc_hd__decap_3
XFILLER_12_85 VGND VGND VPWR VPWR sky130_fd_sc_hd__decap_3
Xfanout670 _5406_/A2 VGND VGND VPWR VPWR _6292_/A sky130_fd_sc_hd__clkdlybuf4s25_1
Xfanout692 input101/X VGND VGND VPWR VPWR _6274_/A sky130_fd_sc_hd__clkdlybuf4s25_1
XFILLER_18_223 VGND VGND VPWR VPWR sky130_fd_sc_hd__decap_3
XFILLER_58_392 VGND VGND VPWR VPWR sky130_fd_sc_hd__decap_3
XFILLER_18_245 VGND VGND VPWR VPWR sky130_fd_sc_hd__fill_1
XPHY_EDGE_ROW_16_Right_16 VGND VGND VPWR VPWR sky130_fd_sc_hd__decap_3
XFILLER_61_502 VGND VGND VPWR VPWR sky130_fd_sc_hd__fill_2
XFILLER_41_270 VGND VGND VPWR VPWR sky130_fd_sc_hd__decap_3
XFILLER_41_281 VGND VGND VPWR VPWR sky130_fd_sc_hd__decap_3
X_3560_ _3557_/Y _3559_/X _3486_/Y VGND VGND VPWR VPWR _3856_/B sky130_fd_sc_hd__o21a_2
XPHY_EDGE_ROW_25_Right_25 VGND VGND VPWR VPWR sky130_fd_sc_hd__decap_3
X_5230_ _3844_/Y _4841_/Y _5222_/Y _5440_/A _5229_/Y VGND VGND VPWR VPWR _5230_/X
+ sky130_fd_sc_hd__o221a_2
X_3491_ _3620_/A _3467_/Y _3481_/X _3485_/X _3490_/X VGND VGND VPWR VPWR _5988_/D
+ sky130_fd_sc_hd__o2111a_2
X_5161_ _5117_/A _5117_/B _5117_/C _5191_/B VGND VGND VPWR VPWR _5166_/A sky130_fd_sc_hd__a31oi_2
X_5092_ _6298_/A _5123_/C VGND VGND VPWR VPWR _5092_/Y sky130_fd_sc_hd__nand2_2
X_4112_ _6164_/A _6167_/A VGND VGND VPWR VPWR _4251_/B sky130_fd_sc_hd__nor2b_2
XFILLER_56_307 VGND VGND VPWR VPWR sky130_fd_sc_hd__fill_1
XFILLER_56_318 VGND VGND VPWR VPWR sky130_fd_sc_hd__decap_3
X_4043_ _4042_/A _4044_/B _4003_/A _4044_/C VGND VGND VPWR VPWR _4043_/X sky130_fd_sc_hd__o211a_2
XFILLER_49_381 VGND VGND VPWR VPWR sky130_fd_sc_hd__decap_3
XTAP_TAPCELL_ROW_39_527 VGND VPWR sky130_fd_sc_hd__tapvpwrvgnd_1
XPHY_EDGE_ROW_34_Right_34 VGND VGND VPWR VPWR sky130_fd_sc_hd__decap_3
XFILLER_24_215 VGND VGND VPWR VPWR sky130_fd_sc_hd__decap_3
X_5994_ _5994_/A _5994_/B _5994_/C VGND VGND VPWR VPWR _5995_/D sky130_fd_sc_hd__or3_2
XFILLER_64_384 VGND VGND VPWR VPWR sky130_fd_sc_hd__decap_3
XFILLER_24_259 VGND VGND VPWR VPWR sky130_fd_sc_hd__decap_3
X_4945_ _4945_/A VGND VGND VPWR VPWR _4946_/A sky130_fd_sc_hd__clkbuf_1
XFILLER_32_270 VGND VGND VPWR VPWR sky130_fd_sc_hd__fill_2
X_4876_ _5284_/S _5510_/A _4875_/X VGND VGND VPWR VPWR _4876_/X sky130_fd_sc_hd__o21ba_2
X_3827_ _3840_/S _3826_/Y VGND VGND VPWR VPWR _3827_/X sky130_fd_sc_hd__or2b_2
XPHY_EDGE_ROW_43_Right_43 VGND VGND VPWR VPWR sky130_fd_sc_hd__decap_3
X_3758_ _3754_/A _4086_/A _3758_/S VGND VGND VPWR VPWR _3758_/X sky130_fd_sc_hd__mux2_2
X_6477_ _6477_/A _6477_/B VGND VGND VPWR VPWR _6477_/Y sky130_fd_sc_hd__nor2_2
X_3689_ _3689_/A _3727_/A _3814_/B VGND VGND VPWR VPWR _3855_/B sky130_fd_sc_hd__and3_2
X_5428_ _5097_/S _6306_/A _5423_/A VGND VGND VPWR VPWR _5429_/D sky130_fd_sc_hd__a21o_2
X_5359_ _5573_/A _5572_/D _5359_/C _5573_/B VGND VGND VPWR VPWR _5360_/B sky130_fd_sc_hd__and4_2
XFILLER_58_26 VGND VGND VPWR VPWR sky130_fd_sc_hd__fill_2
XPHY_EDGE_ROW_52_Right_52 VGND VGND VPWR VPWR sky130_fd_sc_hd__decap_3
XFILLER_59_178 VGND VGND VPWR VPWR sky130_fd_sc_hd__decap_3
XFILLER_55_340 VGND VGND VPWR VPWR sky130_fd_sc_hd__decap_3
XFILLER_43_513 VGND VGND VPWR VPWR sky130_fd_sc_hd__decap_3
XFILLER_55_384 VGND VGND VPWR VPWR sky130_fd_sc_hd__decap_3
XTAP_TAPCELL_ROW_73_839 VGND VPWR sky130_fd_sc_hd__tapvpwrvgnd_1
XTAP_TAPCELL_ROW_2_196 VGND VPWR sky130_fd_sc_hd__tapvpwrvgnd_1
XFILLER_70_376 VGND VGND VPWR VPWR sky130_fd_sc_hd__fill_1
XFILLER_30_229 VGND VGND VPWR VPWR sky130_fd_sc_hd__decap_3
XPHY_EDGE_ROW_61_Right_61 VGND VGND VPWR VPWR sky130_fd_sc_hd__decap_3
Xwire312 _4106_/A VGND VGND VPWR VPWR _3432_/A sky130_fd_sc_hd__buf_2
Xwire323 _6167_/C VGND VGND VPWR VPWR _4183_/B sky130_fd_sc_hd__buf_2
XFILLER_7_447 VGND VGND VPWR VPWR sky130_fd_sc_hd__fill_1
XPHY_EDGE_ROW_70_Right_70 VGND VGND VPWR VPWR sky130_fd_sc_hd__decap_3
XFILLER_38_307 VGND VGND VPWR VPWR sky130_fd_sc_hd__fill_1
XFILLER_0_55 VGND VGND VPWR VPWR sky130_fd_sc_hd__fill_1
XFILLER_46_362 VGND VGND VPWR VPWR sky130_fd_sc_hd__fill_2
XFILLER_61_343 VGND VGND VPWR VPWR sky130_fd_sc_hd__decap_3
XFILLER_61_332 VGND VGND VPWR VPWR sky130_fd_sc_hd__decap_3
XTAP_TAPCELL_ROW_44_574 VGND VPWR sky130_fd_sc_hd__tapvpwrvgnd_1
XFILLER_61_376 VGND VGND VPWR VPWR sky130_fd_sc_hd__decap_3
XFILLER_14_281 VGND VGND VPWR VPWR sky130_fd_sc_hd__decap_3
X_4730_ _4751_/A _6244_/A VGND VGND VPWR VPWR _4731_/A sky130_fd_sc_hd__xnor2_2
X_4661_ _6243_/A _6243_/B _4660_/Y _4768_/B VGND VGND VPWR VPWR _4661_/X sky130_fd_sc_hd__o211a_2
X_6400_ _6400_/A _6400_/B VGND VGND VPWR VPWR _6400_/Y sky130_fd_sc_hd__xnor2_2
X_3612_ _3612_/A _3612_/B VGND VGND VPWR VPWR _3685_/A sky130_fd_sc_hd__nand2_2
X_6331_ _5591_/S _6328_/Y _6329_/Y _6330_/X VGND VGND VPWR VPWR _6331_/X sky130_fd_sc_hd__o211a_2
X_4592_ _4599_/A _6457_/A1 _6457_/A3 _4429_/A _4675_/S0 _4675_/S1 VGND VGND VPWR VPWR
+ _4592_/X sky130_fd_sc_hd__mux4_2
X_3543_ _3748_/A _4374_/A VGND VGND VPWR VPWR _3704_/A sky130_fd_sc_hd__nand2_2
X_6262_ _6262_/A _6262_/B VGND VGND VPWR VPWR _6262_/X sky130_fd_sc_hd__or2_2
X_3474_ _3761_/S _3640_/A VGND VGND VPWR VPWR _3474_/Y sky130_fd_sc_hd__nand2_2
X_6193_ _6191_/X _6192_/Y _6193_/S VGND VGND VPWR VPWR _6194_/B sky130_fd_sc_hd__mux2_2
X_5213_ _5210_/Y _5688_/A1 _5212_/X VGND VGND VPWR VPWR _5214_/B sky130_fd_sc_hd__a21o_2
X_5144_ _6391_/A _5144_/B VGND VGND VPWR VPWR _5210_/A sky130_fd_sc_hd__nand2_2
X_5075_ _5624_/A _5624_/C _5076_/B VGND VGND VPWR VPWR _5075_/Y sky130_fd_sc_hd__o21ai_2
XFILLER_37_340 VGND VGND VPWR VPWR sky130_fd_sc_hd__decap_3
X_4026_ _3574_/X _3569_/X _3649_/X _3654_/X _3949_/S _4026_/S1 VGND VGND VPWR VPWR
+ _4027_/B sky130_fd_sc_hd__mux4_2
XFILLER_64_170 VGND VGND VPWR VPWR sky130_fd_sc_hd__decap_3
XTAP_TAPCELL_ROW_70_809 VGND VPWR sky130_fd_sc_hd__tapvpwrvgnd_1
XFILLER_52_365 VGND VGND VPWR VPWR sky130_fd_sc_hd__decap_3
X_5977_ _5884_/A _5874_/B _5881_/B _5925_/A _5935_/A VGND VGND VPWR VPWR _5977_/X
+ sky130_fd_sc_hd__a221o_2
X_4928_ _5535_/A _4928_/B VGND VGND VPWR VPWR _4928_/X sky130_fd_sc_hd__xor2_2
XFILLER_20_251 VGND VGND VPWR VPWR sky130_fd_sc_hd__fill_1
XFILLER_60_27 VGND VGND VPWR VPWR sky130_fd_sc_hd__fill_1
XFILLER_20_284 VGND VGND VPWR VPWR sky130_fd_sc_hd__decap_3
X_4859_ _4813_/X _4916_/C _4824_/X _4852_/Y _4858_/Y VGND VGND VPWR VPWR _5999_/C
+ sky130_fd_sc_hd__a311o_2
XTAP_TAPCELL_ROW_7_244 VGND VPWR sky130_fd_sc_hd__tapvpwrvgnd_1
XFILLER_47_137 VGND VGND VPWR VPWR sky130_fd_sc_hd__decap_3
XFILLER_28_351 VGND VGND VPWR VPWR sky130_fd_sc_hd__decap_3
XTAP_TAPCELL_ROW_58_699 VGND VPWR sky130_fd_sc_hd__tapvpwrvgnd_1
XFILLER_62_129 VGND VGND VPWR VPWR sky130_fd_sc_hd__decap_3
XFILLER_28_395 VGND VGND VPWR VPWR sky130_fd_sc_hd__fill_2
XFILLER_43_343 VGND VGND VPWR VPWR sky130_fd_sc_hd__decap_3
XFILLER_43_376 VGND VGND VPWR VPWR sky130_fd_sc_hd__decap_3
XFILLER_34_61 VGND VGND VPWR VPWR sky130_fd_sc_hd__fill_2
XFILLER_70_195 VGND VGND VPWR VPWR sky130_fd_sc_hd__fill_1
XTAP_TAPCELL_ROW_41_544 VGND VPWR sky130_fd_sc_hd__tapvpwrvgnd_1
XFILLER_11_284 VGND VGND VPWR VPWR sky130_fd_sc_hd__decap_3
XFILLER_78_262 VGND VGND VPWR VPWR sky130_fd_sc_hd__decap_3
XFILLER_59_91 VGND VGND VPWR VPWR sky130_fd_sc_hd__fill_2
XTAP_TAPCELL_ROW_49_622 VGND VPWR sky130_fd_sc_hd__tapvpwrvgnd_1
XFILLER_38_148 VGND VGND VPWR VPWR sky130_fd_sc_hd__decap_3
XFILLER_19_384 VGND VGND VPWR VPWR sky130_fd_sc_hd__decap_3
XFILLER_53_129 VGND VGND VPWR VPWR sky130_fd_sc_hd__decap_3
X_5900_ _5899_/Y _5909_/A _5935_/A VGND VGND VPWR VPWR _5900_/X sky130_fd_sc_hd__mux2_2
XFILLER_34_321 VGND VGND VPWR VPWR sky130_fd_sc_hd__decap_3
XFILLER_46_181 VGND VGND VPWR VPWR sky130_fd_sc_hd__decap_3
XFILLER_34_365 VGND VGND VPWR VPWR sky130_fd_sc_hd__decap_3
X_5831_ _6400_/A _5866_/A VGND VGND VPWR VPWR _5874_/C sky130_fd_sc_hd__and2b_2
X_5762_ _6486_/C _5762_/B _6495_/B VGND VGND VPWR VPWR _5763_/B sky130_fd_sc_hd__and3_2
XFILLER_61_184 VGND VGND VPWR VPWR sky130_fd_sc_hd__fill_2
X_4713_ _5178_/A _6247_/A VGND VGND VPWR VPWR _4713_/Y sky130_fd_sc_hd__nor2_2
X_5693_ _5639_/A _5639_/B _5639_/C _6374_/B VGND VGND VPWR VPWR _5693_/X sky130_fd_sc_hd__a31o_2
X_4644_ _6243_/A VGND VGND VPWR VPWR _6252_/A sky130_fd_sc_hd__inv_2
X_4575_ _6233_/A _4616_/B _4582_/S VGND VGND VPWR VPWR _4575_/Y sky130_fd_sc_hd__nor3_2
XTAP_TAPCELL_ROW_12_290 VGND VPWR sky130_fd_sc_hd__tapvpwrvgnd_1
X_6314_ _6330_/A _6326_/C VGND VGND VPWR VPWR _6314_/Y sky130_fd_sc_hd__nand2_2
X_3526_ _6447_/A0 _6447_/A3 _6447_/A1 input34/X _3526_/S0 _6447_/S0 VGND VGND VPWR
+ VPWR _3526_/X sky130_fd_sc_hd__mux4_2
X_6245_ _4751_/A _6244_/Y _4734_/A VGND VGND VPWR VPWR _6245_/X sky130_fd_sc_hd__o21a_2
X_3457_ _3842_/S VGND VGND VPWR VPWR _3970_/A sky130_fd_sc_hd__clkbuf_1
X_6176_ _6176_/A _6176_/B _6200_/C VGND VGND VPWR VPWR _6176_/X sky130_fd_sc_hd__or3_2
X_3388_ _4239_/A _6199_/B _6208_/A _6457_/A3 _4504_/S _3948_/S1 VGND VGND VPWR VPWR
+ _3388_/X sky130_fd_sc_hd__mux4_2
XTAP_TAPCELL_ROW_4_214 VGND VPWR sky130_fd_sc_hd__tapvpwrvgnd_1
XFILLER_57_402 VGND VGND VPWR VPWR sky130_fd_sc_hd__decap_3
Xload_slew681 _4931_/B2 VGND VGND VPWR VPWR _3592_/S sky130_fd_sc_hd__buf_2
X_5127_ _6275_/A _6274_/A _5124_/X _5125_/Y _5126_/Y VGND VGND VPWR VPWR _5127_/X
+ sky130_fd_sc_hd__a2111o_2
XPHY_EDGE_ROW_24_Left_107 VGND VGND VPWR VPWR sky130_fd_sc_hd__decap_3
XFILLER_29_159 VGND VGND VPWR VPWR sky130_fd_sc_hd__decap_3
X_5058_ _6298_/A _5058_/B VGND VGND VPWR VPWR _5058_/Y sky130_fd_sc_hd__nand2_2
XPHY_EDGE_ROW_2_Right_2 VGND VGND VPWR VPWR sky130_fd_sc_hd__decap_3
XFILLER_44_107 VGND VGND VPWR VPWR sky130_fd_sc_hd__decap_3
XFILLER_44_129 VGND VGND VPWR VPWR sky130_fd_sc_hd__fill_1
X_4009_ _3581_/X _3625_/B _3631_/X _3624_/X _3592_/S _3625_/A VGND VGND VPWR VPWR
+ _4009_/X sky130_fd_sc_hd__mux4_2
XFILLER_37_181 VGND VGND VPWR VPWR sky130_fd_sc_hd__decap_3
XFILLER_40_302 VGND VGND VPWR VPWR sky130_fd_sc_hd__decap_3
XFILLER_40_324 VGND VGND VPWR VPWR sky130_fd_sc_hd__decap_3
XFILLER_40_368 VGND VGND VPWR VPWR sky130_fd_sc_hd__decap_3
XPHY_EDGE_ROW_33_Left_116 VGND VGND VPWR VPWR sky130_fd_sc_hd__decap_3
XPHY_EDGE_ROW_42_Left_125 VGND VGND VPWR VPWR sky130_fd_sc_hd__decap_3
XFILLER_48_413 VGND VGND VPWR VPWR sky130_fd_sc_hd__decap_3
XFILLER_75_210 VGND VGND VPWR VPWR sky130_fd_sc_hd__decap_3
XFILLER_75_243 VGND VGND VPWR VPWR sky130_fd_sc_hd__fill_2
XTAP_TAPCELL_ROW_18_338 VGND VPWR sky130_fd_sc_hd__tapvpwrvgnd_1
XFILLER_31_335 VGND VGND VPWR VPWR sky130_fd_sc_hd__fill_1
XFILLER_43_162 VGND VGND VPWR VPWR sky130_fd_sc_hd__decap_3
XPHY_EDGE_ROW_51_Left_134 VGND VGND VPWR VPWR sky130_fd_sc_hd__decap_3
XFILLER_31_346 VGND VGND VPWR VPWR sky130_fd_sc_hd__decap_3
XANTENNA_3 _4849_/B VGND VGND VPWR VPWR sky130_fd_sc_hd__diode_2
X_4360_ _4360_/A _4360_/B _4708_/A _4360_/D VGND VGND VPWR VPWR _5534_/A sky130_fd_sc_hd__or4_2
X_3311_ _3305_/Y _3985_/B _3309_/X _3310_/Y VGND VGND VPWR VPWR _3312_/B sky130_fd_sc_hd__a22o_2
X_4291_ _6173_/A _6199_/A VGND VGND VPWR VPWR _4356_/A sky130_fd_sc_hd__nand2b_2
XPHY_EDGE_ROW_60_Left_143 VGND VGND VPWR VPWR sky130_fd_sc_hd__decap_3
X_6030_ _6344_/A _6332_/A _6344_/B VGND VGND VPWR VPWR _6374_/D sky130_fd_sc_hd__and3_2
X_3242_ _3242_/A VGND VGND VPWR VPWR _4884_/B sky130_fd_sc_hd__buf_1
XFILLER_54_405 VGND VGND VPWR VPWR sky130_fd_sc_hd__decap_3
XFILLER_66_265 VGND VGND VPWR VPWR sky130_fd_sc_hd__decap_3
XFILLER_19_181 VGND VGND VPWR VPWR sky130_fd_sc_hd__decap_3
XFILLER_81_279 VGND VGND VPWR VPWR sky130_fd_sc_hd__fill_1
XFILLER_34_184 VGND VGND VPWR VPWR sky130_fd_sc_hd__decap_3
X_5814_ _5822_/A _5822_/B VGND VGND VPWR VPWR _5814_/Y sky130_fd_sc_hd__nand2_2
X_5745_ _5951_/A1 _5726_/A _5731_/X _5396_/A _5744_/X VGND VGND VPWR VPWR _5745_/X
+ sky130_fd_sc_hd__a221o_2
X_5676_ _5553_/S _5710_/B _5710_/A _5674_/B VGND VGND VPWR VPWR _5714_/B sky130_fd_sc_hd__o31a_2
X_4627_ _4627_/A _4627_/B _4627_/C _6194_/A VGND VGND VPWR VPWR _4774_/A sky130_fd_sc_hd__nand4_2
X_4558_ _4558_/A VGND VGND VPWR VPWR _4558_/Y sky130_fd_sc_hd__inv_2
Xmax_cap294 _3694_/B VGND VGND VPWR VPWR _4849_/C sky130_fd_sc_hd__buf_2
Xmax_cap283 _4945_/A VGND VGND VPWR VPWR _5658_/C sky130_fd_sc_hd__buf_2
Xmax_cap272 _3641_/B VGND VGND VPWR VPWR _4111_/A sky130_fd_sc_hd__clkbuf_2
X_4489_ _4487_/X _4489_/B VGND VGND VPWR VPWR _4539_/B sky130_fd_sc_hd__and2b_2
X_3509_ _3703_/A _4286_/B _3508_/Y VGND VGND VPWR VPWR _3509_/X sky130_fd_sc_hd__a21o_2
X_6228_ _6233_/C _6232_/C VGND VGND VPWR VPWR _6228_/X sky130_fd_sc_hd__or2_2
X_6159_ _4049_/S _6157_/Y _6158_/Y _4042_/A VGND VGND VPWR VPWR _6159_/X sky130_fd_sc_hd__a22o_2
XFILLER_57_254 VGND VGND VPWR VPWR sky130_fd_sc_hd__decap_3
XTAP_TAPCELL_ROW_68_794 VGND VPWR sky130_fd_sc_hd__tapvpwrvgnd_1
XFILLER_25_184 VGND VGND VPWR VPWR sky130_fd_sc_hd__decap_3
XFILLER_40_110 VGND VGND VPWR VPWR sky130_fd_sc_hd__decap_3
XFILLER_13_346 VGND VGND VPWR VPWR sky130_fd_sc_hd__fill_1
XFILLER_21_390 VGND VGND VPWR VPWR sky130_fd_sc_hd__fill_2
XTAP_TAPCELL_ROW_23_385 VGND VPWR sky130_fd_sc_hd__tapvpwrvgnd_1
XFILLER_31_73 VGND VGND VPWR VPWR sky130_fd_sc_hd__decap_3
XFILLER_48_243 VGND VGND VPWR VPWR sky130_fd_sc_hd__decap_3
XFILLER_63_202 VGND VGND VPWR VPWR sky130_fd_sc_hd__decap_3
XFILLER_63_246 VGND VGND VPWR VPWR sky130_fd_sc_hd__decap_3
XFILLER_63_213 VGND VGND VPWR VPWR sky130_fd_sc_hd__fill_2
XFILLER_51_408 VGND VGND VPWR VPWR sky130_fd_sc_hd__fill_1
X_3860_ _3860_/A _3860_/B _4077_/B VGND VGND VPWR VPWR _3919_/B sky130_fd_sc_hd__or3b_2
X_3791_ _3812_/A _3664_/A _3791_/S VGND VGND VPWR VPWR _3791_/X sky130_fd_sc_hd__mux2_2
X_5530_ _5530_/A _5530_/B _5530_/C VGND VGND VPWR VPWR _5530_/X sky130_fd_sc_hd__or3_2
XFILLER_75_3 VGND VGND VPWR VPWR sky130_fd_sc_hd__decap_3
X_5461_ _5458_/X _5460_/Y _5117_/A _5117_/B _5434_/X VGND VGND VPWR VPWR _5465_/A
+ sky130_fd_sc_hd__o2111a_2
X_4412_ _4370_/A _4408_/X _4409_/Y _4410_/X _4411_/Y VGND VGND VPWR VPWR _4412_/X
+ sky130_fd_sc_hd__o221a_2
X_5392_ _5967_/B1 _5376_/X _5377_/X _5382_/X _5391_/X VGND VGND VPWR VPWR _5392_/X
+ sky130_fd_sc_hd__a221o_2
X_4343_ _4728_/A1 _4353_/C _4303_/Y _4342_/X VGND VGND VPWR VPWR _4343_/X sky130_fd_sc_hd__a31o_2
X_4274_ _6427_/A VGND VGND VPWR VPWR _6473_/S sky130_fd_sc_hd__clkbuf_2
XFILLER_39_210 VGND VGND VPWR VPWR sky130_fd_sc_hd__decap_3
X_6013_ _6013_/A _6113_/B _6013_/C VGND VGND VPWR VPWR _6090_/C sky130_fd_sc_hd__and3_2
X_3225_ _6439_/A3 _5712_/A _6440_/A3 _6440_/A2 _6439_/S0 _3780_/A VGND VGND VPWR VPWR
+ _3225_/X sky130_fd_sc_hd__mux4_2
XFILLER_39_243 VGND VGND VPWR VPWR sky130_fd_sc_hd__decap_3
XFILLER_39_276 VGND VGND VPWR VPWR sky130_fd_sc_hd__decap_3
XTAP_TAPCELL_ROW_65_764 VGND VPWR sky130_fd_sc_hd__tapvpwrvgnd_1
XFILLER_50_474 VGND VGND VPWR VPWR sky130_fd_sc_hd__fill_2
X_5728_ _6349_/A _6374_/C _5658_/A VGND VGND VPWR VPWR _5728_/X sky130_fd_sc_hd__o21a_2
X_3989_ _3594_/X _3979_/X _3980_/X _3580_/Y _3988_/X VGND VGND VPWR VPWR _3989_/X
+ sky130_fd_sc_hd__a221o_2
XTAP_TAPCELL_ROW_20_355 VGND VPWR sky130_fd_sc_hd__tapvpwrvgnd_1
X_5659_ _5714_/A _5477_/A _5654_/X _5656_/X _5658_/X VGND VGND VPWR VPWR _5659_/X
+ sky130_fd_sc_hd__a221o_2
XFILLER_26_40 VGND VGND VPWR VPWR sky130_fd_sc_hd__fill_1
XFILLER_45_246 VGND VGND VPWR VPWR sky130_fd_sc_hd__fill_2
XFILLER_45_268 VGND VGND VPWR VPWR sky130_fd_sc_hd__decap_3
XTAP_TAPCELL_ROW_28_433 VGND VPWR sky130_fd_sc_hd__tapvpwrvgnd_1
XFILLER_60_227 VGND VGND VPWR VPWR sky130_fd_sc_hd__decap_3
XFILLER_13_110 VGND VGND VPWR VPWR sky130_fd_sc_hd__fill_2
XFILLER_26_493 VGND VGND VPWR VPWR sky130_fd_sc_hd__fill_2
XFILLER_5_342 VGND VGND VPWR VPWR sky130_fd_sc_hd__decap_3
XFILLER_68_327 VGND VGND VPWR VPWR sky130_fd_sc_hd__decap_3
XFILLER_68_305 VGND VGND VPWR VPWR sky130_fd_sc_hd__decap_3
XTAP_TAPCELL_ROW_79_889 VGND VPWR sky130_fd_sc_hd__tapvpwrvgnd_1
XFILLER_36_224 VGND VGND VPWR VPWR sky130_fd_sc_hd__decap_3
XFILLER_24_408 VGND VGND VPWR VPWR sky130_fd_sc_hd__decap_3
XFILLER_51_205 VGND VGND VPWR VPWR sky130_fd_sc_hd__decap_3
X_4961_ _5108_/A _4997_/B _4997_/C VGND VGND VPWR VPWR _4962_/B sky130_fd_sc_hd__nand3_2
XTAP_TAPCELL_ROW_62_734 VGND VPWR sky130_fd_sc_hd__tapvpwrvgnd_1
XFILLER_44_290 VGND VGND VPWR VPWR sky130_fd_sc_hd__decap_3
XFILLER_51_249 VGND VGND VPWR VPWR sky130_fd_sc_hd__decap_3
X_4892_ _4881_/Y _4882_/X _4874_/B _4883_/X _4891_/X VGND VGND VPWR VPWR _4892_/X
+ sky130_fd_sc_hd__a221o_2
X_3912_ _4001_/A _3912_/B VGND VGND VPWR VPWR _3912_/X sky130_fd_sc_hd__xor2_2
XFILLER_32_452 VGND VGND VPWR VPWR sky130_fd_sc_hd__decap_3
X_3843_ _3645_/X _3842_/X _3942_/A VGND VGND VPWR VPWR _3843_/X sky130_fd_sc_hd__mux2_2
X_3774_ _3860_/A _3774_/B _3774_/C VGND VGND VPWR VPWR _3776_/A sky130_fd_sc_hd__nand3_2
X_6493_ _6493_/A _6493_/B VGND VGND VPWR VPWR _6493_/Y sky130_fd_sc_hd__nand2_2
X_5513_ _6485_/A _5530_/A VGND VGND VPWR VPWR _5513_/X sky130_fd_sc_hd__or2_2
X_5444_ _5859_/A _5444_/B VGND VGND VPWR VPWR _5444_/X sky130_fd_sc_hd__or2_2
X_5375_ _5706_/A1 _5704_/A _4057_/B VGND VGND VPWR VPWR _5375_/X sky130_fd_sc_hd__o21a_2
X_4326_ _4355_/B _4611_/A _4513_/B VGND VGND VPWR VPWR _4326_/Y sky130_fd_sc_hd__o21ai_2
X_4257_ _4430_/A _4354_/S VGND VGND VPWR VPWR _4266_/A sky130_fd_sc_hd__xnor2_2
XFILLER_59_349 VGND VGND VPWR VPWR sky130_fd_sc_hd__decap_3
X_4188_ _4875_/B _3389_/X _4502_/S VGND VGND VPWR VPWR _4188_/X sky130_fd_sc_hd__mux2_2
XFILLER_27_213 VGND VGND VPWR VPWR sky130_fd_sc_hd__decap_3
XTAP_TAPCELL_ROW_25_403 VGND VPWR sky130_fd_sc_hd__tapvpwrvgnd_1
XFILLER_35_290 VGND VGND VPWR VPWR sky130_fd_sc_hd__fill_2
XFILLER_50_271 VGND VGND VPWR VPWR sky130_fd_sc_hd__decap_3
XTAP_TAPCELL_ROW_33_480 VGND VPWR sky130_fd_sc_hd__tapvpwrvgnd_1
XFILLER_12_75 VGND VGND VPWR VPWR sky130_fd_sc_hd__fill_2
XFILLER_5_3 VGND VGND VPWR VPWR sky130_fd_sc_hd__fill_1
Xfanout660 _5503_/A2 VGND VGND VPWR VPWR _6322_/A sky130_fd_sc_hd__clkdlybuf4s25_1
XFILLER_46_500 VGND VGND VPWR VPWR sky130_fd_sc_hd__decap_3
Xfanout671 input107/X VGND VGND VPWR VPWR _6392_/B sky130_fd_sc_hd__clkdlybuf4s25_1
Xfanout682 _6442_/A VGND VGND VPWR VPWR _4150_/A sky130_fd_sc_hd__clkdlybuf4s25_1
Xfanout693 input101/X VGND VGND VPWR VPWR _6298_/A sky130_fd_sc_hd__clkdlybuf4s25_1
XTAP_TAPCELL_ROW_76_859 VGND VPWR sky130_fd_sc_hd__tapvpwrvgnd_1
XFILLER_58_371 VGND VGND VPWR VPWR sky130_fd_sc_hd__decap_3
XFILLER_18_257 VGND VGND VPWR VPWR sky130_fd_sc_hd__decap_3
XFILLER_33_249 VGND VGND VPWR VPWR sky130_fd_sc_hd__decap_3
XFILLER_41_293 VGND VGND VPWR VPWR sky130_fd_sc_hd__decap_3
X_3490_ _3488_/X _3489_/Y _3418_/X VGND VGND VPWR VPWR _3490_/X sky130_fd_sc_hd__a21o_2
X_5160_ _5160_/A _5160_/B VGND VGND VPWR VPWR _5168_/B sky130_fd_sc_hd__nand2_2
X_5091_ _6442_/A _4422_/A _5090_/Y _3708_/Y VGND VGND VPWR VPWR _5091_/X sky130_fd_sc_hd__a31o_2
X_4111_ _4111_/A VGND VGND VPWR VPWR _4202_/A sky130_fd_sc_hd__clkbuf_1
X_4042_ _4042_/A _4044_/B VGND VGND VPWR VPWR _4042_/Y sky130_fd_sc_hd__nor2_2
XTAP_TAPCELL_ROW_39_528 VGND VPWR sky130_fd_sc_hd__tapvpwrvgnd_1
X_5993_ _5993_/A _5993_/B _5993_/C _5993_/D VGND VGND VPWR VPWR _5995_/C sky130_fd_sc_hd__or4_2
X_4944_ _5906_/A1 _4939_/Y _4943_/X VGND VGND VPWR VPWR _4944_/X sky130_fd_sc_hd__a21o_2
XFILLER_64_396 VGND VGND VPWR VPWR sky130_fd_sc_hd__fill_1
X_4875_ _5176_/S _4875_/B VGND VGND VPWR VPWR _4875_/X sky130_fd_sc_hd__and2_2
X_3826_ _3826_/A _6126_/B VGND VGND VPWR VPWR _3826_/Y sky130_fd_sc_hd__nand2_2
X_3757_ _6126_/A _3640_/A _4241_/B _3752_/X _3756_/Y VGND VGND VPWR VPWR _3757_/X
+ sky130_fd_sc_hd__a221o_2
XTAP_TAPCELL_ROW_30_450 VGND VPWR sky130_fd_sc_hd__tapvpwrvgnd_1
X_6476_ _6476_/A _6476_/B VGND VGND VPWR VPWR _6477_/B sky130_fd_sc_hd__nand2_2
X_3688_ _3727_/A _3814_/B _3689_/A VGND VGND VPWR VPWR _3855_/A sky130_fd_sc_hd__a21oi_2
X_5427_ _5424_/X _5425_/X _5426_/X _5394_/B VGND VGND VPWR VPWR _5434_/A sky130_fd_sc_hd__a31o_2
X_5358_ _5259_/A _5259_/B _5299_/A _5319_/B VGND VGND VPWR VPWR _5573_/B sky130_fd_sc_hd__a211oi_2
X_4309_ _4355_/C _4305_/Y _4308_/X VGND VGND VPWR VPWR _4309_/Y sky130_fd_sc_hd__o21ai_2
XFILLER_59_113 VGND VGND VPWR VPWR sky130_fd_sc_hd__decap_3
X_5289_ wire282/X wire281/X _6294_/A VGND VGND VPWR VPWR _5289_/X sky130_fd_sc_hd__mux2_2
XFILLER_59_157 VGND VGND VPWR VPWR sky130_fd_sc_hd__decap_3
XFILLER_74_138 VGND VGND VPWR VPWR sky130_fd_sc_hd__fill_2
XFILLER_74_26 VGND VGND VPWR VPWR sky130_fd_sc_hd__fill_2
XFILLER_55_363 VGND VGND VPWR VPWR sky130_fd_sc_hd__decap_3
XTAP_TAPCELL_ROW_2_197 VGND VPWR sky130_fd_sc_hd__tapvpwrvgnd_1
XFILLER_55_396 VGND VGND VPWR VPWR sky130_fd_sc_hd__decap_3
XFILLER_30_208 VGND VGND VPWR VPWR sky130_fd_sc_hd__decap_3
XFILLER_70_355 VGND VGND VPWR VPWR sky130_fd_sc_hd__decap_3
XFILLER_2_197 VGND VGND VPWR VPWR sky130_fd_sc_hd__fill_1
XFILLER_78_477 VGND VGND VPWR VPWR sky130_fd_sc_hd__fill_2
Xfanout490 input51/X VGND VGND VPWR VPWR _5615_/A3 sky130_fd_sc_hd__clkdlybuf4s25_1
XFILLER_46_341 VGND VGND VPWR VPWR sky130_fd_sc_hd__decap_3
XFILLER_46_374 VGND VGND VPWR VPWR sky130_fd_sc_hd__decap_3
XFILLER_46_385 VGND VGND VPWR VPWR sky130_fd_sc_hd__decap_3
XFILLER_61_311 VGND VGND VPWR VPWR sky130_fd_sc_hd__decap_3
XTAP_TAPCELL_ROW_44_575 VGND VPWR sky130_fd_sc_hd__tapvpwrvgnd_1
XFILLER_61_355 VGND VGND VPWR VPWR sky130_fd_sc_hd__decap_3
XFILLER_14_271 VGND VGND VPWR VPWR sky130_fd_sc_hd__decap_3
X_4660_ _4613_/X _4614_/Y _4578_/B VGND VGND VPWR VPWR _4660_/Y sky130_fd_sc_hd__a21oi_2
X_3611_ _3479_/A _3479_/C _3610_/X VGND VGND VPWR VPWR _3615_/B sky130_fd_sc_hd__a21o_2
X_6330_ _6330_/A _6330_/B _6333_/A _6330_/D VGND VGND VPWR VPWR _6330_/X sky130_fd_sc_hd__or4_2
X_4591_ _4549_/B _4582_/S _4589_/X _4590_/Y VGND VGND VPWR VPWR _4591_/X sky130_fd_sc_hd__a31o_2
X_3542_ _3703_/A _4286_/B _3541_/X _3508_/Y VGND VGND VPWR VPWR _3542_/X sky130_fd_sc_hd__a31o_2
X_6261_ _6255_/X _6248_/X _6258_/X _4818_/A _6260_/X VGND VGND VPWR VPWR _6262_/B
+ sky130_fd_sc_hd__a221o_2
X_3473_ _4106_/A _3572_/S _3472_/X VGND VGND VPWR VPWR _3473_/X sky130_fd_sc_hd__a21o_2
X_6192_ _6192_/A _6233_/C VGND VGND VPWR VPWR _6192_/Y sky130_fd_sc_hd__xnor2_2
X_5212_ _6391_/B _6306_/C _5211_/X VGND VGND VPWR VPWR _5212_/X sky130_fd_sc_hd__o21a_2
XFILLER_69_411 VGND VGND VPWR VPWR sky130_fd_sc_hd__fill_2
X_5143_ _5191_/B VGND VGND VPWR VPWR _5144_/B sky130_fd_sc_hd__inv_2
XFILLER_29_319 VGND VGND VPWR VPWR sky130_fd_sc_hd__decap_3
XFILLER_56_116 VGND VGND VPWR VPWR sky130_fd_sc_hd__decap_3
X_5074_ _5297_/A _5120_/B VGND VGND VPWR VPWR _5076_/B sky130_fd_sc_hd__and2b_2
X_4025_ _3573_/X _3582_/X _3648_/X _3632_/X _4025_/S0 _4025_/S1 VGND VGND VPWR VPWR
+ _4025_/X sky130_fd_sc_hd__mux4_2
XFILLER_37_352 VGND VGND VPWR VPWR sky130_fd_sc_hd__decap_3
XFILLER_37_385 VGND VGND VPWR VPWR sky130_fd_sc_hd__decap_3
XFILLER_64_182 VGND VGND VPWR VPWR sky130_fd_sc_hd__decap_3
X_5976_ _6477_/A _5976_/B VGND VGND VPWR VPWR _5976_/Y sky130_fd_sc_hd__nor2_2
XFILLER_52_388 VGND VGND VPWR VPWR sky130_fd_sc_hd__decap_3
X_4927_ _4967_/B _4927_/B _4927_/C _4927_/D VGND VGND VPWR VPWR _4928_/B sky130_fd_sc_hd__and4b_2
X_4858_ _4853_/X _4874_/A _5628_/A VGND VGND VPWR VPWR _4858_/Y sky130_fd_sc_hd__a21oi_2
XFILLER_20_263 VGND VGND VPWR VPWR sky130_fd_sc_hd__decap_3
X_3809_ _4132_/A _3928_/A _3808_/X VGND VGND VPWR VPWR _3809_/Y sky130_fd_sc_hd__o21ai_2
XFILLER_20_296 VGND VGND VPWR VPWR sky130_fd_sc_hd__decap_3
X_4789_ _4967_/C _4789_/B VGND VGND VPWR VPWR _4927_/C sky130_fd_sc_hd__and2b_2
X_6459_ _6457_/X _6458_/X _6469_/S VGND VGND VPWR VPWR _6459_/X sky130_fd_sc_hd__mux2_2
XFILLER_79_208 VGND VGND VPWR VPWR sky130_fd_sc_hd__decap_3
XTAP_TAPCELL_ROW_7_245 VGND VPWR sky130_fd_sc_hd__tapvpwrvgnd_1
XFILLER_28_363 VGND VGND VPWR VPWR sky130_fd_sc_hd__fill_1
XFILLER_43_300 VGND VGND VPWR VPWR sky130_fd_sc_hd__decap_3
XFILLER_55_193 VGND VGND VPWR VPWR sky130_fd_sc_hd__decap_3
XFILLER_43_366 VGND VGND VPWR VPWR sky130_fd_sc_hd__decap_3
XFILLER_70_141 VGND VGND VPWR VPWR sky130_fd_sc_hd__fill_1
XFILLER_43_388 VGND VGND VPWR VPWR sky130_fd_sc_hd__decap_3
XFILLER_43_399 VGND VGND VPWR VPWR sky130_fd_sc_hd__decap_3
XFILLER_70_174 VGND VGND VPWR VPWR sky130_fd_sc_hd__decap_3
XTAP_TAPCELL_ROW_41_545 VGND VPWR sky130_fd_sc_hd__tapvpwrvgnd_1
XFILLER_7_289 VGND VGND VPWR VPWR sky130_fd_sc_hd__decap_3
XFILLER_78_241 VGND VGND VPWR VPWR sky130_fd_sc_hd__decap_3
XFILLER_38_127 VGND VGND VPWR VPWR sky130_fd_sc_hd__decap_3
XTAP_TAPCELL_ROW_49_623 VGND VPWR sky130_fd_sc_hd__tapvpwrvgnd_1
XFILLER_53_119 VGND VGND VPWR VPWR sky130_fd_sc_hd__decap_3
XFILLER_19_396 VGND VGND VPWR VPWR sky130_fd_sc_hd__decap_3
XFILLER_46_193 VGND VGND VPWR VPWR sky130_fd_sc_hd__decap_3
X_5830_ _4934_/X _5238_/X _5547_/X _5829_/X _5948_/S0 _5948_/S1 VGND VGND VPWR VPWR
+ _5830_/X sky130_fd_sc_hd__mux4_2
XFILLER_61_152 VGND VGND VPWR VPWR sky130_fd_sc_hd__decap_3
XFILLER_61_130 VGND VGND VPWR VPWR sky130_fd_sc_hd__decap_3
X_5761_ _5724_/A _5724_/B _5682_/A VGND VGND VPWR VPWR _6495_/B sky130_fd_sc_hd__a21oi_2
XFILLER_61_196 VGND VGND VPWR VPWR sky130_fd_sc_hd__decap_3
X_4712_ _5216_/A _4011_/X _4235_/A VGND VGND VPWR VPWR _4712_/X sky130_fd_sc_hd__o21a_2
X_5692_ _5635_/C _5691_/X _6374_/B VGND VGND VPWR VPWR _5692_/X sky130_fd_sc_hd__o21a_2
X_4643_ _6060_/D VGND VGND VPWR VPWR _6243_/B sky130_fd_sc_hd__inv_2
X_4574_ _4614_/B _4578_/B VGND VGND VPWR VPWR _4582_/S sky130_fd_sc_hd__nor2_2
XTAP_TAPCELL_ROW_12_291 VGND VPWR sky130_fd_sc_hd__tapvpwrvgnd_1
X_6313_ _6339_/A _6322_/A _6330_/B _6313_/D VGND VGND VPWR VPWR _6326_/C sky130_fd_sc_hd__and4_2
X_3525_ wire500/A _3519_/Y _3524_/X _3363_/Y VGND VGND VPWR VPWR _3525_/X sky130_fd_sc_hd__o22a_2
X_6244_ _6244_/A _6244_/B VGND VGND VPWR VPWR _6244_/Y sky130_fd_sc_hd__xnor2_2
X_3456_ _4196_/B _3901_/B _3455_/X _4146_/A VGND VGND VPWR VPWR _3456_/Y sky130_fd_sc_hd__a22oi_2
X_6175_ _6176_/A _6175_/B VGND VGND VPWR VPWR _6175_/Y sky130_fd_sc_hd__nand2_2
X_3387_ _6457_/A2 _6460_/A3 _6460_/A2 _6447_/A3 _3575_/S0 _3575_/S1 VGND VGND VPWR
+ VPWR _3387_/X sky130_fd_sc_hd__mux4_2
XTAP_TAPCELL_ROW_4_215 VGND VPWR sky130_fd_sc_hd__tapvpwrvgnd_1
XFILLER_29_127 VGND VGND VPWR VPWR sky130_fd_sc_hd__decap_3
X_5126_ _4939_/Y _4978_/X _5123_/B _5052_/S VGND VGND VPWR VPWR _5126_/Y sky130_fd_sc_hd__o31ai_2
XFILLER_69_274 VGND VGND VPWR VPWR sky130_fd_sc_hd__decap_3
XFILLER_69_263 VGND VGND VPWR VPWR sky130_fd_sc_hd__decap_3
X_5057_ _4940_/A _4941_/A _5057_/S VGND VGND VPWR VPWR _5057_/X sky130_fd_sc_hd__mux2_2
X_4008_ _4708_/B _4008_/B VGND VGND VPWR VPWR _4008_/Y sky130_fd_sc_hd__xnor2_2
XFILLER_25_322 VGND VGND VPWR VPWR sky130_fd_sc_hd__decap_3
XFILLER_52_130 VGND VGND VPWR VPWR sky130_fd_sc_hd__decap_3
XFILLER_52_141 VGND VGND VPWR VPWR sky130_fd_sc_hd__decap_3
XFILLER_25_399 VGND VGND VPWR VPWR sky130_fd_sc_hd__decap_3
XFILLER_52_185 VGND VGND VPWR VPWR sky130_fd_sc_hd__decap_3
X_5959_ _5976_/B _6498_/A VGND VGND VPWR VPWR _5961_/A sky130_fd_sc_hd__xor2_2
XFILLER_40_336 VGND VGND VPWR VPWR sky130_fd_sc_hd__decap_3
XFILLER_75_222 VGND VGND VPWR VPWR sky130_fd_sc_hd__fill_2
XFILLER_28_193 VGND VGND VPWR VPWR sky130_fd_sc_hd__decap_3
XTAP_TAPCELL_ROW_18_339 VGND VPWR sky130_fd_sc_hd__tapvpwrvgnd_1
XFILLER_43_196 VGND VGND VPWR VPWR sky130_fd_sc_hd__fill_2
XANTENNA_4 _4849_/B VGND VGND VPWR VPWR sky130_fd_sc_hd__diode_2
X_3310_ _4842_/A _4884_/B VGND VGND VPWR VPWR _3310_/Y sky130_fd_sc_hd__nor2_2
XFILLER_3_281 VGND VGND VPWR VPWR sky130_fd_sc_hd__fill_1
X_4290_ _4469_/A _4355_/B _4289_/X VGND VGND VPWR VPWR _4290_/Y sky130_fd_sc_hd__o21ai_2
X_3241_ _3241_/A _6486_/A _6486_/B _5853_/A VGND VGND VPWR VPWR _3242_/A sky130_fd_sc_hd__or4b_2
XFILLER_39_447 VGND VGND VPWR VPWR sky130_fd_sc_hd__fill_1
XFILLER_66_233 VGND VGND VPWR VPWR sky130_fd_sc_hd__decap_3
XFILLER_26_108 VGND VGND VPWR VPWR sky130_fd_sc_hd__decap_3
XFILLER_66_277 VGND VGND VPWR VPWR sky130_fd_sc_hd__fill_1
XFILLER_34_141 VGND VGND VPWR VPWR sky130_fd_sc_hd__decap_3
XFILLER_34_163 VGND VGND VPWR VPWR sky130_fd_sc_hd__decap_3
X_5813_ _5813_/A VGND VGND VPWR VPWR _5822_/B sky130_fd_sc_hd__buf_1
XFILLER_22_358 VGND VGND VPWR VPWR sky130_fd_sc_hd__decap_3
X_5744_ _5967_/B1 _5733_/X _5736_/X _6486_/C _5743_/Y VGND VGND VPWR VPWR _5744_/X
+ sky130_fd_sc_hd__a221o_2
X_5675_ _5714_/A _5675_/B VGND VGND VPWR VPWR _5675_/X sky130_fd_sc_hd__or2_2
X_4626_ _4599_/A input89/X _4624_/X _4625_/X VGND VGND VPWR VPWR _4687_/C sky130_fd_sc_hd__a22o_2
Xmax_cap262 _4885_/X VGND VGND VPWR VPWR _5050_/A sky130_fd_sc_hd__clkbuf_2
Xmax_cap251 _4202_/A VGND VGND VPWR VPWR _5099_/B sky130_fd_sc_hd__buf_2
X_4557_ _5216_/B VGND VGND VPWR VPWR _4557_/Y sky130_fd_sc_hd__inv_2
Xmax_cap295 _3350_/X VGND VGND VPWR VPWR _3640_/A sky130_fd_sc_hd__buf_2
Xmax_cap273 _3970_/A VGND VGND VPWR VPWR _4221_/S sky130_fd_sc_hd__buf_2
X_4488_ _6189_/B _4546_/A VGND VGND VPWR VPWR _4489_/B sky130_fd_sc_hd__or2b_2
X_3508_ _3703_/A _3508_/B VGND VGND VPWR VPWR _3508_/Y sky130_fd_sc_hd__nor2_2
X_6227_ _6227_/A _6227_/B _6227_/C VGND VGND VPWR VPWR _6232_/C sky130_fd_sc_hd__and3_2
X_3439_ _6450_/A0 _6450_/A1 _6446_/A0 _5225_/S _6450_/S0 _3648_/S1 VGND VGND VPWR
+ VPWR _3439_/X sky130_fd_sc_hd__mux4_2
X_6158_ _6158_/A _6183_/A VGND VGND VPWR VPWR _6158_/Y sky130_fd_sc_hd__xnor2_2
XFILLER_66_16 VGND VGND VPWR VPWR sky130_fd_sc_hd__fill_1
X_5109_ _5109_/A _5109_/B VGND VGND VPWR VPWR _5429_/C sky130_fd_sc_hd__or2_2
XFILLER_57_233 VGND VGND VPWR VPWR sky130_fd_sc_hd__decap_3
XFILLER_57_222 VGND VGND VPWR VPWR sky130_fd_sc_hd__fill_2
X_6089_ _6089_/A _6089_/B VGND VGND VPWR VPWR _6089_/Y sky130_fd_sc_hd__xnor2_2
XFILLER_57_266 VGND VGND VPWR VPWR sky130_fd_sc_hd__decap_3
XTAP_TAPCELL_ROW_68_795 VGND VPWR sky130_fd_sc_hd__tapvpwrvgnd_1
XFILLER_82_37 VGND VGND VPWR VPWR sky130_fd_sc_hd__decap_3
XFILLER_40_144 VGND VGND VPWR VPWR sky130_fd_sc_hd__decap_3
XTAP_TAPCELL_ROW_51_640 VGND VPWR sky130_fd_sc_hd__tapvpwrvgnd_1
XFILLER_13_369 VGND VGND VPWR VPWR sky130_fd_sc_hd__fill_2
XFILLER_15_86 VGND VGND VPWR VPWR sky130_fd_sc_hd__decap_3
XTAP_TAPCELL_ROW_23_386 VGND VPWR sky130_fd_sc_hd__tapvpwrvgnd_1
XFILLER_48_200 VGND VGND VPWR VPWR sky130_fd_sc_hd__decap_3
Xinput130 operand_b[6] VGND VGND VPWR VPWR _3679_/B sky130_fd_sc_hd__clkdlybuf4s25_1
XFILLER_36_406 VGND VGND VPWR VPWR sky130_fd_sc_hd__decap_3
XFILLER_48_277 VGND VGND VPWR VPWR sky130_fd_sc_hd__decap_3
XFILLER_36_439 VGND VGND VPWR VPWR sky130_fd_sc_hd__decap_3
XFILLER_16_141 VGND VGND VPWR VPWR sky130_fd_sc_hd__fill_1
XFILLER_31_155 VGND VGND VPWR VPWR sky130_fd_sc_hd__decap_3
X_3790_ _3520_/X _3758_/X _3799_/A VGND VGND VPWR VPWR _3790_/X sky130_fd_sc_hd__mux2_2
XFILLER_31_199 VGND VGND VPWR VPWR sky130_fd_sc_hd__decap_3
X_5460_ _5460_/A _5467_/B VGND VGND VPWR VPWR _5460_/Y sky130_fd_sc_hd__nor2_2
X_4411_ _6059_/B _5099_/B VGND VGND VPWR VPWR _4411_/Y sky130_fd_sc_hd__nand2_2
X_5391_ _5386_/X _5387_/Y _5609_/A _5390_/X VGND VGND VPWR VPWR _5391_/X sky130_fd_sc_hd__a2bb2o_2
X_4342_ _4356_/A _4357_/S _4355_/C _4326_/Y _4341_/X VGND VGND VPWR VPWR _4342_/X
+ sky130_fd_sc_hd__a41o_2
X_4273_ _4268_/Y _4272_/X _4273_/S VGND VGND VPWR VPWR _4273_/X sky130_fd_sc_hd__mux2_2
XFILLER_39_200 VGND VGND VPWR VPWR sky130_fd_sc_hd__fill_1
X_6012_ _6100_/A _6012_/B input1/X VGND VGND VPWR VPWR _6098_/B sky130_fd_sc_hd__and3_2
X_3224_ _3945_/A _3222_/X _3571_/S VGND VGND VPWR VPWR _3750_/B sky130_fd_sc_hd__mux2_2
.ends
