* NGSPICE file created from alu64_cp_top.ext - technology: sky130A

* Black-box entry subcircuit for sky130_fd_sc_hd__fill_1 abstract view
.subckt sky130_fd_sc_hd__fill_1 VGND VNB VPB VPWR
.ends

* Black-box entry subcircuit for sky130_fd_sc_hd__buf_12 abstract view
.subckt sky130_fd_sc_hd__buf_12 A VGND VNB VPB VPWR X
.ends

* Black-box entry subcircuit for sky130_fd_sc_hd__decap_3 abstract view
.subckt sky130_fd_sc_hd__decap_3 VGND VNB VPB VPWR
.ends

* Black-box entry subcircuit for sky130_fd_sc_hd__clkbuf_4 abstract view
.subckt sky130_fd_sc_hd__clkbuf_4 A VGND VNB VPB VPWR X
.ends

* Black-box entry subcircuit for sky130_fd_sc_hd__buf_6 abstract view
.subckt sky130_fd_sc_hd__buf_6 A VGND VNB VPB VPWR X
.ends

* Black-box entry subcircuit for sky130_fd_sc_hd__dfxtp_2 abstract view
.subckt sky130_fd_sc_hd__dfxtp_2 CLK D VGND VNB VPB VPWR Q
.ends

* Black-box entry subcircuit for sky130_fd_sc_hd__nor2_2 abstract view
.subckt sky130_fd_sc_hd__nor2_2 A B VGND VNB VPB VPWR Y
.ends

* Black-box entry subcircuit for sky130_fd_sc_hd__and2_2 abstract view
.subckt sky130_fd_sc_hd__and2_2 A B VGND VNB VPB VPWR X
.ends

* Black-box entry subcircuit for sky130_fd_sc_hd__tapvpwrvgnd_1 abstract view
.subckt sky130_fd_sc_hd__tapvpwrvgnd_1 VGND VPWR
.ends

* Black-box entry subcircuit for sky130_fd_sc_hd__a21o_2 abstract view
.subckt sky130_fd_sc_hd__a21o_2 A1 A2 B1 VGND VNB VPB VPWR X
.ends

* Black-box entry subcircuit for sky130_fd_sc_hd__o21ai_2 abstract view
.subckt sky130_fd_sc_hd__o21ai_2 A1 A2 B1 VGND VNB VPB VPWR Y
.ends

* Black-box entry subcircuit for sky130_fd_sc_hd__or2_2 abstract view
.subckt sky130_fd_sc_hd__or2_2 A B VGND VNB VPB VPWR X
.ends

* Black-box entry subcircuit for sky130_fd_sc_hd__a31o_2 abstract view
.subckt sky130_fd_sc_hd__a31o_2 A1 A2 A3 B1 VGND VNB VPB VPWR X
.ends

* Black-box entry subcircuit for sky130_fd_sc_hd__buf_1 abstract view
.subckt sky130_fd_sc_hd__buf_1 A VGND VNB VPB VPWR X
.ends

* Black-box entry subcircuit for sky130_fd_sc_hd__o22a_2 abstract view
.subckt sky130_fd_sc_hd__o22a_2 A1 A2 B1 B2 VGND VNB VPB VPWR X
.ends

* Black-box entry subcircuit for sky130_fd_sc_hd__fill_2 abstract view
.subckt sky130_fd_sc_hd__fill_2 VGND VNB VPB VPWR
.ends

* Black-box entry subcircuit for sky130_fd_sc_hd__nand2_2 abstract view
.subckt sky130_fd_sc_hd__nand2_2 A B VGND VNB VPB VPWR Y
.ends

* Black-box entry subcircuit for sky130_fd_sc_hd__o311a_2 abstract view
.subckt sky130_fd_sc_hd__o311a_2 A1 A2 A3 B1 C1 VGND VNB VPB VPWR X
.ends

* Black-box entry subcircuit for sky130_fd_sc_hd__nor3_2 abstract view
.subckt sky130_fd_sc_hd__nor3_2 A B C VGND VNB VPB VPWR Y
.ends

* Black-box entry subcircuit for sky130_fd_sc_hd__inv_2 abstract view
.subckt sky130_fd_sc_hd__inv_2 A VGND VNB VPB VPWR Y
.ends

* Black-box entry subcircuit for sky130_fd_sc_hd__dfxtp_4 abstract view
.subckt sky130_fd_sc_hd__dfxtp_4 CLK D VGND VNB VPB VPWR Q
.ends

* Black-box entry subcircuit for sky130_fd_sc_hd__mux2_2 abstract view
.subckt sky130_fd_sc_hd__mux2_2 A0 A1 S VGND VNB VPB VPWR X
.ends

* Black-box entry subcircuit for sky130_fd_sc_hd__or3_2 abstract view
.subckt sky130_fd_sc_hd__or3_2 A B C VGND VNB VPB VPWR X
.ends

* Black-box entry subcircuit for sky130_fd_sc_hd__xnor2_2 abstract view
.subckt sky130_fd_sc_hd__xnor2_2 A B VGND VNB VPB VPWR Y
.ends

* Black-box entry subcircuit for sky130_fd_sc_hd__o211a_2 abstract view
.subckt sky130_fd_sc_hd__o211a_2 A1 A2 B1 C1 VGND VNB VPB VPWR X
.ends

* Black-box entry subcircuit for sky130_fd_sc_hd__a31o_4 abstract view
.subckt sky130_fd_sc_hd__a31o_4 A1 A2 A3 B1 VGND VNB VPB VPWR X
.ends

* Black-box entry subcircuit for sky130_fd_sc_hd__a21oi_2 abstract view
.subckt sky130_fd_sc_hd__a21oi_2 A1 A2 B1 VGND VNB VPB VPWR Y
.ends

* Black-box entry subcircuit for sky130_fd_sc_hd__and2b_2 abstract view
.subckt sky130_fd_sc_hd__and2b_2 A_N B VGND VNB VPB VPWR X
.ends

* Black-box entry subcircuit for sky130_fd_sc_hd__a32o_2 abstract view
.subckt sky130_fd_sc_hd__a32o_2 A1 A2 A3 B1 B2 VGND VNB VPB VPWR X
.ends

* Black-box entry subcircuit for sky130_fd_sc_hd__mux4_2 abstract view
.subckt sky130_fd_sc_hd__mux4_2 A0 A1 A2 A3 S0 S1 VGND VNB VPB VPWR X
.ends

* Black-box entry subcircuit for sky130_fd_sc_hd__a211o_2 abstract view
.subckt sky130_fd_sc_hd__a211o_2 A1 A2 B1 C1 VGND VNB VPB VPWR X
.ends

* Black-box entry subcircuit for sky130_fd_sc_hd__o2bb2a_2 abstract view
.subckt sky130_fd_sc_hd__o2bb2a_2 A1_N A2_N B1 B2 VGND VNB VPB VPWR X
.ends

* Black-box entry subcircuit for sky130_fd_sc_hd__or4_2 abstract view
.subckt sky130_fd_sc_hd__or4_2 A B C D VGND VNB VPB VPWR X
.ends

* Black-box entry subcircuit for sky130_fd_sc_hd__o21a_2 abstract view
.subckt sky130_fd_sc_hd__o21a_2 A1 A2 B1 VGND VNB VPB VPWR X
.ends

* Black-box entry subcircuit for sky130_fd_sc_hd__and3_2 abstract view
.subckt sky130_fd_sc_hd__and3_2 A B C VGND VNB VPB VPWR X
.ends

* Black-box entry subcircuit for sky130_fd_sc_hd__a221o_2 abstract view
.subckt sky130_fd_sc_hd__a221o_2 A1 A2 B1 B2 C1 VGND VNB VPB VPWR X
.ends

* Black-box entry subcircuit for sky130_fd_sc_hd__a32oi_2 abstract view
.subckt sky130_fd_sc_hd__a32oi_2 A1 A2 A3 B1 B2 VGND VNB VPB VPWR Y
.ends

* Black-box entry subcircuit for sky130_fd_sc_hd__a22o_2 abstract view
.subckt sky130_fd_sc_hd__a22o_2 A1 A2 B1 B2 VGND VNB VPB VPWR X
.ends

* Black-box entry subcircuit for sky130_fd_sc_hd__o21ba_2 abstract view
.subckt sky130_fd_sc_hd__o21ba_2 A1 A2 B1_N VGND VNB VPB VPWR X
.ends

* Black-box entry subcircuit for sky130_fd_sc_hd__o32a_2 abstract view
.subckt sky130_fd_sc_hd__o32a_2 A1 A2 A3 B1 B2 VGND VNB VPB VPWR X
.ends

* Black-box entry subcircuit for sky130_fd_sc_hd__o221a_2 abstract view
.subckt sky130_fd_sc_hd__o221a_2 A1 A2 B1 B2 C1 VGND VNB VPB VPWR X
.ends

* Black-box entry subcircuit for sky130_fd_sc_hd__buf_2 abstract view
.subckt sky130_fd_sc_hd__buf_2 A VGND VNB VPB VPWR X
.ends

* Black-box entry subcircuit for sky130_fd_sc_hd__nor2_4 abstract view
.subckt sky130_fd_sc_hd__nor2_4 A B VGND VNB VPB VPWR Y
.ends

* Black-box entry subcircuit for sky130_fd_sc_hd__diode_2 abstract view
.subckt sky130_fd_sc_hd__diode_2 DIODE VGND VNB VPB VPWR
.ends

* Black-box entry subcircuit for sky130_fd_sc_hd__a2bb2o_2 abstract view
.subckt sky130_fd_sc_hd__a2bb2o_2 A1_N A2_N B1 B2 VGND VNB VPB VPWR X
.ends

* Black-box entry subcircuit for sky130_fd_sc_hd__clkbuf_8 abstract view
.subckt sky130_fd_sc_hd__clkbuf_8 A VGND VNB VPB VPWR X
.ends

* Black-box entry subcircuit for sky130_fd_sc_hd__a21bo_2 abstract view
.subckt sky130_fd_sc_hd__a21bo_2 A1 A2 B1_N VGND VNB VPB VPWR X
.ends

* Black-box entry subcircuit for sky130_fd_sc_hd__clkdlybuf4s25_1 abstract view
.subckt sky130_fd_sc_hd__clkdlybuf4s25_1 A VGND VNB VPB VPWR X
.ends

* Black-box entry subcircuit for sky130_fd_sc_hd__clkbuf_1 abstract view
.subckt sky130_fd_sc_hd__clkbuf_1 A VGND VNB VPB VPWR X
.ends

* Black-box entry subcircuit for sky130_fd_sc_hd__buf_8 abstract view
.subckt sky130_fd_sc_hd__buf_8 A VGND VNB VPB VPWR X
.ends

* Black-box entry subcircuit for sky130_fd_sc_hd__buf_4 abstract view
.subckt sky130_fd_sc_hd__buf_4 A VGND VNB VPB VPWR X
.ends

* Black-box entry subcircuit for sky130_fd_sc_hd__or2_4 abstract view
.subckt sky130_fd_sc_hd__or2_4 A B VGND VNB VPB VPWR X
.ends

* Black-box entry subcircuit for sky130_fd_sc_hd__nand4_2 abstract view
.subckt sky130_fd_sc_hd__nand4_2 A B C D VGND VNB VPB VPWR Y
.ends

* Black-box entry subcircuit for sky130_fd_sc_hd__a211o_4 abstract view
.subckt sky130_fd_sc_hd__a211o_4 A1 A2 B1 C1 VGND VNB VPB VPWR X
.ends

* Black-box entry subcircuit for sky130_fd_sc_hd__xor2_2 abstract view
.subckt sky130_fd_sc_hd__xor2_2 A B VGND VNB VPB VPWR X
.ends

* Black-box entry subcircuit for sky130_fd_sc_hd__a21oi_4 abstract view
.subckt sky130_fd_sc_hd__a21oi_4 A1 A2 B1 VGND VNB VPB VPWR Y
.ends

* Black-box entry subcircuit for sky130_fd_sc_hd__or4_4 abstract view
.subckt sky130_fd_sc_hd__or4_4 A B C D VGND VNB VPB VPWR X
.ends

* Black-box entry subcircuit for sky130_fd_sc_hd__nor2b_2 abstract view
.subckt sky130_fd_sc_hd__nor2b_2 A B_N VGND VNB VPB VPWR Y
.ends

* Black-box entry subcircuit for sky130_fd_sc_hd__and4_2 abstract view
.subckt sky130_fd_sc_hd__and4_2 A B C D VGND VNB VPB VPWR X
.ends

* Black-box entry subcircuit for sky130_fd_sc_hd__and3_4 abstract view
.subckt sky130_fd_sc_hd__and3_4 A B C VGND VNB VPB VPWR X
.ends

* Black-box entry subcircuit for sky130_fd_sc_hd__clkbuf_2 abstract view
.subckt sky130_fd_sc_hd__clkbuf_2 A VGND VNB VPB VPWR X
.ends

* Black-box entry subcircuit for sky130_fd_sc_hd__o2111a_2 abstract view
.subckt sky130_fd_sc_hd__o2111a_2 A1 A2 B1 C1 D1 VGND VNB VPB VPWR X
.ends

* Black-box entry subcircuit for sky130_fd_sc_hd__or3b_4 abstract view
.subckt sky130_fd_sc_hd__or3b_4 A B C_N VGND VNB VPB VPWR X
.ends

* Black-box entry subcircuit for sky130_fd_sc_hd__o31a_2 abstract view
.subckt sky130_fd_sc_hd__o31a_2 A1 A2 A3 B1 VGND VNB VPB VPWR X
.ends

* Black-box entry subcircuit for sky130_fd_sc_hd__a22oi_2 abstract view
.subckt sky130_fd_sc_hd__a22oi_2 A1 A2 B1 B2 VGND VNB VPB VPWR Y
.ends

* Black-box entry subcircuit for sky130_fd_sc_hd__or2b_2 abstract view
.subckt sky130_fd_sc_hd__or2b_2 A B_N VGND VNB VPB VPWR X
.ends

* Black-box entry subcircuit for sky130_fd_sc_hd__or3b_2 abstract view
.subckt sky130_fd_sc_hd__or3b_2 A B C_N VGND VNB VPB VPWR X
.ends

* Black-box entry subcircuit for sky130_fd_sc_hd__and4b_2 abstract view
.subckt sky130_fd_sc_hd__and4b_2 A_N B C D VGND VNB VPB VPWR X
.ends

* Black-box entry subcircuit for sky130_fd_sc_hd__or3_4 abstract view
.subckt sky130_fd_sc_hd__or3_4 A B C VGND VNB VPB VPWR X
.ends

* Black-box entry subcircuit for sky130_fd_sc_hd__a41o_2 abstract view
.subckt sky130_fd_sc_hd__a41o_2 A1 A2 A3 A4 B1 VGND VNB VPB VPWR X
.ends

* Black-box entry subcircuit for sky130_fd_sc_hd__and3b_2 abstract view
.subckt sky130_fd_sc_hd__and3b_2 A_N B C VGND VNB VPB VPWR X
.ends

* Black-box entry subcircuit for sky130_fd_sc_hd__or4b_4 abstract view
.subckt sky130_fd_sc_hd__or4b_4 A B C D_N VGND VNB VPB VPWR X
.ends

* Black-box entry subcircuit for sky130_fd_sc_hd__a211oi_2 abstract view
.subckt sky130_fd_sc_hd__a211oi_2 A1 A2 B1 C1 VGND VNB VPB VPWR Y
.ends

* Black-box entry subcircuit for sky130_fd_sc_hd__a2111o_2 abstract view
.subckt sky130_fd_sc_hd__a2111o_2 A1 A2 B1 C1 D1 VGND VNB VPB VPWR X
.ends

* Black-box entry subcircuit for sky130_fd_sc_hd__o21bai_2 abstract view
.subckt sky130_fd_sc_hd__o21bai_2 A1 A2 B1_N VGND VNB VPB VPWR Y
.ends

* Black-box entry subcircuit for sky130_fd_sc_hd__o41a_4 abstract view
.subckt sky130_fd_sc_hd__o41a_4 A1 A2 A3 A4 B1 VGND VNB VPB VPWR X
.ends

* Black-box entry subcircuit for sky130_fd_sc_hd__inv_8 abstract view
.subckt sky130_fd_sc_hd__inv_8 A VGND VNB VPB VPWR Y
.ends

* Black-box entry subcircuit for sky130_fd_sc_hd__o21a_4 abstract view
.subckt sky130_fd_sc_hd__o21a_4 A1 A2 B1 VGND VNB VPB VPWR X
.ends

* Black-box entry subcircuit for sky130_fd_sc_hd__a31oi_2 abstract view
.subckt sky130_fd_sc_hd__a31oi_2 A1 A2 A3 B1 VGND VNB VPB VPWR Y
.ends

* Black-box entry subcircuit for sky130_fd_sc_hd__clkinv_8 abstract view
.subckt sky130_fd_sc_hd__clkinv_8 A VGND VNB VPB VPWR Y
.ends

* Black-box entry subcircuit for sky130_fd_sc_hd__nand2b_2 abstract view
.subckt sky130_fd_sc_hd__nand2b_2 A_N B VGND VNB VPB VPWR Y
.ends

* Black-box entry subcircuit for sky130_fd_sc_hd__o211a_4 abstract view
.subckt sky130_fd_sc_hd__o211a_4 A1 A2 B1 C1 VGND VNB VPB VPWR X
.ends

* Black-box entry subcircuit for sky130_fd_sc_hd__o31a_4 abstract view
.subckt sky130_fd_sc_hd__o31a_4 A1 A2 A3 B1 VGND VNB VPB VPWR X
.ends

* Black-box entry subcircuit for sky130_fd_sc_hd__o2111ai_2 abstract view
.subckt sky130_fd_sc_hd__o2111ai_2 A1 A2 B1 C1 D1 VGND VNB VPB VPWR Y
.ends

* Black-box entry subcircuit for sky130_fd_sc_hd__clkinvlp_4 abstract view
.subckt sky130_fd_sc_hd__clkinvlp_4 A VGND VNB VPB VPWR Y
.ends

* Black-box entry subcircuit for sky130_fd_sc_hd__mux2_4 abstract view
.subckt sky130_fd_sc_hd__mux2_4 A0 A1 S VGND VNB VPB VPWR X
.ends

* Black-box entry subcircuit for sky130_fd_sc_hd__o211ai_2 abstract view
.subckt sky130_fd_sc_hd__o211ai_2 A1 A2 B1 C1 VGND VNB VPB VPWR Y
.ends

* Black-box entry subcircuit for sky130_fd_sc_hd__a311o_2 abstract view
.subckt sky130_fd_sc_hd__a311o_2 A1 A2 A3 B1 C1 VGND VNB VPB VPWR X
.ends

* Black-box entry subcircuit for sky130_fd_sc_hd__clkbuf_16 abstract view
.subckt sky130_fd_sc_hd__clkbuf_16 A VGND VNB VPB VPWR X
.ends

* Black-box entry subcircuit for sky130_fd_sc_hd__nand2_4 abstract view
.subckt sky130_fd_sc_hd__nand2_4 A B VGND VNB VPB VPWR Y
.ends

* Black-box entry subcircuit for sky130_fd_sc_hd__clkinv_2 abstract view
.subckt sky130_fd_sc_hd__clkinv_2 A VGND VNB VPB VPWR Y
.ends

* Black-box entry subcircuit for sky130_fd_sc_hd__nand3_2 abstract view
.subckt sky130_fd_sc_hd__nand3_2 A B C VGND VNB VPB VPWR Y
.ends

* Black-box entry subcircuit for sky130_fd_sc_hd__a21boi_2 abstract view
.subckt sky130_fd_sc_hd__a21boi_2 A1 A2 B1_N VGND VNB VPB VPWR Y
.ends

* Black-box entry subcircuit for sky130_fd_sc_hd__or4bb_4 abstract view
.subckt sky130_fd_sc_hd__or4bb_4 A B C_N D_N VGND VNB VPB VPWR X
.ends

* Black-box entry subcircuit for sky130_fd_sc_hd__o2bb2ai_2 abstract view
.subckt sky130_fd_sc_hd__o2bb2ai_2 A1_N A2_N B1 B2 VGND VNB VPB VPWR Y
.ends

* Black-box entry subcircuit for sky130_fd_sc_hd__or2b_4 abstract view
.subckt sky130_fd_sc_hd__or2b_4 A B_N VGND VNB VPB VPWR X
.ends

* Black-box entry subcircuit for sky130_fd_sc_hd__and2_4 abstract view
.subckt sky130_fd_sc_hd__and2_4 A B VGND VNB VPB VPWR X
.ends

* Black-box entry subcircuit for sky130_fd_sc_hd__o221a_4 abstract view
.subckt sky130_fd_sc_hd__o221a_4 A1 A2 B1 B2 C1 VGND VNB VPB VPWR X
.ends

* Black-box entry subcircuit for sky130_fd_sc_hd__clkinv_4 abstract view
.subckt sky130_fd_sc_hd__clkinv_4 A VGND VNB VPB VPWR Y
.ends

* Black-box entry subcircuit for sky130_fd_sc_hd__a41o_4 abstract view
.subckt sky130_fd_sc_hd__a41o_4 A1 A2 A3 A4 B1 VGND VNB VPB VPWR X
.ends

* Black-box entry subcircuit for sky130_fd_sc_hd__a22o_4 abstract view
.subckt sky130_fd_sc_hd__a22o_4 A1 A2 B1 B2 VGND VNB VPB VPWR X
.ends

* Black-box entry subcircuit for sky130_fd_sc_hd__o31ai_2 abstract view
.subckt sky130_fd_sc_hd__o31ai_2 A1 A2 A3 B1 VGND VNB VPB VPWR Y
.ends

* Black-box entry subcircuit for sky130_fd_sc_hd__o21ba_4 abstract view
.subckt sky130_fd_sc_hd__o21ba_4 A1 A2 B1_N VGND VNB VPB VPWR X
.ends

* Black-box entry subcircuit for sky130_fd_sc_hd__a21o_4 abstract view
.subckt sky130_fd_sc_hd__a21o_4 A1 A2 B1 VGND VNB VPB VPWR X
.ends

* Black-box entry subcircuit for sky130_fd_sc_hd__nor3_4 abstract view
.subckt sky130_fd_sc_hd__nor3_4 A B C VGND VNB VPB VPWR Y
.ends

* Black-box entry subcircuit for sky130_fd_sc_hd__or4b_2 abstract view
.subckt sky130_fd_sc_hd__or4b_2 A B C D_N VGND VNB VPB VPWR X
.ends

* Black-box entry subcircuit for sky130_fd_sc_hd__a221oi_2 abstract view
.subckt sky130_fd_sc_hd__a221oi_2 A1 A2 B1 B2 C1 VGND VNB VPB VPWR Y
.ends

* Black-box entry subcircuit for sky130_fd_sc_hd__bufinv_8 abstract view
.subckt sky130_fd_sc_hd__bufinv_8 A VGND VNB VPB VPWR Y
.ends

* Black-box entry subcircuit for sky130_fd_sc_hd__o21ai_4 abstract view
.subckt sky130_fd_sc_hd__o21ai_4 A1 A2 B1 VGND VNB VPB VPWR Y
.ends

* Black-box entry subcircuit for sky130_fd_sc_hd__and4bb_4 abstract view
.subckt sky130_fd_sc_hd__and4bb_4 A_N B_N C D VGND VNB VPB VPWR X
.ends

* Black-box entry subcircuit for sky130_fd_sc_hd__o221ai_2 abstract view
.subckt sky130_fd_sc_hd__o221ai_2 A1 A2 B1 B2 C1 VGND VNB VPB VPWR Y
.ends

* Black-box entry subcircuit for sky130_fd_sc_hd__a2bb2o_4 abstract view
.subckt sky130_fd_sc_hd__a2bb2o_4 A1_N A2_N B1 B2 VGND VNB VPB VPWR X
.ends

* Black-box entry subcircuit for sky130_fd_sc_hd__nor4_2 abstract view
.subckt sky130_fd_sc_hd__nor4_2 A B C D VGND VNB VPB VPWR Y
.ends

* Black-box entry subcircuit for sky130_fd_sc_hd__xor2_4 abstract view
.subckt sky130_fd_sc_hd__xor2_4 A B VGND VNB VPB VPWR X
.ends

* Black-box entry subcircuit for sky130_fd_sc_hd__nand2b_4 abstract view
.subckt sky130_fd_sc_hd__nand2b_4 A_N B VGND VNB VPB VPWR Y
.ends

* Black-box entry subcircuit for sky130_fd_sc_hd__nor4_4 abstract view
.subckt sky130_fd_sc_hd__nor4_4 A B C D VGND VNB VPB VPWR Y
.ends

* Black-box entry subcircuit for sky130_fd_sc_hd__o32a_4 abstract view
.subckt sky130_fd_sc_hd__o32a_4 A1 A2 A3 B1 B2 VGND VNB VPB VPWR X
.ends

* Black-box entry subcircuit for sky130_fd_sc_hd__nand4_4 abstract view
.subckt sky130_fd_sc_hd__nand4_4 A B C D VGND VNB VPB VPWR Y
.ends

* Black-box entry subcircuit for sky130_fd_sc_hd__a21boi_4 abstract view
.subckt sky130_fd_sc_hd__a21boi_4 A1 A2 B1_N VGND VNB VPB VPWR Y
.ends

* Black-box entry subcircuit for sky130_fd_sc_hd__a21bo_4 abstract view
.subckt sky130_fd_sc_hd__a21bo_4 A1 A2 B1_N VGND VNB VPB VPWR X
.ends

* Black-box entry subcircuit for sky130_fd_sc_hd__o311a_4 abstract view
.subckt sky130_fd_sc_hd__o311a_4 A1 A2 A3 B1 C1 VGND VNB VPB VPWR X
.ends

* Black-box entry subcircuit for sky130_fd_sc_hd__o2bb2a_4 abstract view
.subckt sky130_fd_sc_hd__o2bb2a_4 A1_N A2_N B1 B2 VGND VNB VPB VPWR X
.ends

* Black-box entry subcircuit for sky130_fd_sc_hd__o41a_2 abstract view
.subckt sky130_fd_sc_hd__o41a_2 A1 A2 A3 A4 B1 VGND VNB VPB VPWR X
.ends

* Black-box entry subcircuit for sky130_fd_sc_hd__and4bb_2 abstract view
.subckt sky130_fd_sc_hd__and4bb_2 A_N B_N C D VGND VNB VPB VPWR X
.ends

* Black-box entry subcircuit for sky130_fd_sc_hd__o31ai_4 abstract view
.subckt sky130_fd_sc_hd__o31ai_4 A1 A2 A3 B1 VGND VNB VPB VPWR Y
.ends

* Black-box entry subcircuit for sky130_fd_sc_hd__and4_4 abstract view
.subckt sky130_fd_sc_hd__and4_4 A B C D VGND VNB VPB VPWR X
.ends

* Black-box entry subcircuit for sky130_fd_sc_hd__o22a_4 abstract view
.subckt sky130_fd_sc_hd__o22a_4 A1 A2 B1 B2 VGND VNB VPB VPWR X
.ends

.subckt alu64_cp_top VGND VPWR carry_in carry_out clk cmd[0] cmd[1] cmd[2] cmd[3]
+ negative_flag operand_a[0] operand_a[10] operand_a[11] operand_a[12] operand_a[13]
+ operand_a[14] operand_a[15] operand_a[16] operand_a[17] operand_a[18] operand_a[19]
+ operand_a[1] operand_a[20] operand_a[21] operand_a[22] operand_a[23] operand_a[24]
+ operand_a[25] operand_a[26] operand_a[27] operand_a[28] operand_a[29] operand_a[2]
+ operand_a[30] operand_a[31] operand_a[32] operand_a[33] operand_a[34] operand_a[35]
+ operand_a[36] operand_a[37] operand_a[38] operand_a[39] operand_a[3] operand_a[40]
+ operand_a[41] operand_a[42] operand_a[43] operand_a[44] operand_a[45] operand_a[46]
+ operand_a[47] operand_a[48] operand_a[49] operand_a[4] operand_a[50] operand_a[51]
+ operand_a[52] operand_a[53] operand_a[54] operand_a[55] operand_a[56] operand_a[57]
+ operand_a[58] operand_a[59] operand_a[5] operand_a[60] operand_a[61] operand_a[62]
+ operand_a[63] operand_a[6] operand_a[7] operand_a[8] operand_a[9] operand_b[0] operand_b[10]
+ operand_b[11] operand_b[12] operand_b[13] operand_b[14] operand_b[15] operand_b[16]
+ operand_b[17] operand_b[18] operand_b[19] operand_b[1] operand_b[20] operand_b[21]
+ operand_b[22] operand_b[23] operand_b[24] operand_b[25] operand_b[26] operand_b[27]
+ operand_b[28] operand_b[29] operand_b[2] operand_b[30] operand_b[31] operand_b[32]
+ operand_b[33] operand_b[34] operand_b[35] operand_b[36] operand_b[37] operand_b[38]
+ operand_b[39] operand_b[3] operand_b[40] operand_b[41] operand_b[42] operand_b[43]
+ operand_b[44] operand_b[45] operand_b[46] operand_b[47] operand_b[48] operand_b[49]
+ operand_b[4] operand_b[50] operand_b[51] operand_b[52] operand_b[53] operand_b[54]
+ operand_b[55] operand_b[56] operand_b[57] operand_b[58] operand_b[59] operand_b[5]
+ operand_b[60] operand_b[61] operand_b[62] operand_b[63] operand_b[6] operand_b[7]
+ operand_b[8] operand_b[9] overflow_flag result[0] result[10] result[11] result[12]
+ result[13] result[14] result[15] result[16] result[17] result[18] result[19] result[1]
+ result[20] result[21] result[22] result[23] result[24] result[25] result[26] result[27]
+ result[28] result[29] result[2] result[30] result[31] result[32] result[33] result[34]
+ result[35] result[36] result[37] result[38] result[39] result[3] result[40] result[41]
+ result[42] result[43] result[44] result[45] result[46] result[47] result[48] result[49]
+ result[4] result[50] result[51] result[52] result[53] result[54] result[55] result[56]
+ result[57] result[58] result[59] result[5] result[60] result[61] result[62] result[63]
+ result[6] result[7] result[8] result[9] rst_n valid_in valid_out zero_flag
XFILLER_79_391 VGND VGND VPWR VPWR sky130_fd_sc_hd__fill_1
Xsplit260 _7623_/S VGND VGND VPWR VPWR _5579_/S sky130_fd_sc_hd__buf_12
XFILLER_27_406 VGND VGND VPWR VPWR sky130_fd_sc_hd__decap_3
XFILLER_54_203 VGND VGND VPWR VPWR sky130_fd_sc_hd__decap_3
Xsplit271 _8170_/Q VGND VGND VPWR VPWR _7776_/B sky130_fd_sc_hd__clkbuf_4
Xsplit282 _7555_/S VGND VGND VPWR VPWR _7623_/S sky130_fd_sc_hd__buf_6
X_7963_ _8387_/CLK _7963_/D VGND VGND VPWR VPWR _7963_/Q sky130_fd_sc_hd__dfxtp_2
XFILLER_42_409 VGND VGND VPWR VPWR sky130_fd_sc_hd__decap_3
XFILLER_70_707 VGND VGND VPWR VPWR sky130_fd_sc_hd__decap_3
X_6914_ _7844_/C _6914_/B VGND VGND VPWR VPWR _6914_/Y sky130_fd_sc_hd__nor2_2
XFILLER_22_100 VGND VGND VPWR VPWR sky130_fd_sc_hd__decap_3
XFILLER_23_601 VGND VGND VPWR VPWR sky130_fd_sc_hd__decap_3
XFILLER_23_612 VGND VGND VPWR VPWR sky130_fd_sc_hd__decap_3
XFILLER_23_623 VGND VGND VPWR VPWR sky130_fd_sc_hd__decap_3
XFILLER_82_589 VGND VGND VPWR VPWR sky130_fd_sc_hd__decap_3
X_7894_ _8317_/Q _7930_/B VGND VGND VPWR VPWR _7895_/A sky130_fd_sc_hd__and2_2
XTAP_TAPCELL_ROW_85_1362 VGND VPWR sky130_fd_sc_hd__tapvpwrvgnd_1
XTAP_TAPCELL_ROW_53_949 VGND VPWR sky130_fd_sc_hd__tapvpwrvgnd_1
XFILLER_35_494 VGND VGND VPWR VPWR sky130_fd_sc_hd__fill_1
XFILLER_50_442 VGND VGND VPWR VPWR sky130_fd_sc_hd__decap_3
XFILLER_62_280 VGND VGND VPWR VPWR sky130_fd_sc_hd__decap_3
X_6845_ _8261_/Q _6807_/B _8197_/Q VGND VGND VPWR VPWR _6845_/X sky130_fd_sc_hd__a21o_2
XFILLER_50_475 VGND VGND VPWR VPWR sky130_fd_sc_hd__fill_1
X_6776_ _4827_/B _7631_/C _5415_/A VGND VGND VPWR VPWR _6776_/Y sky130_fd_sc_hd__o21ai_2
X_3988_ _8347_/Q _7930_/B VGND VGND VPWR VPWR _3989_/A sky130_fd_sc_hd__and2_2
X_5727_ _6095_/A _5727_/B VGND VGND VPWR VPWR _5896_/A sky130_fd_sc_hd__or2_2
XTAP_TAPCELL_ROW_33_684 VGND VPWR sky130_fd_sc_hd__tapvpwrvgnd_1
XFILLER_108_227 VGND VGND VPWR VPWR sky130_fd_sc_hd__decap_3
X_5658_ _5016_/Y _5651_/Y _5528_/A VGND VGND VPWR VPWR _5658_/X sky130_fd_sc_hd__a21o_2
X_8377_ _8377_/CLK _8377_/D VGND VGND VPWR VPWR _8377_/Q sky130_fd_sc_hd__dfxtp_2
X_5589_ _7631_/B _8230_/Q _5323_/Y _5598_/D VGND VGND VPWR VPWR _5589_/X sky130_fd_sc_hd__a31o_2
X_4609_ _4609_/A VGND VGND VPWR VPWR _8242_/D sky130_fd_sc_hd__buf_1
XFILLER_104_400 VGND VGND VPWR VPWR sky130_fd_sc_hd__decap_3
XFILLER_117_33 VGND VGND VPWR VPWR sky130_fd_sc_hd__decap_3
XFILLER_89_122 VGND VGND VPWR VPWR sky130_fd_sc_hd__decap_3
X_7328_ _8213_/Q _8277_/Q VGND VGND VPWR VPWR _7328_/X sky130_fd_sc_hd__and2_2
XFILLER_104_433 VGND VGND VPWR VPWR sky130_fd_sc_hd__decap_3
XFILLER_89_155 VGND VGND VPWR VPWR sky130_fd_sc_hd__decap_3
X_7259_ _4974_/Y _6767_/Y _7258_/X _5333_/A VGND VGND VPWR VPWR _7259_/X sky130_fd_sc_hd__o22a_2
XFILLER_104_477 VGND VGND VPWR VPWR sky130_fd_sc_hd__decap_3
XFILLER_117_99 VGND VGND VPWR VPWR sky130_fd_sc_hd__fill_2
XFILLER_77_317 VGND VGND VPWR VPWR sky130_fd_sc_hd__decap_3
XTAP_TAPCELL_ROW_5_321 VGND VPWR sky130_fd_sc_hd__tapvpwrvgnd_1
XFILLER_58_520 VGND VGND VPWR VPWR sky130_fd_sc_hd__decap_3
XFILLER_89_199 VGND VGND VPWR VPWR sky130_fd_sc_hd__decap_3
XFILLER_46_704 VGND VGND VPWR VPWR sky130_fd_sc_hd__fill_2
XFILLER_46_715 VGND VGND VPWR VPWR sky130_fd_sc_hd__fill_2
XFILLER_58_575 VGND VGND VPWR VPWR sky130_fd_sc_hd__decap_3
XFILLER_92_309 VGND VGND VPWR VPWR sky130_fd_sc_hd__fill_1
XFILLER_45_214 VGND VGND VPWR VPWR sky130_fd_sc_hd__decap_3
XFILLER_45_225 VGND VGND VPWR VPWR sky130_fd_sc_hd__decap_3
XFILLER_85_383 VGND VGND VPWR VPWR sky130_fd_sc_hd__decap_3
XFILLER_93_47 VGND VGND VPWR VPWR sky130_fd_sc_hd__decap_3
XFILLER_45_258 VGND VGND VPWR VPWR sky130_fd_sc_hd__decap_3
XFILLER_73_556 VGND VGND VPWR VPWR sky130_fd_sc_hd__decap_3
XFILLER_73_578 VGND VGND VPWR VPWR sky130_fd_sc_hd__decap_3
XFILLER_93_69 VGND VGND VPWR VPWR sky130_fd_sc_hd__decap_3
XFILLER_14_601 VGND VGND VPWR VPWR sky130_fd_sc_hd__decap_3
XFILLER_26_483 VGND VGND VPWR VPWR sky130_fd_sc_hd__fill_2
XFILLER_60_206 VGND VGND VPWR VPWR sky130_fd_sc_hd__decap_3
XFILLER_61_729 VGND VGND VPWR VPWR sky130_fd_sc_hd__decap_3
XFILLER_14_645 VGND VGND VPWR VPWR sky130_fd_sc_hd__decap_3
XFILLER_26_85 VGND VGND VPWR VPWR sky130_fd_sc_hd__decap_3
XFILLER_41_442 VGND VGND VPWR VPWR sky130_fd_sc_hd__decap_3
XFILLER_53_291 VGND VGND VPWR VPWR sky130_fd_sc_hd__decap_3
XFILLER_60_239 VGND VGND VPWR VPWR sky130_fd_sc_hd__decap_3
XFILLER_13_155 VGND VGND VPWR VPWR sky130_fd_sc_hd__decap_3
XFILLER_41_464 VGND VGND VPWR VPWR sky130_fd_sc_hd__fill_2
XFILLER_41_486 VGND VGND VPWR VPWR sky130_fd_sc_hd__decap_3
XFILLER_5_343 VGND VGND VPWR VPWR sky130_fd_sc_hd__decap_3
XFILLER_5_365 VGND VGND VPWR VPWR sky130_fd_sc_hd__decap_3
XFILLER_107_271 VGND VGND VPWR VPWR sky130_fd_sc_hd__decap_3
XFILLER_3_34 VGND VGND VPWR VPWR sky130_fd_sc_hd__decap_3
XFILLER_96_615 VGND VGND VPWR VPWR sky130_fd_sc_hd__decap_3
XFILLER_110_436 VGND VGND VPWR VPWR sky130_fd_sc_hd__decap_3
XFILLER_110_458 VGND VGND VPWR VPWR sky130_fd_sc_hd__decap_3
XFILLER_3_78 VGND VGND VPWR VPWR sky130_fd_sc_hd__decap_3
XFILLER_49_542 VGND VGND VPWR VPWR sky130_fd_sc_hd__fill_1
XFILLER_96_648 VGND VGND VPWR VPWR sky130_fd_sc_hd__decap_3
XFILLER_64_501 VGND VGND VPWR VPWR sky130_fd_sc_hd__decap_3
XFILLER_67_81 VGND VGND VPWR VPWR sky130_fd_sc_hd__fill_2
XFILLER_76_361 VGND VGND VPWR VPWR sky130_fd_sc_hd__decap_3
XFILLER_83_309 VGND VGND VPWR VPWR sky130_fd_sc_hd__decap_3
XFILLER_95_169 VGND VGND VPWR VPWR sky130_fd_sc_hd__decap_3
XFILLER_64_512 VGND VGND VPWR VPWR sky130_fd_sc_hd__decap_3
XFILLER_76_383 VGND VGND VPWR VPWR sky130_fd_sc_hd__decap_3
XFILLER_64_545 VGND VGND VPWR VPWR sky130_fd_sc_hd__decap_3
XFILLER_17_461 VGND VGND VPWR VPWR sky130_fd_sc_hd__decap_3
XFILLER_51_228 VGND VGND VPWR VPWR sky130_fd_sc_hd__decap_3
X_4960_ _4960_/A _5651_/B VGND VGND VPWR VPWR _4969_/A sky130_fd_sc_hd__nand2_2
X_4891_ _6393_/A _4891_/B VGND VGND VPWR VPWR _6297_/A sky130_fd_sc_hd__or2_2
XFILLER_20_604 VGND VGND VPWR VPWR sky130_fd_sc_hd__decap_3
XFILLER_32_475 VGND VGND VPWR VPWR sky130_fd_sc_hd__fill_1
X_6630_ _5966_/X _6602_/X _6603_/Y _6629_/X _7930_/B VGND VGND VPWR VPWR _8326_/D
+ sky130_fd_sc_hd__o311a_2
XTAP_TAPCELL_ROW_50_908 VGND VPWR sky130_fd_sc_hd__tapvpwrvgnd_1
XFILLER_20_648 VGND VGND VPWR VPWR sky130_fd_sc_hd__fill_2
X_6561_ _8254_/Q _6561_/B _6561_/C VGND VGND VPWR VPWR _6561_/Y sky130_fd_sc_hd__nor3_2
X_8300_ _8385_/CLK _8300_/D VGND VGND VPWR VPWR _8300_/Q sky130_fd_sc_hd__dfxtp_2
X_5512_ _5512_/A _5512_/B VGND VGND VPWR VPWR _5513_/B sky130_fd_sc_hd__nand2_2
XTAP_TAPCELL_ROW_30_654 VGND VPWR sky130_fd_sc_hd__tapvpwrvgnd_1
XTAP_TAPCELL_ROW_30_643 VGND VPWR sky130_fd_sc_hd__tapvpwrvgnd_1
X_6492_ _6825_/C VGND VGND VPWR VPWR _6548_/D sky130_fd_sc_hd__inv_2
XFILLER_105_208 VGND VGND VPWR VPWR sky130_fd_sc_hd__fill_1
X_8231_ clkload7/A _8231_/D VGND VGND VPWR VPWR _8231_/Q sky130_fd_sc_hd__dfxtp_4
X_5443_ _5217_/X _5213_/X _5444_/S VGND VGND VPWR VPWR _5443_/X sky130_fd_sc_hd__mux2_2
XFILLER_99_420 VGND VGND VPWR VPWR sky130_fd_sc_hd__decap_3
X_8162_ clkload3/A _8162_/D VGND VGND VPWR VPWR _8162_/Q sky130_fd_sc_hd__dfxtp_4
X_5374_ _5168_/X _5163_/X _5384_/S VGND VGND VPWR VPWR _5374_/X sky130_fd_sc_hd__mux2_2
XFILLER_99_431 VGND VGND VPWR VPWR sky130_fd_sc_hd__decap_3
X_7113_ _7112_/X _6977_/X _7623_/S VGND VGND VPWR VPWR _7113_/X sky130_fd_sc_hd__mux2_2
X_4325_ _4325_/A VGND VGND VPWR VPWR _8100_/D sky130_fd_sc_hd__buf_1
XFILLER_59_328 VGND VGND VPWR VPWR sky130_fd_sc_hd__decap_3
XFILLER_87_615 VGND VGND VPWR VPWR sky130_fd_sc_hd__fill_1
XFILLER_87_637 VGND VGND VPWR VPWR sky130_fd_sc_hd__decap_3
XFILLER_99_475 VGND VGND VPWR VPWR sky130_fd_sc_hd__decap_3
XFILLER_99_497 VGND VGND VPWR VPWR sky130_fd_sc_hd__decap_3
X_8093_ _8229_/CLK _8093_/D VGND VGND VPWR VPWR _8093_/Q sky130_fd_sc_hd__dfxtp_2
XFILLER_101_425 VGND VGND VPWR VPWR sky130_fd_sc_hd__fill_2
X_7044_ _8288_/Q _7044_/B _7044_/C VGND VGND VPWR VPWR _7044_/X sky130_fd_sc_hd__or3_2
X_4256_ _7898_/B _4256_/B VGND VGND VPWR VPWR _4257_/A sky130_fd_sc_hd__and2_2
XFILLER_101_469 VGND VGND VPWR VPWR sky130_fd_sc_hd__decap_3
XFILLER_28_704 VGND VGND VPWR VPWR sky130_fd_sc_hd__fill_2
XFILLER_28_715 VGND VGND VPWR VPWR sky130_fd_sc_hd__fill_2
XFILLER_67_361 VGND VGND VPWR VPWR sky130_fd_sc_hd__decap_3
XFILLER_74_309 VGND VGND VPWR VPWR sky130_fd_sc_hd__decap_3
XFILLER_86_158 VGND VGND VPWR VPWR sky130_fd_sc_hd__fill_2
X_4187_ _4187_/A VGND VGND VPWR VPWR _8031_/D sky130_fd_sc_hd__buf_1
XFILLER_27_203 VGND VGND VPWR VPWR sky130_fd_sc_hd__decap_3
XFILLER_27_225 VGND VGND VPWR VPWR sky130_fd_sc_hd__decap_3
XFILLER_94_180 VGND VGND VPWR VPWR sky130_fd_sc_hd__decap_3
XTAP_TAPCELL_ROW_38_754 VGND VPWR sky130_fd_sc_hd__tapvpwrvgnd_1
XFILLER_27_269 VGND VGND VPWR VPWR sky130_fd_sc_hd__decap_3
XFILLER_42_206 VGND VGND VPWR VPWR sky130_fd_sc_hd__decap_3
XFILLER_55_578 VGND VGND VPWR VPWR sky130_fd_sc_hd__decap_3
XFILLER_70_504 VGND VGND VPWR VPWR sky130_fd_sc_hd__decap_3
XFILLER_70_526 VGND VGND VPWR VPWR sky130_fd_sc_hd__decap_3
XFILLER_82_386 VGND VGND VPWR VPWR sky130_fd_sc_hd__decap_3
X_7946_ _8352_/CLK _7946_/D VGND VGND VPWR VPWR _7946_/Q sky130_fd_sc_hd__dfxtp_2
X_7877_ _7877_/A VGND VGND VPWR VPWR _8375_/D sky130_fd_sc_hd__buf_1
XFILLER_23_442 VGND VGND VPWR VPWR sky130_fd_sc_hd__decap_3
XFILLER_23_475 VGND VGND VPWR VPWR sky130_fd_sc_hd__decap_3
X_6828_ _8198_/Q _6828_/B VGND VGND VPWR VPWR _6828_/Y sky130_fd_sc_hd__xnor2_2
XFILLER_109_503 VGND VGND VPWR VPWR sky130_fd_sc_hd__fill_1
XFILLER_109_514 VGND VGND VPWR VPWR sky130_fd_sc_hd__decap_3
X_6759_ _7305_/A1 _6736_/X _6758_/X _7930_/B VGND VGND VPWR VPWR _8330_/D sky130_fd_sc_hd__o211a_2
XTAP_TAPCELL_ROW_98_1531 VGND VPWR sky130_fd_sc_hd__tapvpwrvgnd_1
XFILLER_109_547 VGND VGND VPWR VPWR sky130_fd_sc_hd__decap_3
XFILLER_12_43 VGND VGND VPWR VPWR sky130_fd_sc_hd__fill_2
XFILLER_109_558 VGND VGND VPWR VPWR sky130_fd_sc_hd__fill_2
XFILLER_12_76 VGND VGND VPWR VPWR sky130_fd_sc_hd__decap_3
XFILLER_104_230 VGND VGND VPWR VPWR sky130_fd_sc_hd__decap_3
XFILLER_117_591 VGND VGND VPWR VPWR sky130_fd_sc_hd__fill_1
XFILLER_2_357 VGND VGND VPWR VPWR sky130_fd_sc_hd__decap_3
XFILLER_104_274 VGND VGND VPWR VPWR sky130_fd_sc_hd__decap_3
XFILLER_78_604 VGND VGND VPWR VPWR sky130_fd_sc_hd__decap_3
XFILLER_77_125 VGND VGND VPWR VPWR sky130_fd_sc_hd__decap_3
XFILLER_18_225 VGND VGND VPWR VPWR sky130_fd_sc_hd__decap_3
XFILLER_37_51 VGND VGND VPWR VPWR sky130_fd_sc_hd__decap_3
XFILLER_46_523 VGND VGND VPWR VPWR sky130_fd_sc_hd__decap_3
XFILLER_58_383 VGND VGND VPWR VPWR sky130_fd_sc_hd__decap_3
XFILLER_86_681 VGND VGND VPWR VPWR sky130_fd_sc_hd__fill_2
XFILLER_92_128 VGND VGND VPWR VPWR sky130_fd_sc_hd__decap_3
XFILLER_46_567 VGND VGND VPWR VPWR sky130_fd_sc_hd__decap_3
XFILLER_46_589 VGND VGND VPWR VPWR sky130_fd_sc_hd__decap_3
XFILLER_61_526 VGND VGND VPWR VPWR sky130_fd_sc_hd__fill_1
XFILLER_73_386 VGND VGND VPWR VPWR sky130_fd_sc_hd__decap_3
XFILLER_26_280 VGND VGND VPWR VPWR sky130_fd_sc_hd__decap_3
XFILLER_33_228 VGND VGND VPWR VPWR sky130_fd_sc_hd__decap_3
XFILLER_14_442 VGND VGND VPWR VPWR sky130_fd_sc_hd__fill_1
XFILLER_41_250 VGND VGND VPWR VPWR sky130_fd_sc_hd__decap_3
XFILLER_53_72 VGND VGND VPWR VPWR sky130_fd_sc_hd__decap_3
XFILLER_10_681 VGND VGND VPWR VPWR sky130_fd_sc_hd__decap_3
XFILLER_10_692 VGND VGND VPWR VPWR sky130_fd_sc_hd__decap_3
XFILLER_5_140 VGND VGND VPWR VPWR sky130_fd_sc_hd__decap_3
XTAP_TAPCELL_ROW_58_1014 VGND VPWR sky130_fd_sc_hd__tapvpwrvgnd_1
XFILLER_115_539 VGND VGND VPWR VPWR sky130_fd_sc_hd__fill_2
XFILLER_5_173 VGND VGND VPWR VPWR sky130_fd_sc_hd__decap_3
XFILLER_68_103 VGND VGND VPWR VPWR sky130_fd_sc_hd__decap_3
XFILLER_110_200 VGND VGND VPWR VPWR sky130_fd_sc_hd__decap_3
XFILLER_69_648 VGND VGND VPWR VPWR sky130_fd_sc_hd__decap_3
XFILLER_78_80 VGND VGND VPWR VPWR sky130_fd_sc_hd__decap_3
XFILLER_78_91 VGND VGND VPWR VPWR sky130_fd_sc_hd__decap_3
XFILLER_96_445 VGND VGND VPWR VPWR sky130_fd_sc_hd__decap_3
X_5090_ _7619_/A _6769_/B VGND VGND VPWR VPWR _5090_/Y sky130_fd_sc_hd__nor2_2
X_4110_ _7930_/B _8396_/Q VGND VGND VPWR VPWR _4111_/A sky130_fd_sc_hd__and2_2
XFILLER_83_106 VGND VGND VPWR VPWR sky130_fd_sc_hd__decap_3
XFILLER_96_489 VGND VGND VPWR VPWR sky130_fd_sc_hd__decap_3
X_4041_ _4041_/A VGND VGND VPWR VPWR _7958_/D sky130_fd_sc_hd__buf_1
XFILLER_49_361 VGND VGND VPWR VPWR sky130_fd_sc_hd__decap_3
XFILLER_64_342 VGND VGND VPWR VPWR sky130_fd_sc_hd__decap_3
XFILLER_92_662 VGND VGND VPWR VPWR sky130_fd_sc_hd__decap_3
XTAP_TAPCELL_ROW_69_1154 VGND VPWR sky130_fd_sc_hd__tapvpwrvgnd_1
XFILLER_24_206 VGND VGND VPWR VPWR sky130_fd_sc_hd__decap_3
XFILLER_25_729 VGND VGND VPWR VPWR sky130_fd_sc_hd__decap_3
XFILLER_37_589 VGND VGND VPWR VPWR sky130_fd_sc_hd__fill_1
XFILLER_91_150 VGND VGND VPWR VPWR sky130_fd_sc_hd__decap_3
XFILLER_92_695 VGND VGND VPWR VPWR sky130_fd_sc_hd__decap_3
X_7800_ _8199_/Q _7672_/X _7681_/X VGND VGND VPWR VPWR _7800_/Y sky130_fd_sc_hd__o21ai_2
X_5992_ _8238_/Q _6302_/C _5933_/A _6024_/A VGND VGND VPWR VPWR _5992_/X sky130_fd_sc_hd__a31o_4
XTAP_TAPCELL_ROW_35_713 VGND VPWR sky130_fd_sc_hd__tapvpwrvgnd_1
XFILLER_24_239 VGND VGND VPWR VPWR sky130_fd_sc_hd__decap_3
X_7731_ _7812_/A _7727_/X _7730_/X VGND VGND VPWR VPWR _7731_/Y sky130_fd_sc_hd__a21oi_2
X_4943_ _8231_/Q _8167_/Q VGND VGND VPWR VPWR _4944_/B sky130_fd_sc_hd__and2b_2
XTAP_TAPCELL_ROW_82_1321 VGND VPWR sky130_fd_sc_hd__tapvpwrvgnd_1
X_7662_ _7662_/A VGND VGND VPWR VPWR _7663_/B sky130_fd_sc_hd__buf_1
XFILLER_60_592 VGND VGND VPWR VPWR sky130_fd_sc_hd__fill_2
X_6613_ _5396_/A _8192_/Q _6612_/Y _5402_/X _4842_/B VGND VGND VPWR VPWR _6613_/X
+ sky130_fd_sc_hd__a32o_2
X_4874_ _8187_/Q _8251_/Q VGND VGND VPWR VPWR _6563_/A sky130_fd_sc_hd__and2b_2
XFILLER_20_445 VGND VGND VPWR VPWR sky130_fd_sc_hd__decap_3
X_7593_ _7060_/X _7592_/X _6817_/X _7349_/X _5268_/X _7745_/A VGND VGND VPWR VPWR
+ _7594_/B sky130_fd_sc_hd__mux4_2
X_6544_ _8190_/Q _8254_/Q _8288_/Q VGND VGND VPWR VPWR _6544_/X sky130_fd_sc_hd__mux2_2
X_6475_ _6476_/B _6476_/C _6592_/B VGND VGND VPWR VPWR _6477_/B sky130_fd_sc_hd__o21ai_2
XFILLER_106_539 VGND VGND VPWR VPWR sky130_fd_sc_hd__decap_3
X_8214_ _8218_/CLK _8214_/D VGND VGND VPWR VPWR _8214_/Q sky130_fd_sc_hd__dfxtp_2
X_5426_ _5491_/A _5413_/X _5420_/X _5425_/X VGND VGND VPWR VPWR _5426_/X sky130_fd_sc_hd__a211o_2
XFILLER_114_550 VGND VGND VPWR VPWR sky130_fd_sc_hd__fill_2
XFILLER_114_572 VGND VGND VPWR VPWR sky130_fd_sc_hd__decap_3
XFILLER_87_401 VGND VGND VPWR VPWR sky130_fd_sc_hd__fill_1
XFILLER_99_272 VGND VGND VPWR VPWR sky130_fd_sc_hd__decap_3
X_8145_ _8280_/CLK _8145_/D VGND VGND VPWR VPWR _8145_/Q sky130_fd_sc_hd__dfxtp_2
X_5357_ _5126_/X _5155_/X _5444_/S VGND VGND VPWR VPWR _5357_/X sky130_fd_sc_hd__mux2_2
XTAP_TAPCELL_ROW_93_1472 VGND VPWR sky130_fd_sc_hd__tapvpwrvgnd_1
XFILLER_59_125 VGND VGND VPWR VPWR sky130_fd_sc_hd__fill_2
XFILLER_59_136 VGND VGND VPWR VPWR sky130_fd_sc_hd__decap_3
X_8076_ _8226_/CLK _8076_/D VGND VGND VPWR VPWR _8076_/Q sky130_fd_sc_hd__dfxtp_2
X_5288_ _5288_/A _5288_/B VGND VGND VPWR VPWR _5289_/B sky130_fd_sc_hd__nor2_2
X_4308_ _7898_/B _4308_/B VGND VGND VPWR VPWR _4309_/A sky130_fd_sc_hd__and2_2
XFILLER_101_255 VGND VGND VPWR VPWR sky130_fd_sc_hd__decap_3
XFILLER_114_12 VGND VGND VPWR VPWR sky130_fd_sc_hd__decap_3
XFILLER_47_309 VGND VGND VPWR VPWR sky130_fd_sc_hd__decap_3
XFILLER_59_169 VGND VGND VPWR VPWR sky130_fd_sc_hd__decap_3
X_7027_ _8268_/Q _7027_/B VGND VGND VPWR VPWR _7028_/C sky130_fd_sc_hd__nand2_2
X_4239_ _4239_/A VGND VGND VPWR VPWR _8057_/D sky130_fd_sc_hd__buf_1
XFILLER_101_299 VGND VGND VPWR VPWR sky130_fd_sc_hd__decap_3
XFILLER_28_567 VGND VGND VPWR VPWR sky130_fd_sc_hd__decap_3
XFILLER_55_331 VGND VGND VPWR VPWR sky130_fd_sc_hd__decap_3
XFILLER_67_180 VGND VGND VPWR VPWR sky130_fd_sc_hd__decap_3
XFILLER_83_640 VGND VGND VPWR VPWR sky130_fd_sc_hd__decap_3
XFILLER_16_718 VGND VGND VPWR VPWR sky130_fd_sc_hd__decap_3
XFILLER_28_589 VGND VGND VPWR VPWR sky130_fd_sc_hd__decap_3
XFILLER_70_312 VGND VGND VPWR VPWR sky130_fd_sc_hd__decap_3
XFILLER_83_673 VGND VGND VPWR VPWR sky130_fd_sc_hd__decap_3
XFILLER_15_228 VGND VGND VPWR VPWR sky130_fd_sc_hd__decap_3
XFILLER_43_559 VGND VGND VPWR VPWR sky130_fd_sc_hd__fill_1
XFILLER_82_194 VGND VGND VPWR VPWR sky130_fd_sc_hd__fill_2
X_7929_ _7929_/A VGND VGND VPWR VPWR _8401_/D sky130_fd_sc_hd__buf_1
XFILLER_23_250 VGND VGND VPWR VPWR sky130_fd_sc_hd__decap_3
XFILLER_30_209 VGND VGND VPWR VPWR sky130_fd_sc_hd__decap_3
XFILLER_90_26 VGND VGND VPWR VPWR sky130_fd_sc_hd__fill_2
XFILLER_23_20 VGND VGND VPWR VPWR sky130_fd_sc_hd__decap_3
XFILLER_51_570 VGND VGND VPWR VPWR sky130_fd_sc_hd__decap_3
XFILLER_90_59 VGND VGND VPWR VPWR sky130_fd_sc_hd__decap_3
XTAP_TAPCELL_ROW_13_429 VGND VPWR sky130_fd_sc_hd__tapvpwrvgnd_1
XTAP_TAPCELL_ROW_102_1590 VGND VPWR sky130_fd_sc_hd__tapvpwrvgnd_1
XFILLER_11_478 VGND VGND VPWR VPWR sky130_fd_sc_hd__decap_3
XFILLER_23_86 VGND VGND VPWR VPWR sky130_fd_sc_hd__decap_3
XFILLER_7_416 VGND VGND VPWR VPWR sky130_fd_sc_hd__decap_3
XFILLER_109_355 VGND VGND VPWR VPWR sky130_fd_sc_hd__fill_2
XFILLER_99_35 VGND VGND VPWR VPWR sky130_fd_sc_hd__decap_3
XFILLER_109_388 VGND VGND VPWR VPWR sky130_fd_sc_hd__decap_3
XFILLER_109_399 VGND VGND VPWR VPWR sky130_fd_sc_hd__fill_1
XFILLER_2_121 VGND VGND VPWR VPWR sky130_fd_sc_hd__decap_3
XFILLER_3_644 VGND VGND VPWR VPWR sky130_fd_sc_hd__fill_2
XFILLER_105_561 VGND VGND VPWR VPWR sky130_fd_sc_hd__decap_3
XFILLER_3_688 VGND VGND VPWR VPWR sky130_fd_sc_hd__decap_3
XFILLER_78_401 VGND VGND VPWR VPWR sky130_fd_sc_hd__decap_3
XFILLER_97_209 VGND VGND VPWR VPWR sky130_fd_sc_hd__decap_3
XFILLER_105_583 VGND VGND VPWR VPWR sky130_fd_sc_hd__decap_3
XFILLER_78_445 VGND VGND VPWR VPWR sky130_fd_sc_hd__decap_3
XFILLER_38_309 VGND VGND VPWR VPWR sky130_fd_sc_hd__fill_1
XFILLER_48_50 VGND VGND VPWR VPWR sky130_fd_sc_hd__fill_2
XFILLER_65_128 VGND VGND VPWR VPWR sky130_fd_sc_hd__decap_3
XFILLER_66_629 VGND VGND VPWR VPWR sky130_fd_sc_hd__decap_3
XFILLER_93_437 VGND VGND VPWR VPWR sky130_fd_sc_hd__decap_3
XFILLER_0_24 VGND VGND VPWR VPWR sky130_fd_sc_hd__decap_3
XFILLER_0_35 VGND VGND VPWR VPWR sky130_fd_sc_hd__decap_3
XFILLER_74_640 VGND VGND VPWR VPWR sky130_fd_sc_hd__decap_3
XFILLER_74_651 VGND VGND VPWR VPWR sky130_fd_sc_hd__decap_3
XFILLER_0_57 VGND VGND VPWR VPWR sky130_fd_sc_hd__decap_3
XFILLER_19_567 VGND VGND VPWR VPWR sky130_fd_sc_hd__decap_3
XFILLER_61_301 VGND VGND VPWR VPWR sky130_fd_sc_hd__decap_3
XFILLER_73_161 VGND VGND VPWR VPWR sky130_fd_sc_hd__decap_3
XTAP_TAPCELL_ROW_105_1619 VGND VPWR sky130_fd_sc_hd__tapvpwrvgnd_1
XFILLER_34_548 VGND VGND VPWR VPWR sky130_fd_sc_hd__decap_3
XFILLER_64_82 VGND VGND VPWR VPWR sky130_fd_sc_hd__fill_2
XFILLER_61_378 VGND VGND VPWR VPWR sky130_fd_sc_hd__decap_3
XFILLER_30_710 VGND VGND VPWR VPWR sky130_fd_sc_hd__fill_1
XTAP_TAPCELL_ROW_64_1095 VGND VPWR sky130_fd_sc_hd__tapvpwrvgnd_1
XFILLER_80_70 VGND VGND VPWR VPWR sky130_fd_sc_hd__decap_3
XFILLER_80_81 VGND VGND VPWR VPWR sky130_fd_sc_hd__decap_3
XPHY_EDGE_ROW_104_Right_104 VGND VGND VPWR VPWR sky130_fd_sc_hd__decap_3
X_4590_ _7898_/B _8099_/Q VGND VGND VPWR VPWR _4591_/A sky130_fd_sc_hd__and2_2
XTAP_TAPCELL_ROW_40_782 VGND VPWR sky130_fd_sc_hd__tapvpwrvgnd_1
XFILLER_115_303 VGND VGND VPWR VPWR sky130_fd_sc_hd__decap_3
X_6260_ _8247_/Q _5618_/A _5398_/A _8183_/Q VGND VGND VPWR VPWR _6260_/X sky130_fd_sc_hd__o2bb2a_2
XFILLER_115_369 VGND VGND VPWR VPWR sky130_fd_sc_hd__decap_3
XFILLER_88_209 VGND VGND VPWR VPWR sky130_fd_sc_hd__decap_3
XFILLER_89_90 VGND VGND VPWR VPWR sky130_fd_sc_hd__decap_3
X_6191_ _7732_/B _8245_/Q _6190_/X VGND VGND VPWR VPWR _6191_/X sky130_fd_sc_hd__a21o_2
X_5211_ _7623_/S _5911_/B _5209_/X VGND VGND VPWR VPWR _6354_/A sky130_fd_sc_hd__a21oi_2
XFILLER_69_412 VGND VGND VPWR VPWR sky130_fd_sc_hd__decap_3
XFILLER_69_434 VGND VGND VPWR VPWR sky130_fd_sc_hd__decap_3
XFILLER_97_732 VGND VGND VPWR VPWR sky130_fd_sc_hd__fill_1
X_5142_ _5140_/X _5367_/B _5452_/S VGND VGND VPWR VPWR _5142_/X sky130_fd_sc_hd__mux2_2
XFILLER_111_564 VGND VGND VPWR VPWR sky130_fd_sc_hd__decap_3
XFILLER_69_467 VGND VGND VPWR VPWR sky130_fd_sc_hd__decap_3
XFILLER_96_242 VGND VGND VPWR VPWR sky130_fd_sc_hd__decap_3
XFILLER_96_253 VGND VGND VPWR VPWR sky130_fd_sc_hd__decap_3
XFILLER_56_106 VGND VGND VPWR VPWR sky130_fd_sc_hd__decap_3
XFILLER_84_437 VGND VGND VPWR VPWR sky130_fd_sc_hd__decap_3
X_5073_ _4972_/Y _7619_/A _5073_/S VGND VGND VPWR VPWR _5073_/X sky130_fd_sc_hd__mux2_2
X_4024_ _8338_/Q _8341_/Q _8340_/Q _8343_/Q VGND VGND VPWR VPWR _4026_/C sky130_fd_sc_hd__or4_2
XFILLER_64_150 VGND VGND VPWR VPWR sky130_fd_sc_hd__decap_3
XFILLER_65_673 VGND VGND VPWR VPWR sky130_fd_sc_hd__decap_3
XFILLER_25_526 VGND VGND VPWR VPWR sky130_fd_sc_hd__decap_3
XFILLER_44_19 VGND VGND VPWR VPWR sky130_fd_sc_hd__fill_2
XFILLER_52_312 VGND VGND VPWR VPWR sky130_fd_sc_hd__decap_3
XFILLER_64_194 VGND VGND VPWR VPWR sky130_fd_sc_hd__fill_2
XTAP_TAPCELL_ROW_48_882 VGND VPWR sky130_fd_sc_hd__tapvpwrvgnd_1
XFILLER_52_356 VGND VGND VPWR VPWR sky130_fd_sc_hd__decap_3
XFILLER_80_654 VGND VGND VPWR VPWR sky130_fd_sc_hd__decap_3
X_5975_ _6022_/B _8239_/Q _6999_/A1 VGND VGND VPWR VPWR _5975_/X sky130_fd_sc_hd__o21a_2
XFILLER_100_36 VGND VGND VPWR VPWR sky130_fd_sc_hd__fill_2
XFILLER_21_732 VGND VGND VPWR VPWR sky130_fd_sc_hd__fill_1
XFILLER_40_529 VGND VGND VPWR VPWR sky130_fd_sc_hd__decap_3
XFILLER_52_389 VGND VGND VPWR VPWR sky130_fd_sc_hd__decap_3
X_7714_ _7783_/A _8213_/Q _7820_/B VGND VGND VPWR VPWR _7714_/X sky130_fd_sc_hd__and3_2
X_4926_ _8172_/Q VGND VGND VPWR VPWR _4927_/A sky130_fd_sc_hd__inv_2
XFILLER_20_242 VGND VGND VPWR VPWR sky130_fd_sc_hd__decap_3
X_7645_ _8223_/Q _7840_/B _6148_/X VGND VGND VPWR VPWR _7645_/X sky130_fd_sc_hd__o21a_2
X_4857_ _8253_/Q _4857_/B VGND VGND VPWR VPWR _4858_/B sky130_fd_sc_hd__and2b_2
XFILLER_20_253 VGND VGND VPWR VPWR sky130_fd_sc_hd__decap_3
XFILLER_20_275 VGND VGND VPWR VPWR sky130_fd_sc_hd__decap_3
X_7576_ _8220_/Q _8284_/Q _8285_/Q _8221_/Q _7515_/X VGND VGND VPWR VPWR _7578_/A
+ sky130_fd_sc_hd__a221o_2
XFILLER_109_23 VGND VGND VPWR VPWR sky130_fd_sc_hd__fill_1
XFILLER_118_141 VGND VGND VPWR VPWR sky130_fd_sc_hd__decap_3
XFILLER_119_642 VGND VGND VPWR VPWR sky130_fd_sc_hd__fill_2
X_6527_ _6592_/D _6527_/B _6527_/C VGND VGND VPWR VPWR _6528_/B sky130_fd_sc_hd__and3_2
X_4788_ _8211_/Q _8275_/Q VGND VGND VPWR VPWR _4974_/A sky130_fd_sc_hd__and2b_2
XFILLER_119_697 VGND VGND VPWR VPWR sky130_fd_sc_hd__decap_3
XFILLER_4_419 VGND VGND VPWR VPWR sky130_fd_sc_hd__fill_1
XFILLER_106_358 VGND VGND VPWR VPWR sky130_fd_sc_hd__decap_3
X_6458_ _5142_/X _6130_/B _6571_/C _6457_/X _5477_/X VGND VGND VPWR VPWR _6458_/Y
+ sky130_fd_sc_hd__a32oi_2
XFILLER_69_49 VGND VGND VPWR VPWR sky130_fd_sc_hd__decap_3
X_6389_ _6384_/X _6386_/Y _6388_/X _6109_/A VGND VGND VPWR VPWR _6390_/C sky130_fd_sc_hd__a22o_2
X_5409_ _7612_/A VGND VGND VPWR VPWR _7264_/A sky130_fd_sc_hd__buf_1
XFILLER_87_220 VGND VGND VPWR VPWR sky130_fd_sc_hd__decap_3
XFILLER_88_721 VGND VGND VPWR VPWR sky130_fd_sc_hd__decap_3
X_8128_ _8400_/CLK _8128_/D VGND VGND VPWR VPWR _8128_/Q sky130_fd_sc_hd__dfxtp_2
XFILLER_102_564 VGND VGND VPWR VPWR sky130_fd_sc_hd__decap_3
XFILLER_85_26 VGND VGND VPWR VPWR sky130_fd_sc_hd__decap_3
XFILLER_87_231 VGND VGND VPWR VPWR sky130_fd_sc_hd__decap_3
XFILLER_102_575 VGND VGND VPWR VPWR sky130_fd_sc_hd__decap_3
XFILLER_75_426 VGND VGND VPWR VPWR sky130_fd_sc_hd__decap_3
X_8059_ clkload4/A _8059_/D VGND VGND VPWR VPWR _8059_/Q sky130_fd_sc_hd__dfxtp_2
XFILLER_28_331 VGND VGND VPWR VPWR sky130_fd_sc_hd__fill_1
XFILLER_56_651 VGND VGND VPWR VPWR sky130_fd_sc_hd__decap_3
XFILLER_18_64 VGND VGND VPWR VPWR sky130_fd_sc_hd__fill_2
XFILLER_18_75 VGND VGND VPWR VPWR sky130_fd_sc_hd__fill_1
XFILLER_28_353 VGND VGND VPWR VPWR sky130_fd_sc_hd__decap_3
XFILLER_55_161 VGND VGND VPWR VPWR sky130_fd_sc_hd__decap_3
XFILLER_62_109 VGND VGND VPWR VPWR sky130_fd_sc_hd__decap_3
XFILLER_83_470 VGND VGND VPWR VPWR sky130_fd_sc_hd__decap_3
XFILLER_90_407 VGND VGND VPWR VPWR sky130_fd_sc_hd__decap_3
XFILLER_28_386 VGND VGND VPWR VPWR sky130_fd_sc_hd__fill_1
XFILLER_43_334 VGND VGND VPWR VPWR sky130_fd_sc_hd__fill_2
XFILLER_55_172 VGND VGND VPWR VPWR sky130_fd_sc_hd__fill_2
XFILLER_55_183 VGND VGND VPWR VPWR sky130_fd_sc_hd__decap_3
XFILLER_70_153 VGND VGND VPWR VPWR sky130_fd_sc_hd__decap_3
XFILLER_71_676 VGND VGND VPWR VPWR sky130_fd_sc_hd__decap_3
XFILLER_24_581 VGND VGND VPWR VPWR sky130_fd_sc_hd__decap_3
XFILLER_70_186 VGND VGND VPWR VPWR sky130_fd_sc_hd__decap_3
XTAP_TAPCELL_ROW_26_598 VGND VPWR sky130_fd_sc_hd__tapvpwrvgnd_1
XFILLER_11_231 VGND VGND VPWR VPWR sky130_fd_sc_hd__decap_3
XFILLER_24_592 VGND VGND VPWR VPWR sky130_fd_sc_hd__decap_3
XFILLER_34_85 VGND VGND VPWR VPWR sky130_fd_sc_hd__decap_3
XFILLER_70_197 VGND VGND VPWR VPWR sky130_fd_sc_hd__decap_3
XFILLER_11_264 VGND VGND VPWR VPWR sky130_fd_sc_hd__decap_3
XFILLER_8_725 VGND VGND VPWR VPWR sky130_fd_sc_hd__decap_3
XFILLER_109_196 VGND VGND VPWR VPWR sky130_fd_sc_hd__decap_3
XFILLER_3_430 VGND VGND VPWR VPWR sky130_fd_sc_hd__decap_3
XFILLER_3_452 VGND VGND VPWR VPWR sky130_fd_sc_hd__decap_3
XFILLER_79_732 VGND VGND VPWR VPWR sky130_fd_sc_hd__fill_1
XFILLER_59_93 VGND VGND VPWR VPWR sky130_fd_sc_hd__decap_3
XFILLER_78_242 VGND VGND VPWR VPWR sky130_fd_sc_hd__decap_3
XFILLER_78_253 VGND VGND VPWR VPWR sky130_fd_sc_hd__decap_3
XFILLER_38_106 VGND VGND VPWR VPWR sky130_fd_sc_hd__decap_3
XFILLER_38_128 VGND VGND VPWR VPWR sky130_fd_sc_hd__decap_3
XFILLER_39_629 VGND VGND VPWR VPWR sky130_fd_sc_hd__decap_3
XFILLER_93_212 VGND VGND VPWR VPWR sky130_fd_sc_hd__decap_3
XFILLER_66_459 VGND VGND VPWR VPWR sky130_fd_sc_hd__decap_3
XFILLER_93_234 VGND VGND VPWR VPWR sky130_fd_sc_hd__decap_3
XFILLER_46_150 VGND VGND VPWR VPWR sky130_fd_sc_hd__decap_3
XFILLER_47_673 VGND VGND VPWR VPWR sky130_fd_sc_hd__fill_1
XFILLER_75_81 VGND VGND VPWR VPWR sky130_fd_sc_hd__decap_3
XFILLER_34_312 VGND VGND VPWR VPWR sky130_fd_sc_hd__decap_3
XFILLER_46_194 VGND VGND VPWR VPWR sky130_fd_sc_hd__fill_2
XFILLER_62_621 VGND VGND VPWR VPWR sky130_fd_sc_hd__fill_2
XTAP_TAPCELL_ROW_66_1113 VGND VPWR sky130_fd_sc_hd__tapvpwrvgnd_1
XFILLER_22_507 VGND VGND VPWR VPWR sky130_fd_sc_hd__decap_3
XTAP_TAPCELL_ROW_45_841 VGND VPWR sky130_fd_sc_hd__tapvpwrvgnd_1
XFILLER_15_570 VGND VGND VPWR VPWR sky130_fd_sc_hd__fill_2
XFILLER_15_581 VGND VGND VPWR VPWR sky130_fd_sc_hd__fill_1
XFILLER_61_175 VGND VGND VPWR VPWR sky130_fd_sc_hd__decap_3
X_5760_ _5867_/C _5758_/X _5759_/X VGND VGND VPWR VPWR _5760_/X sky130_fd_sc_hd__o21ba_2
X_5691_ _5727_/B _6148_/A _6497_/B _5944_/C VGND VGND VPWR VPWR _5691_/X sky130_fd_sc_hd__o2bb2a_2
X_4711_ _4711_/A VGND VGND VPWR VPWR _8293_/D sky130_fd_sc_hd__buf_1
XFILLER_30_551 VGND VGND VPWR VPWR sky130_fd_sc_hd__decap_3
X_7430_ _7844_/C _7409_/Y _7429_/X VGND VGND VPWR VPWR _7430_/Y sky130_fd_sc_hd__o21ai_2
X_4642_ _7930_/B _8125_/Q VGND VGND VPWR VPWR _4643_/A sky130_fd_sc_hd__and2_2
XFILLER_116_601 VGND VGND VPWR VPWR sky130_fd_sc_hd__decap_3
X_7361_ _8278_/Q _5422_/X _7358_/Y _8290_/Q _7360_/X VGND VGND VPWR VPWR _7361_/X
+ sky130_fd_sc_hd__a221o_2
X_4573_ _4573_/A VGND VGND VPWR VPWR _8224_/D sky130_fd_sc_hd__buf_1
XFILLER_115_100 VGND VGND VPWR VPWR sky130_fd_sc_hd__decap_3
XFILLER_115_122 VGND VGND VPWR VPWR sky130_fd_sc_hd__decap_3
XFILLER_116_645 VGND VGND VPWR VPWR sky130_fd_sc_hd__decap_3
X_7292_ _8276_/Q _5337_/X _5338_/X VGND VGND VPWR VPWR _7292_/Y sky130_fd_sc_hd__o21ai_2
X_6312_ _8184_/Q _8248_/Q VGND VGND VPWR VPWR _6312_/X sky130_fd_sc_hd__or2_2
XTAP_TAPCELL_ROW_77_1264 VGND VPWR sky130_fd_sc_hd__tapvpwrvgnd_1
XFILLER_115_166 VGND VGND VPWR VPWR sky130_fd_sc_hd__fill_2
XFILLER_116_678 VGND VGND VPWR VPWR sky130_fd_sc_hd__decap_3
X_6243_ _6529_/A _6243_/B VGND VGND VPWR VPWR _6243_/Y sky130_fd_sc_hd__nand2_2
XFILLER_103_317 VGND VGND VPWR VPWR sky130_fd_sc_hd__decap_3
XFILLER_115_188 VGND VGND VPWR VPWR sky130_fd_sc_hd__decap_3
XFILLER_69_220 VGND VGND VPWR VPWR sky130_fd_sc_hd__decap_3
XTAP_TAPCELL_ROW_90_1431 VGND VPWR sky130_fd_sc_hd__tapvpwrvgnd_1
XFILLER_69_231 VGND VGND VPWR VPWR sky130_fd_sc_hd__fill_2
XFILLER_85_702 VGND VGND VPWR VPWR sky130_fd_sc_hd__decap_3
X_6174_ _6277_/A _7827_/A _5474_/B _6623_/B _6173_/Y VGND VGND VPWR VPWR _7300_/A
+ sky130_fd_sc_hd__o32a_2
XFILLER_111_350 VGND VGND VPWR VPWR sky130_fd_sc_hd__decap_3
XFILLER_111_372 VGND VGND VPWR VPWR sky130_fd_sc_hd__decap_3
XFILLER_57_415 VGND VGND VPWR VPWR sky130_fd_sc_hd__decap_3
XFILLER_84_212 VGND VGND VPWR VPWR sky130_fd_sc_hd__decap_3
XFILLER_97_573 VGND VGND VPWR VPWR sky130_fd_sc_hd__decap_3
X_5125_ _8210_/Q _8211_/Q _5484_/S VGND VGND VPWR VPWR _5125_/X sky130_fd_sc_hd__mux2_2
XFILLER_29_128 VGND VGND VPWR VPWR sky130_fd_sc_hd__decap_3
X_5056_ _6605_/A _8255_/Q _4888_/A _5050_/X _5055_/X VGND VGND VPWR VPWR _5056_/X
+ sky130_fd_sc_hd__o221a_2
XFILLER_72_418 VGND VGND VPWR VPWR sky130_fd_sc_hd__fill_2
XFILLER_84_256 VGND VGND VPWR VPWR sky130_fd_sc_hd__decap_3
X_4007_ _4007_/A VGND VGND VPWR VPWR _7952_/D sky130_fd_sc_hd__buf_1
XFILLER_53_610 VGND VGND VPWR VPWR sky130_fd_sc_hd__decap_3
XFILLER_53_632 VGND VGND VPWR VPWR sky130_fd_sc_hd__decap_3
XFILLER_65_481 VGND VGND VPWR VPWR sky130_fd_sc_hd__decap_3
XFILLER_111_35 VGND VGND VPWR VPWR sky130_fd_sc_hd__decap_3
XFILLER_53_665 VGND VGND VPWR VPWR sky130_fd_sc_hd__decap_3
XFILLER_53_676 VGND VGND VPWR VPWR sky130_fd_sc_hd__decap_3
XFILLER_40_315 VGND VGND VPWR VPWR sky130_fd_sc_hd__decap_3
XFILLER_53_687 VGND VGND VPWR VPWR sky130_fd_sc_hd__decap_3
XFILLER_71_17 VGND VGND VPWR VPWR sky130_fd_sc_hd__decap_3
XFILLER_80_473 VGND VGND VPWR VPWR sky130_fd_sc_hd__decap_3
X_5958_ _5957_/X _5596_/X _7745_/A VGND VGND VPWR VPWR _5959_/B sky130_fd_sc_hd__mux2_2
XFILLER_52_197 VGND VGND VPWR VPWR sky130_fd_sc_hd__decap_3
X_4909_ _8178_/Q _4910_/B VGND VGND VPWR VPWR _4909_/Y sky130_fd_sc_hd__nor2_2
Xrebuffer800 _8207_/Q VGND VGND VPWR VPWR _7228_/B sky130_fd_sc_hd__buf_2
X_5889_ _5695_/S _8232_/Q _5888_/B _5027_/A VGND VGND VPWR VPWR _5889_/X sky130_fd_sc_hd__a31o_2
XTAP_TAPCELL_ROW_23_557 VGND VPWR sky130_fd_sc_hd__tapvpwrvgnd_1
X_7628_ _8291_/Q _7618_/X _7621_/Y _7627_/X VGND VGND VPWR VPWR _7628_/X sky130_fd_sc_hd__o211a_2
Xrebuffer833 _8253_/Q VGND VGND VPWR VPWR _6525_/A1 sky130_fd_sc_hd__buf_2
XFILLER_107_612 VGND VGND VPWR VPWR sky130_fd_sc_hd__decap_3
XFILLER_5_706 VGND VGND VPWR VPWR sky130_fd_sc_hd__decap_3
X_7559_ _8220_/Q _7559_/B VGND VGND VPWR VPWR _7559_/Y sky130_fd_sc_hd__nor2_4
Xrebuffer844 _7608_/X VGND VGND VPWR VPWR rebuffer844/X sky130_fd_sc_hd__buf_2
XFILLER_107_645 VGND VGND VPWR VPWR sky130_fd_sc_hd__decap_3
XFILLER_119_483 VGND VGND VPWR VPWR sky130_fd_sc_hd__decap_3
Xrebuffer888 _6232_/X VGND VGND VPWR VPWR _6233_/B sky130_fd_sc_hd__buf_2
XFILLER_106_144 VGND VGND VPWR VPWR sky130_fd_sc_hd__decap_3
XFILLER_20_76 VGND VGND VPWR VPWR sky130_fd_sc_hd__fill_2
XFILLER_106_177 VGND VGND VPWR VPWR sky130_fd_sc_hd__decap_3
XFILLER_0_455 VGND VGND VPWR VPWR sky130_fd_sc_hd__decap_3
XFILLER_96_69 VGND VGND VPWR VPWR sky130_fd_sc_hd__decap_3
XFILLER_0_488 VGND VGND VPWR VPWR sky130_fd_sc_hd__decap_3
XFILLER_102_350 VGND VGND VPWR VPWR sky130_fd_sc_hd__decap_3
XFILLER_76_713 VGND VGND VPWR VPWR sky130_fd_sc_hd__decap_3
XFILLER_102_383 VGND VGND VPWR VPWR sky130_fd_sc_hd__decap_3
XFILLER_29_96 VGND VGND VPWR VPWR sky130_fd_sc_hd__decap_3
XFILLER_75_234 VGND VGND VPWR VPWR sky130_fd_sc_hd__decap_3
XFILLER_29_662 VGND VGND VPWR VPWR sky130_fd_sc_hd__decap_3
XFILLER_29_673 VGND VGND VPWR VPWR sky130_fd_sc_hd__decap_3
XFILLER_35_109 VGND VGND VPWR VPWR sky130_fd_sc_hd__decap_3
XFILLER_75_256 VGND VGND VPWR VPWR sky130_fd_sc_hd__decap_3
XFILLER_75_267 VGND VGND VPWR VPWR sky130_fd_sc_hd__decap_3
XFILLER_90_204 VGND VGND VPWR VPWR sky130_fd_sc_hd__decap_3
XFILLER_16_312 VGND VGND VPWR VPWR sky130_fd_sc_hd__decap_3
XFILLER_28_161 VGND VGND VPWR VPWR sky130_fd_sc_hd__decap_3
XFILLER_56_470 VGND VGND VPWR VPWR sky130_fd_sc_hd__decap_3
XFILLER_90_215 VGND VGND VPWR VPWR sky130_fd_sc_hd__decap_3
XTAP_TAPCELL_ROW_3_293 VGND VPWR sky130_fd_sc_hd__tapvpwrvgnd_1
XFILLER_16_345 VGND VGND VPWR VPWR sky130_fd_sc_hd__decap_3
XFILLER_28_194 VGND VGND VPWR VPWR sky130_fd_sc_hd__fill_2
XFILLER_44_654 VGND VGND VPWR VPWR sky130_fd_sc_hd__decap_3
XFILLER_71_440 VGND VGND VPWR VPWR sky130_fd_sc_hd__decap_3
XFILLER_16_378 VGND VGND VPWR VPWR sky130_fd_sc_hd__decap_3
XFILLER_43_153 VGND VGND VPWR VPWR sky130_fd_sc_hd__decap_3
XFILLER_44_698 VGND VGND VPWR VPWR sky130_fd_sc_hd__fill_2
XTAP_TAPCELL_ROW_42_811 VGND VPWR sky130_fd_sc_hd__tapvpwrvgnd_1
XTAP_TAPCELL_ROW_42_800 VGND VPWR sky130_fd_sc_hd__tapvpwrvgnd_1
XFILLER_31_337 VGND VGND VPWR VPWR sky130_fd_sc_hd__decap_3
XFILLER_31_348 VGND VGND VPWR VPWR sky130_fd_sc_hd__decap_3
XFILLER_12_562 VGND VGND VPWR VPWR sky130_fd_sc_hd__decap_3
XFILLER_8_522 VGND VGND VPWR VPWR sky130_fd_sc_hd__decap_3
XTAP_TAPCELL_ROW_61_1054 VGND VPWR sky130_fd_sc_hd__tapvpwrvgnd_1
XFILLER_117_409 VGND VGND VPWR VPWR sky130_fd_sc_hd__decap_3
XFILLER_61_72 VGND VGND VPWR VPWR sky130_fd_sc_hd__decap_3
XFILLER_8_533 VGND VGND VPWR VPWR sky130_fd_sc_hd__decap_3
XFILLER_8_566 VGND VGND VPWR VPWR sky130_fd_sc_hd__decap_3
XANTENNA_5 _4017_/A VGND VGND VPWR VPWR sky130_fd_sc_hd__diode_2
XFILLER_113_604 VGND VGND VPWR VPWR sky130_fd_sc_hd__decap_3
XTAP_TAPCELL_ROW_113_1729 VGND VPWR sky130_fd_sc_hd__tapvpwrvgnd_1
XFILLER_112_125 VGND VGND VPWR VPWR sky130_fd_sc_hd__decap_3
XFILLER_112_147 VGND VGND VPWR VPWR sky130_fd_sc_hd__decap_3
XFILLER_98_359 VGND VGND VPWR VPWR sky130_fd_sc_hd__decap_3
XFILLER_39_426 VGND VGND VPWR VPWR sky130_fd_sc_hd__decap_3
XTAP_TAPCELL_ROW_72_1194 VGND VPWR sky130_fd_sc_hd__tapvpwrvgnd_1
XFILLER_66_212 VGND VGND VPWR VPWR sky130_fd_sc_hd__decap_3
XFILLER_66_245 VGND VGND VPWR VPWR sky130_fd_sc_hd__decap_3
XFILLER_86_80 VGND VGND VPWR VPWR sky130_fd_sc_hd__decap_3
XFILLER_86_91 VGND VGND VPWR VPWR sky130_fd_sc_hd__decap_3
XFILLER_54_418 VGND VGND VPWR VPWR sky130_fd_sc_hd__fill_2
XFILLER_66_256 VGND VGND VPWR VPWR sky130_fd_sc_hd__decap_3
XFILLER_94_576 VGND VGND VPWR VPWR sky130_fd_sc_hd__decap_3
XFILLER_19_161 VGND VGND VPWR VPWR sky130_fd_sc_hd__decap_3
XFILLER_19_172 VGND VGND VPWR VPWR sky130_fd_sc_hd__decap_3
XFILLER_47_492 VGND VGND VPWR VPWR sky130_fd_sc_hd__decap_3
XFILLER_66_289 VGND VGND VPWR VPWR sky130_fd_sc_hd__fill_1
XFILLER_81_215 VGND VGND VPWR VPWR sky130_fd_sc_hd__decap_3
XFILLER_81_237 VGND VGND VPWR VPWR sky130_fd_sc_hd__decap_3
X_6930_ _6928_/X _6929_/X _8201_/Q VGND VGND VPWR VPWR _6930_/X sky130_fd_sc_hd__mux2_2
XFILLER_35_654 VGND VGND VPWR VPWR sky130_fd_sc_hd__fill_1
X_6861_ _6852_/A _7551_/B _6860_/X _6686_/B VGND VGND VPWR VPWR _6861_/X sky130_fd_sc_hd__a2bb2o_2
XFILLER_22_304 VGND VGND VPWR VPWR sky130_fd_sc_hd__decap_3
XFILLER_22_315 VGND VGND VPWR VPWR sky130_fd_sc_hd__decap_3
XFILLER_35_676 VGND VGND VPWR VPWR sky130_fd_sc_hd__decap_3
XFILLER_35_698 VGND VGND VPWR VPWR sky130_fd_sc_hd__decap_3
XFILLER_50_602 VGND VGND VPWR VPWR sky130_fd_sc_hd__decap_3
X_6792_ _6792_/A _6792_/B _6792_/C VGND VGND VPWR VPWR _6794_/B sky130_fd_sc_hd__and3_2
X_5812_ _5812_/A _5812_/B VGND VGND VPWR VPWR _5812_/Y sky130_fd_sc_hd__nand2_2
XFILLER_34_197 VGND VGND VPWR VPWR sky130_fd_sc_hd__decap_3
XFILLER_50_668 VGND VGND VPWR VPWR sky130_fd_sc_hd__fill_1
X_5743_ _6070_/B _5740_/Y _5673_/B _5742_/X VGND VGND VPWR VPWR _5743_/X sky130_fd_sc_hd__a31o_2
XFILLER_30_381 VGND VGND VPWR VPWR sky130_fd_sc_hd__decap_3
X_5674_ _5671_/Y _5673_/Y _6247_/B VGND VGND VPWR VPWR _5674_/X sky130_fd_sc_hd__a21o_2
XTAP_TAPCELL_ROW_20_516 VGND VPWR sky130_fd_sc_hd__tapvpwrvgnd_1
X_7413_ _8216_/Q _5600_/A _5718_/A _8280_/Q VGND VGND VPWR VPWR _7413_/X sky130_fd_sc_hd__a2bb2o_2
X_8393_ _8396_/CLK _8393_/D VGND VGND VPWR VPWR _8393_/Q sky130_fd_sc_hd__dfxtp_2
X_4625_ _4625_/A VGND VGND VPWR VPWR _8250_/D sky130_fd_sc_hd__buf_1
X_7344_ _8212_/Q _8213_/Q _7344_/C VGND VGND VPWR VPWR _7424_/C sky130_fd_sc_hd__and3_2
X_4556_ _7843_/A _8082_/Q VGND VGND VPWR VPWR _4557_/A sky130_fd_sc_hd__and2_2
XFILLER_104_604 VGND VGND VPWR VPWR sky130_fd_sc_hd__decap_3
Xmax_cap252 _8225_/Q VGND VGND VPWR VPWR _5310_/B sky130_fd_sc_hd__buf_12
Xmax_cap241 _8289_/Q VGND VGND VPWR VPWR _7631_/B sky130_fd_sc_hd__buf_12
Xmax_cap230 _5181_/X VGND VGND VPWR VPWR _5182_/A sky130_fd_sc_hd__clkbuf_8
XFILLER_104_648 VGND VGND VPWR VPWR sky130_fd_sc_hd__decap_3
XFILLER_116_486 VGND VGND VPWR VPWR sky130_fd_sc_hd__fill_1
X_7275_ _7843_/C _7251_/X _7256_/X _7274_/X VGND VGND VPWR VPWR _7276_/B sky130_fd_sc_hd__a211o_2
X_4487_ _4487_/A VGND VGND VPWR VPWR _8181_/D sky130_fd_sc_hd__buf_1
XFILLER_103_125 VGND VGND VPWR VPWR sky130_fd_sc_hd__decap_3
XFILLER_103_158 VGND VGND VPWR VPWR sky130_fd_sc_hd__decap_3
X_6226_ _8289_/Q _6219_/A _6225_/Y _8290_/Q VGND VGND VPWR VPWR _6226_/X sky130_fd_sc_hd__o22a_2
XFILLER_103_169 VGND VGND VPWR VPWR sky130_fd_sc_hd__decap_3
X_6157_ _8180_/Q _8244_/Q VGND VGND VPWR VPWR _6157_/X sky130_fd_sc_hd__or2_2
XFILLER_111_191 VGND VGND VPWR VPWR sky130_fd_sc_hd__fill_2
XFILLER_112_692 VGND VGND VPWR VPWR sky130_fd_sc_hd__decap_3
XFILLER_57_234 VGND VGND VPWR VPWR sky130_fd_sc_hd__decap_3
XFILLER_97_381 VGND VGND VPWR VPWR sky130_fd_sc_hd__decap_3
X_5108_ _5108_/A VGND VGND VPWR VPWR _5108_/X sky130_fd_sc_hd__buf_1
XFILLER_57_278 VGND VGND VPWR VPWR sky130_fd_sc_hd__fill_2
X_6088_ _8178_/Q _5701_/X _6087_/X _8288_/Q VGND VGND VPWR VPWR _6088_/X sky130_fd_sc_hd__o22a_2
XFILLER_26_632 VGND VGND VPWR VPWR sky130_fd_sc_hd__decap_3
XFILLER_72_215 VGND VGND VPWR VPWR sky130_fd_sc_hd__decap_3
X_5039_ _8243_/Q _5038_/X _8179_/Q VGND VGND VPWR VPWR _5039_/X sky130_fd_sc_hd__a21bo_2
XTAP_TAPCELL_ROW_28_627 VGND VPWR sky130_fd_sc_hd__tapvpwrvgnd_1
XFILLER_25_120 VGND VGND VPWR VPWR sky130_fd_sc_hd__fill_1
XFILLER_26_654 VGND VGND VPWR VPWR sky130_fd_sc_hd__decap_3
XFILLER_82_27 VGND VGND VPWR VPWR sky130_fd_sc_hd__fill_1
XFILLER_82_38 VGND VGND VPWR VPWR sky130_fd_sc_hd__fill_1
XTAP_TAPCELL_ROW_0_241 VGND VPWR sky130_fd_sc_hd__tapvpwrvgnd_1
XTAP_TAPCELL_ROW_0_252 VGND VPWR sky130_fd_sc_hd__tapvpwrvgnd_1
XTAP_TAPCELL_ROW_0_263 VGND VPWR sky130_fd_sc_hd__tapvpwrvgnd_1
XFILLER_25_175 VGND VGND VPWR VPWR sky130_fd_sc_hd__decap_3
XFILLER_41_613 VGND VGND VPWR VPWR sky130_fd_sc_hd__decap_3
XFILLER_53_473 VGND VGND VPWR VPWR sky130_fd_sc_hd__decap_3
XFILLER_13_337 VGND VGND VPWR VPWR sky130_fd_sc_hd__fill_2
XFILLER_53_495 VGND VGND VPWR VPWR sky130_fd_sc_hd__decap_3
XFILLER_80_292 VGND VGND VPWR VPWR sky130_fd_sc_hd__decap_3
XFILLER_31_20 VGND VGND VPWR VPWR sky130_fd_sc_hd__fill_1
XFILLER_31_53 VGND VGND VPWR VPWR sky130_fd_sc_hd__decap_3
XFILLER_5_503 VGND VGND VPWR VPWR sky130_fd_sc_hd__fill_1
XFILLER_31_64 VGND VGND VPWR VPWR sky130_fd_sc_hd__decap_3
Xrebuffer685 _6814_/Y VGND VGND VPWR VPWR _6815_/B sky130_fd_sc_hd__buf_2
XFILLER_107_464 VGND VGND VPWR VPWR sky130_fd_sc_hd__decap_3
XTAP_TAPCELL_ROW_8_363 VGND VPWR sky130_fd_sc_hd__tapvpwrvgnd_1
XFILLER_0_241 VGND VGND VPWR VPWR sky130_fd_sc_hd__decap_3
XFILLER_110_618 VGND VGND VPWR VPWR sky130_fd_sc_hd__decap_3
XFILLER_95_318 VGND VGND VPWR VPWR sky130_fd_sc_hd__decap_3
Xinput120 operand_b[55] VGND VGND VPWR VPWR _4414_/B sky130_fd_sc_hd__clkdlybuf4s25_1
XFILLER_0_274 VGND VGND VPWR VPWR sky130_fd_sc_hd__decap_3
XFILLER_102_180 VGND VGND VPWR VPWR sky130_fd_sc_hd__decap_3
XFILLER_103_681 VGND VGND VPWR VPWR sky130_fd_sc_hd__fill_2
Xinput131 operand_b[7] VGND VGND VPWR VPWR _4318_/B sky130_fd_sc_hd__clkdlybuf4s25_1
XFILLER_36_418 VGND VGND VPWR VPWR sky130_fd_sc_hd__fill_2
XFILLER_48_245 VGND VGND VPWR VPWR sky130_fd_sc_hd__decap_3
XFILLER_48_256 VGND VGND VPWR VPWR sky130_fd_sc_hd__decap_3
XFILLER_76_554 VGND VGND VPWR VPWR sky130_fd_sc_hd__decap_3
XFILLER_29_470 VGND VGND VPWR VPWR sky130_fd_sc_hd__decap_3
XFILLER_48_289 VGND VGND VPWR VPWR sky130_fd_sc_hd__decap_3
XFILLER_56_61 VGND VGND VPWR VPWR sky130_fd_sc_hd__decap_3
XFILLER_63_204 VGND VGND VPWR VPWR sky130_fd_sc_hd__decap_3
XFILLER_63_237 VGND VGND VPWR VPWR sky130_fd_sc_hd__decap_3
XFILLER_76_598 VGND VGND VPWR VPWR sky130_fd_sc_hd__fill_2
XFILLER_56_94 VGND VGND VPWR VPWR sky130_fd_sc_hd__decap_3
XFILLER_91_557 VGND VGND VPWR VPWR sky130_fd_sc_hd__decap_3
XFILLER_16_153 VGND VGND VPWR VPWR sky130_fd_sc_hd__decap_3
XFILLER_17_687 VGND VGND VPWR VPWR sky130_fd_sc_hd__decap_3
XFILLER_32_624 VGND VGND VPWR VPWR sky130_fd_sc_hd__decap_3
XFILLER_44_451 VGND VGND VPWR VPWR sky130_fd_sc_hd__decap_3
XTAP_TAPCELL_ROW_55_980 VGND VPWR sky130_fd_sc_hd__tapvpwrvgnd_1
XFILLER_16_186 VGND VGND VPWR VPWR sky130_fd_sc_hd__decap_3
XFILLER_44_495 VGND VGND VPWR VPWR sky130_fd_sc_hd__decap_3
XFILLER_118_707 VGND VGND VPWR VPWR sky130_fd_sc_hd__decap_3
XFILLER_40_690 VGND VGND VPWR VPWR sky130_fd_sc_hd__decap_3
XFILLER_8_396 VGND VGND VPWR VPWR sky130_fd_sc_hd__decap_3
X_4410_ _7930_/B _4410_/B VGND VGND VPWR VPWR _4411_/A sky130_fd_sc_hd__and2_2
X_5390_ _5252_/X _5253_/X _5254_/X _5263_/X _7783_/A _5684_/S VGND VGND VPWR VPWR
+ _5390_/X sky130_fd_sc_hd__mux4_2
XFILLER_113_401 VGND VGND VPWR VPWR sky130_fd_sc_hd__decap_3
XFILLER_99_613 VGND VGND VPWR VPWR sky130_fd_sc_hd__decap_3
X_4341_ _4341_/A VGND VGND VPWR VPWR _8108_/D sky130_fd_sc_hd__buf_1
XTAP_TAPCELL_ROW_74_1223 VGND VPWR sky130_fd_sc_hd__tapvpwrvgnd_1
XFILLER_98_156 VGND VGND VPWR VPWR sky130_fd_sc_hd__decap_3
XFILLER_99_679 VGND VGND VPWR VPWR sky130_fd_sc_hd__fill_2
X_7060_ _7059_/X _7019_/X _6949_/X _6889_/X _7812_/A _7670_/A VGND VGND VPWR VPWR
+ _7060_/X sky130_fd_sc_hd__mux4_2
X_4272_ _7843_/A _4272_/B VGND VGND VPWR VPWR _4273_/A sky130_fd_sc_hd__and2_2
XFILLER_101_607 VGND VGND VPWR VPWR sky130_fd_sc_hd__decap_3
XFILLER_101_629 VGND VGND VPWR VPWR sky130_fd_sc_hd__fill_2
XFILLER_86_318 VGND VGND VPWR VPWR sky130_fd_sc_hd__decap_3
X_6011_ _6529_/A VGND VGND VPWR VPWR _6011_/X sky130_fd_sc_hd__clkbuf_1
XFILLER_100_117 VGND VGND VPWR VPWR sky130_fd_sc_hd__decap_3
XFILLER_100_139 VGND VGND VPWR VPWR sky130_fd_sc_hd__fill_1
XFILLER_39_212 VGND VGND VPWR VPWR sky130_fd_sc_hd__decap_3
XFILLER_67_521 VGND VGND VPWR VPWR sky130_fd_sc_hd__decap_3
Xsplit261 _6355_/A VGND VGND VPWR VPWR _6321_/B sky130_fd_sc_hd__buf_8
Xsplit272 _5943_/C VGND VGND VPWR VPWR _5897_/A sky130_fd_sc_hd__buf_4
XFILLER_27_418 VGND VGND VPWR VPWR sky130_fd_sc_hd__decap_3
XFILLER_54_215 VGND VGND VPWR VPWR sky130_fd_sc_hd__decap_3
XFILLER_67_598 VGND VGND VPWR VPWR sky130_fd_sc_hd__fill_2
XFILLER_94_395 VGND VGND VPWR VPWR sky130_fd_sc_hd__decap_3
X_7962_ _8388_/CLK _7962_/D VGND VGND VPWR VPWR _7962_/Q sky130_fd_sc_hd__dfxtp_2
XFILLER_54_259 VGND VGND VPWR VPWR sky130_fd_sc_hd__decap_3
X_6913_ _7167_/B _6913_/B VGND VGND VPWR VPWR _6914_/B sky130_fd_sc_hd__xnor2_2
X_7893_ _7893_/A VGND VGND VPWR VPWR _8383_/D sky130_fd_sc_hd__buf_1
XTAP_TAPCELL_ROW_85_1363 VGND VPWR sky130_fd_sc_hd__tapvpwrvgnd_1
XFILLER_22_112 VGND VGND VPWR VPWR sky130_fd_sc_hd__decap_3
XFILLER_50_410 VGND VGND VPWR VPWR sky130_fd_sc_hd__decap_3
XFILLER_50_421 VGND VGND VPWR VPWR sky130_fd_sc_hd__decap_3
XFILLER_62_292 VGND VGND VPWR VPWR sky130_fd_sc_hd__decap_3
X_6844_ _7305_/A1 _6810_/X _6843_/X _7930_/B VGND VGND VPWR VPWR _8332_/D sky130_fd_sc_hd__o211a_2
XFILLER_22_145 VGND VGND VPWR VPWR sky130_fd_sc_hd__decap_3
XFILLER_22_167 VGND VGND VPWR VPWR sky130_fd_sc_hd__decap_3
XFILLER_50_454 VGND VGND VPWR VPWR sky130_fd_sc_hd__fill_2
X_6775_ _7631_/B _6775_/B VGND VGND VPWR VPWR _6775_/X sky130_fd_sc_hd__or2_2
X_3987_ _3987_/A VGND VGND VPWR VPWR _7942_/D sky130_fd_sc_hd__buf_1
X_5726_ _6999_/A1 _5724_/X _5725_/X VGND VGND VPWR VPWR _5726_/X sky130_fd_sc_hd__a21o_2
XTAP_TAPCELL_ROW_33_685 VGND VPWR sky130_fd_sc_hd__tapvpwrvgnd_1
XFILLER_108_206 VGND VGND VPWR VPWR sky130_fd_sc_hd__decap_3
XFILLER_109_729 VGND VGND VPWR VPWR sky130_fd_sc_hd__decap_3
XFILLER_108_239 VGND VGND VPWR VPWR sky130_fd_sc_hd__decap_3
X_5657_ _4953_/A _5651_/Y _5584_/A VGND VGND VPWR VPWR _5657_/X sky130_fd_sc_hd__a21o_2
XFILLER_117_12 VGND VGND VPWR VPWR sky130_fd_sc_hd__decap_3
X_8376_ _8379_/CLK _8376_/D VGND VGND VPWR VPWR _8376_/Q sky130_fd_sc_hd__dfxtp_2
X_5588_ _5585_/A _5587_/X _5592_/B _5626_/A VGND VGND VPWR VPWR _5588_/X sky130_fd_sc_hd__a31o_2
X_4608_ _7898_/B _8108_/Q VGND VGND VPWR VPWR _4609_/A sky130_fd_sc_hd__and2_2
XFILLER_116_250 VGND VGND VPWR VPWR sky130_fd_sc_hd__fill_2
XFILLER_116_283 VGND VGND VPWR VPWR sky130_fd_sc_hd__decap_3
XFILLER_2_528 VGND VGND VPWR VPWR sky130_fd_sc_hd__decap_3
X_7327_ _8213_/Q _8277_/Q VGND VGND VPWR VPWR _7327_/X sky130_fd_sc_hd__or2_2
X_4539_ _4539_/A VGND VGND VPWR VPWR _8207_/D sky130_fd_sc_hd__buf_1
XFILLER_89_134 VGND VGND VPWR VPWR sky130_fd_sc_hd__decap_3
X_7258_ _6686_/B _7257_/X _6767_/Y _8211_/Q VGND VGND VPWR VPWR _7258_/X sky130_fd_sc_hd__o2bb2a_2
XFILLER_77_329 VGND VGND VPWR VPWR sky130_fd_sc_hd__decap_3
XFILLER_77_38 VGND VGND VPWR VPWR sky130_fd_sc_hd__decap_3
XFILLER_89_167 VGND VGND VPWR VPWR sky130_fd_sc_hd__fill_1
XFILLER_89_178 VGND VGND VPWR VPWR sky130_fd_sc_hd__decap_3
X_6209_ _8180_/Q _8244_/Q VGND VGND VPWR VPWR _6394_/A sky130_fd_sc_hd__and2b_2
XTAP_TAPCELL_ROW_5_322 VGND VPWR sky130_fd_sc_hd__tapvpwrvgnd_1
X_7189_ _8209_/Q _8273_/Q VGND VGND VPWR VPWR _7189_/X sky130_fd_sc_hd__or2_2
XFILLER_100_651 VGND VGND VPWR VPWR sky130_fd_sc_hd__decap_3
XFILLER_85_340 VGND VGND VPWR VPWR sky130_fd_sc_hd__decap_3
XFILLER_100_684 VGND VGND VPWR VPWR sky130_fd_sc_hd__decap_3
XFILLER_58_587 VGND VGND VPWR VPWR sky130_fd_sc_hd__fill_1
XFILLER_73_535 VGND VGND VPWR VPWR sky130_fd_sc_hd__decap_3
XFILLER_93_26 VGND VGND VPWR VPWR sky130_fd_sc_hd__decap_3
XFILLER_26_20 VGND VGND VPWR VPWR sky130_fd_sc_hd__decap_3
XFILLER_26_42 VGND VGND VPWR VPWR sky130_fd_sc_hd__fill_2
XFILLER_45_237 VGND VGND VPWR VPWR sky130_fd_sc_hd__decap_3
XFILLER_61_708 VGND VGND VPWR VPWR sky130_fd_sc_hd__decap_3
XFILLER_41_421 VGND VGND VPWR VPWR sky130_fd_sc_hd__decap_3
XFILLER_81_590 VGND VGND VPWR VPWR sky130_fd_sc_hd__decap_3
XFILLER_13_167 VGND VGND VPWR VPWR sky130_fd_sc_hd__fill_1
XFILLER_9_116 VGND VGND VPWR VPWR sky130_fd_sc_hd__decap_3
XFILLER_42_41 VGND VGND VPWR VPWR sky130_fd_sc_hd__decap_3
XFILLER_42_85 VGND VGND VPWR VPWR sky130_fd_sc_hd__decap_3
XFILLER_5_322 VGND VGND VPWR VPWR sky130_fd_sc_hd__decap_3
XFILLER_107_250 VGND VGND VPWR VPWR sky130_fd_sc_hd__decap_3
XFILLER_5_388 VGND VGND VPWR VPWR sky130_fd_sc_hd__decap_3
XFILLER_107_294 VGND VGND VPWR VPWR sky130_fd_sc_hd__decap_3
XFILLER_110_415 VGND VGND VPWR VPWR sky130_fd_sc_hd__decap_3
XFILLER_3_46 VGND VGND VPWR VPWR sky130_fd_sc_hd__decap_3
XFILLER_68_307 VGND VGND VPWR VPWR sky130_fd_sc_hd__fill_1
XFILLER_68_318 VGND VGND VPWR VPWR sky130_fd_sc_hd__decap_3
XFILLER_96_627 VGND VGND VPWR VPWR sky130_fd_sc_hd__decap_3
XFILLER_67_60 VGND VGND VPWR VPWR sky130_fd_sc_hd__decap_3
XFILLER_95_148 VGND VGND VPWR VPWR sky130_fd_sc_hd__decap_3
XFILLER_36_215 VGND VGND VPWR VPWR sky130_fd_sc_hd__fill_2
XFILLER_49_587 VGND VGND VPWR VPWR sky130_fd_sc_hd__decap_3
XFILLER_76_395 VGND VGND VPWR VPWR sky130_fd_sc_hd__decap_3
XFILLER_36_248 VGND VGND VPWR VPWR sky130_fd_sc_hd__decap_3
XFILLER_64_557 VGND VGND VPWR VPWR sky130_fd_sc_hd__decap_3
XFILLER_91_343 VGND VGND VPWR VPWR sky130_fd_sc_hd__decap_3
XFILLER_91_387 VGND VGND VPWR VPWR sky130_fd_sc_hd__decap_3
XFILLER_32_421 VGND VGND VPWR VPWR sky130_fd_sc_hd__decap_3
X_4890_ _8246_/Q _4890_/B VGND VGND VPWR VPWR _4891_/B sky130_fd_sc_hd__and2b_2
XFILLER_32_443 VGND VGND VPWR VPWR sky130_fd_sc_hd__decap_3
XTAP_TAPCELL_ROW_50_909 VGND VPWR sky130_fd_sc_hd__tapvpwrvgnd_1
XFILLER_80_3 VGND VGND VPWR VPWR sky130_fd_sc_hd__decap_3
X_6560_ _6792_/C _6560_/B VGND VGND VPWR VPWR _6560_/Y sky130_fd_sc_hd__xnor2_2
X_5511_ _8164_/Q _5511_/B VGND VGND VPWR VPWR _5512_/B sky130_fd_sc_hd__or2_4
XTAP_TAPCELL_ROW_80_1293 VGND VPWR sky130_fd_sc_hd__tapvpwrvgnd_1
XTAP_TAPCELL_ROW_30_655 VGND VPWR sky130_fd_sc_hd__tapvpwrvgnd_1
XTAP_TAPCELL_ROW_30_644 VGND VPWR sky130_fd_sc_hd__tapvpwrvgnd_1
XFILLER_118_526 VGND VGND VPWR VPWR sky130_fd_sc_hd__decap_3
XFILLER_8_171 VGND VGND VPWR VPWR sky130_fd_sc_hd__fill_2
XFILLER_9_683 VGND VGND VPWR VPWR sky130_fd_sc_hd__fill_2
X_6491_ _8181_/Q _8184_/Q _8187_/Q _6491_/D VGND VGND VPWR VPWR _6825_/C sky130_fd_sc_hd__nand4_2
XFILLER_8_182 VGND VGND VPWR VPWR sky130_fd_sc_hd__decap_3
X_8230_ clkload7/A _8230_/D VGND VGND VPWR VPWR _8230_/Q sky130_fd_sc_hd__dfxtp_2
X_5442_ _6421_/S _5441_/X _6247_/B VGND VGND VPWR VPWR _5442_/X sky130_fd_sc_hd__a21o_2
XTAP_TAPCELL_ROW_10_390 VGND VPWR sky130_fd_sc_hd__tapvpwrvgnd_1
X_8161_ clkload8/A _8161_/D VGND VGND VPWR VPWR _8161_/Q sky130_fd_sc_hd__dfxtp_4
X_5373_ _5164_/X _5160_/X _5384_/S VGND VGND VPWR VPWR _5373_/X sky130_fd_sc_hd__mux2_2
X_8092_ _8229_/CLK _8092_/D VGND VGND VPWR VPWR _8092_/Q sky130_fd_sc_hd__dfxtp_2
X_7112_ _7228_/B _8206_/Q _8205_/Q _8204_/Q _6380_/S _5452_/S VGND VGND VPWR VPWR
+ _7112_/X sky130_fd_sc_hd__mux4_2
X_4324_ _7898_/B _4324_/B VGND VGND VPWR VPWR _4325_/A sky130_fd_sc_hd__and2_2
XFILLER_113_242 VGND VGND VPWR VPWR sky130_fd_sc_hd__decap_3
X_7043_ _8269_/Q _6775_/X _7042_/Y _5278_/X VGND VGND VPWR VPWR _7044_/C sky130_fd_sc_hd__o22a_2
XFILLER_47_19 VGND VGND VPWR VPWR sky130_fd_sc_hd__decap_3
XFILLER_86_126 VGND VGND VPWR VPWR sky130_fd_sc_hd__decap_3
X_4255_ _4255_/A VGND VGND VPWR VPWR _8065_/D sky130_fd_sc_hd__buf_1
XFILLER_67_340 VGND VGND VPWR VPWR sky130_fd_sc_hd__decap_3
X_4186_ _7898_/B _4186_/B VGND VGND VPWR VPWR _4187_/A sky130_fd_sc_hd__and2_2
XFILLER_27_215 VGND VGND VPWR VPWR sky130_fd_sc_hd__decap_3
XFILLER_55_535 VGND VGND VPWR VPWR sky130_fd_sc_hd__decap_3
XFILLER_67_373 VGND VGND VPWR VPWR sky130_fd_sc_hd__decap_3
XFILLER_95_682 VGND VGND VPWR VPWR sky130_fd_sc_hd__decap_3
XFILLER_103_25 VGND VGND VPWR VPWR sky130_fd_sc_hd__decap_3
XFILLER_27_237 VGND VGND VPWR VPWR sky130_fd_sc_hd__decap_3
XFILLER_55_557 VGND VGND VPWR VPWR sky130_fd_sc_hd__decap_3
XFILLER_55_568 VGND VGND VPWR VPWR sky130_fd_sc_hd__decap_3
XFILLER_82_332 VGND VGND VPWR VPWR sky130_fd_sc_hd__fill_1
XTAP_TAPCELL_ROW_38_755 VGND VPWR sky130_fd_sc_hd__tapvpwrvgnd_1
XFILLER_63_29 VGND VGND VPWR VPWR sky130_fd_sc_hd__decap_3
XFILLER_70_516 VGND VGND VPWR VPWR sky130_fd_sc_hd__decap_3
XFILLER_82_365 VGND VGND VPWR VPWR sky130_fd_sc_hd__decap_3
XPHY_EDGE_ROW_118_Right_118 VGND VGND VPWR VPWR sky130_fd_sc_hd__decap_3
X_7945_ _8349_/CLK _7945_/D VGND VGND VPWR VPWR _7945_/Q sky130_fd_sc_hd__dfxtp_2
XFILLER_35_281 VGND VGND VPWR VPWR sky130_fd_sc_hd__decap_3
XFILLER_82_398 VGND VGND VPWR VPWR sky130_fd_sc_hd__decap_3
X_7876_ _8308_/Q _7898_/B VGND VGND VPWR VPWR _7877_/A sky130_fd_sc_hd__and2_2
XFILLER_50_240 VGND VGND VPWR VPWR sky130_fd_sc_hd__decap_3
X_6827_ _8197_/Q _6927_/B VGND VGND VPWR VPWR _6828_/B sky130_fd_sc_hd__nand2_2
XTAP_TAPCELL_ROW_18_490 VGND VPWR sky130_fd_sc_hd__tapvpwrvgnd_1
XFILLER_23_487 VGND VGND VPWR VPWR sky130_fd_sc_hd__decap_3
XFILLER_50_284 VGND VGND VPWR VPWR sky130_fd_sc_hd__decap_3
XFILLER_50_295 VGND VGND VPWR VPWR sky130_fd_sc_hd__decap_3
XFILLER_7_609 VGND VGND VPWR VPWR sky130_fd_sc_hd__decap_3
X_6758_ _7209_/A _6739_/Y _6747_/X _6757_/Y VGND VGND VPWR VPWR _6758_/X sky130_fd_sc_hd__a211o_4
XFILLER_109_526 VGND VGND VPWR VPWR sky130_fd_sc_hd__decap_3
X_6689_ _6721_/A _6679_/X _6683_/X _8290_/Q _6688_/X VGND VGND VPWR VPWR _6689_/X
+ sky130_fd_sc_hd__a221o_2
X_5709_ _5867_/A _5709_/B VGND VGND VPWR VPWR _5709_/X sky130_fd_sc_hd__xor2_2
XTAP_TAPCELL_ROW_98_1532 VGND VPWR sky130_fd_sc_hd__tapvpwrvgnd_1
XFILLER_12_88 VGND VGND VPWR VPWR sky130_fd_sc_hd__decap_3
XFILLER_2_303 VGND VGND VPWR VPWR sky130_fd_sc_hd__decap_3
XFILLER_88_26 VGND VGND VPWR VPWR sky130_fd_sc_hd__fill_2
X_8359_ _8359_/CLK _8359_/D VGND VGND VPWR VPWR _8359_/Q sky130_fd_sc_hd__dfxtp_2
XFILLER_105_732 VGND VGND VPWR VPWR sky130_fd_sc_hd__fill_1
XFILLER_88_48 VGND VGND VPWR VPWR sky130_fd_sc_hd__decap_3
XFILLER_104_242 VGND VGND VPWR VPWR sky130_fd_sc_hd__decap_3
XFILLER_104_253 VGND VGND VPWR VPWR sky130_fd_sc_hd__decap_3
XFILLER_104_297 VGND VGND VPWR VPWR sky130_fd_sc_hd__decap_3
XFILLER_77_137 VGND VGND VPWR VPWR sky130_fd_sc_hd__decap_3
XFILLER_58_351 VGND VGND VPWR VPWR sky130_fd_sc_hd__decap_3
XFILLER_77_159 VGND VGND VPWR VPWR sky130_fd_sc_hd__decap_3
XFILLER_86_660 VGND VGND VPWR VPWR sky130_fd_sc_hd__decap_3
XFILLER_18_259 VGND VGND VPWR VPWR sky130_fd_sc_hd__decap_3
XFILLER_37_74 VGND VGND VPWR VPWR sky130_fd_sc_hd__fill_1
XFILLER_58_395 VGND VGND VPWR VPWR sky130_fd_sc_hd__decap_3
XFILLER_73_343 VGND VGND VPWR VPWR sky130_fd_sc_hd__fill_2
XFILLER_33_207 VGND VGND VPWR VPWR sky130_fd_sc_hd__decap_3
XFILLER_46_579 VGND VGND VPWR VPWR sky130_fd_sc_hd__decap_3
XFILLER_61_505 VGND VGND VPWR VPWR sky130_fd_sc_hd__decap_3
XFILLER_73_365 VGND VGND VPWR VPWR sky130_fd_sc_hd__decap_3
XTAP_TAPCELL_ROW_107_1650 VGND VPWR sky130_fd_sc_hd__tapvpwrvgnd_1
XFILLER_14_421 VGND VGND VPWR VPWR sky130_fd_sc_hd__decap_3
XFILLER_61_549 VGND VGND VPWR VPWR sky130_fd_sc_hd__decap_3
XFILLER_14_465 VGND VGND VPWR VPWR sky130_fd_sc_hd__decap_3
XFILLER_26_292 VGND VGND VPWR VPWR sky130_fd_sc_hd__decap_3
XFILLER_53_84 VGND VGND VPWR VPWR sky130_fd_sc_hd__decap_3
XFILLER_6_620 VGND VGND VPWR VPWR sky130_fd_sc_hd__decap_3
XFILLER_6_631 VGND VGND VPWR VPWR sky130_fd_sc_hd__decap_3
XTAP_TAPCELL_ROW_58_1015 VGND VPWR sky130_fd_sc_hd__tapvpwrvgnd_1
XFILLER_6_664 VGND VGND VPWR VPWR sky130_fd_sc_hd__decap_3
XFILLER_6_686 VGND VGND VPWR VPWR sky130_fd_sc_hd__decap_3
XTAP_TAPCELL_ROW_118_1790 VGND VPWR sky130_fd_sc_hd__tapvpwrvgnd_1
Xrebuffer290 rebuffer844/X VGND VGND VPWR VPWR _7840_/B sky130_fd_sc_hd__buf_6
XFILLER_108_581 VGND VGND VPWR VPWR sky130_fd_sc_hd__decap_3
XFILLER_108_592 VGND VGND VPWR VPWR sky130_fd_sc_hd__decap_3
XFILLER_5_185 VGND VGND VPWR VPWR sky130_fd_sc_hd__decap_3
XFILLER_69_605 VGND VGND VPWR VPWR sky130_fd_sc_hd__decap_3
XFILLER_110_212 VGND VGND VPWR VPWR sky130_fd_sc_hd__decap_3
XFILLER_96_424 VGND VGND VPWR VPWR sky130_fd_sc_hd__decap_3
XFILLER_110_245 VGND VGND VPWR VPWR sky130_fd_sc_hd__decap_3
XFILLER_110_256 VGND VGND VPWR VPWR sky130_fd_sc_hd__decap_3
XFILLER_1_391 VGND VGND VPWR VPWR sky130_fd_sc_hd__fill_1
XFILLER_68_159 VGND VGND VPWR VPWR sky130_fd_sc_hd__decap_3
XFILLER_96_457 VGND VGND VPWR VPWR sky130_fd_sc_hd__decap_3
X_4040_ _7930_/B _8361_/Q VGND VGND VPWR VPWR _4041_/A sky130_fd_sc_hd__and2_2
XFILLER_110_289 VGND VGND VPWR VPWR sky130_fd_sc_hd__fill_1
XFILLER_49_373 VGND VGND VPWR VPWR sky130_fd_sc_hd__decap_3
XFILLER_83_129 VGND VGND VPWR VPWR sky130_fd_sc_hd__fill_1
XFILLER_64_321 VGND VGND VPWR VPWR sky130_fd_sc_hd__decap_3
XFILLER_76_181 VGND VGND VPWR VPWR sky130_fd_sc_hd__decap_3
XFILLER_92_641 VGND VGND VPWR VPWR sky130_fd_sc_hd__decap_3
XFILLER_24_218 VGND VGND VPWR VPWR sky130_fd_sc_hd__decap_3
XFILLER_52_516 VGND VGND VPWR VPWR sky130_fd_sc_hd__decap_3
XFILLER_52_527 VGND VGND VPWR VPWR sky130_fd_sc_hd__decap_3
XFILLER_64_354 VGND VGND VPWR VPWR sky130_fd_sc_hd__decap_3
XFILLER_64_365 VGND VGND VPWR VPWR sky130_fd_sc_hd__decap_3
XFILLER_91_140 VGND VGND VPWR VPWR sky130_fd_sc_hd__fill_1
XFILLER_91_162 VGND VGND VPWR VPWR sky130_fd_sc_hd__decap_3
XFILLER_94_91 VGND VGND VPWR VPWR sky130_fd_sc_hd__decap_3
X_5991_ _5933_/A _6302_/C _8238_/Q VGND VGND VPWR VPWR _5993_/A sky130_fd_sc_hd__a21o_2
XTAP_TAPCELL_ROW_69_1155 VGND VPWR sky130_fd_sc_hd__tapvpwrvgnd_1
XTAP_TAPCELL_ROW_35_714 VGND VPWR sky130_fd_sc_hd__tapvpwrvgnd_1
XFILLER_17_281 VGND VGND VPWR VPWR sky130_fd_sc_hd__decap_3
XFILLER_64_387 VGND VGND VPWR VPWR sky130_fd_sc_hd__decap_3
X_7730_ _5950_/A _7728_/Y _7729_/Y _7796_/A VGND VGND VPWR VPWR _7730_/X sky130_fd_sc_hd__a22o_2
X_4942_ _8167_/Q _8231_/Q VGND VGND VPWR VPWR _5888_/C sky130_fd_sc_hd__and2b_2
XTAP_TAPCELL_ROW_82_1322 VGND VPWR sky130_fd_sc_hd__tapvpwrvgnd_1
X_7661_ _7670_/A _7661_/B VGND VGND VPWR VPWR _7662_/A sky130_fd_sc_hd__or2_2
XFILLER_20_413 VGND VGND VPWR VPWR sky130_fd_sc_hd__decap_3
XFILLER_20_424 VGND VGND VPWR VPWR sky130_fd_sc_hd__decap_3
XFILLER_32_284 VGND VGND VPWR VPWR sky130_fd_sc_hd__decap_3
XFILLER_60_582 VGND VGND VPWR VPWR sky130_fd_sc_hd__decap_3
XTAP_TAPCELL_ROW_15_460 VGND VPWR sky130_fd_sc_hd__tapvpwrvgnd_1
X_6612_ _8256_/Q _5337_/X _6936_/A2 VGND VGND VPWR VPWR _6612_/Y sky130_fd_sc_hd__o21ai_2
X_4873_ _4873_/A _6400_/A VGND VGND VPWR VPWR _6286_/A sky130_fd_sc_hd__nand2_2
X_7592_ _7591_/X _7527_/X _7478_/X _7418_/X _7812_/A _7670_/A VGND VGND VPWR VPWR
+ _7592_/X sky130_fd_sc_hd__mux4_2
XFILLER_20_468 VGND VGND VPWR VPWR sky130_fd_sc_hd__decap_3
X_6543_ _8190_/Q _5701_/X _6542_/X _8288_/Q VGND VGND VPWR VPWR _6543_/X sky130_fd_sc_hd__o22a_2
X_6474_ _8186_/Q _4886_/B _6472_/X _4876_/B VGND VGND VPWR VPWR _6476_/C sky130_fd_sc_hd__a31o_2
XFILLER_106_518 VGND VGND VPWR VPWR sky130_fd_sc_hd__decap_3
XPHY_EDGE_ROW_12_Right_12 VGND VGND VPWR VPWR sky130_fd_sc_hd__decap_3
X_8213_ _8359_/CLK _8213_/D VGND VGND VPWR VPWR _8213_/Q sky130_fd_sc_hd__dfxtp_2
X_5425_ _6648_/A _8163_/Q _5422_/X _5424_/X VGND VGND VPWR VPWR _5425_/X sky130_fd_sc_hd__o22a_2
XFILLER_58_29 VGND VGND VPWR VPWR sky130_fd_sc_hd__decap_3
XFILLER_99_251 VGND VGND VPWR VPWR sky130_fd_sc_hd__decap_3
X_8144_ _8280_/CLK _8144_/D VGND VGND VPWR VPWR _8144_/Q sky130_fd_sc_hd__dfxtp_2
X_5356_ _5156_/X _5152_/X _5444_/S VGND VGND VPWR VPWR _5356_/X sky130_fd_sc_hd__mux2_2
XTAP_TAPCELL_ROW_93_1473 VGND VPWR sky130_fd_sc_hd__tapvpwrvgnd_1
XTAP_TAPCELL_ROW_93_1462 VGND VPWR sky130_fd_sc_hd__tapvpwrvgnd_1
XFILLER_114_595 VGND VGND VPWR VPWR sky130_fd_sc_hd__fill_2
X_8075_ _8218_/CLK _8075_/D VGND VGND VPWR VPWR _8075_/Q sky130_fd_sc_hd__dfxtp_2
X_5287_ _5286_/A _8292_/Q split/A VGND VGND VPWR VPWR _5288_/B sky130_fd_sc_hd__o21ba_2
X_4307_ _4307_/A VGND VGND VPWR VPWR _8091_/D sky130_fd_sc_hd__buf_1
XFILLER_101_234 VGND VGND VPWR VPWR sky130_fd_sc_hd__decap_3
XFILLER_114_24 VGND VGND VPWR VPWR sky130_fd_sc_hd__decap_3
XFILLER_59_148 VGND VGND VPWR VPWR sky130_fd_sc_hd__decap_3
XFILLER_87_479 VGND VGND VPWR VPWR sky130_fd_sc_hd__decap_3
X_7026_ _8268_/Q _7027_/B _8204_/Q VGND VGND VPWR VPWR _7028_/B sky130_fd_sc_hd__o21ai_2
X_4238_ _7898_/B _4238_/B VGND VGND VPWR VPWR _4239_/A sky130_fd_sc_hd__and2_2
XFILLER_114_35 VGND VGND VPWR VPWR sky130_fd_sc_hd__decap_3
XFILLER_68_682 VGND VGND VPWR VPWR sky130_fd_sc_hd__decap_3
XFILLER_74_118 VGND VGND VPWR VPWR sky130_fd_sc_hd__decap_3
XFILLER_28_557 VGND VGND VPWR VPWR sky130_fd_sc_hd__fill_1
XFILLER_55_343 VGND VGND VPWR VPWR sky130_fd_sc_hd__decap_3
XFILLER_83_652 VGND VGND VPWR VPWR sky130_fd_sc_hd__decap_3
X_4169_ _4169_/A VGND VGND VPWR VPWR _8022_/D sky130_fd_sc_hd__buf_1
XFILLER_15_207 VGND VGND VPWR VPWR sky130_fd_sc_hd__fill_2
XFILLER_28_579 VGND VGND VPWR VPWR sky130_fd_sc_hd__decap_3
XFILLER_43_505 VGND VGND VPWR VPWR sky130_fd_sc_hd__fill_1
XPHY_EDGE_ROW_21_Right_21 VGND VGND VPWR VPWR sky130_fd_sc_hd__decap_3
XFILLER_15_218 VGND VGND VPWR VPWR sky130_fd_sc_hd__decap_3
XFILLER_43_527 VGND VGND VPWR VPWR sky130_fd_sc_hd__decap_3
XFILLER_43_549 VGND VGND VPWR VPWR sky130_fd_sc_hd__fill_2
XFILLER_55_387 VGND VGND VPWR VPWR sky130_fd_sc_hd__decap_3
XFILLER_70_324 VGND VGND VPWR VPWR sky130_fd_sc_hd__decap_3
X_7928_ _8334_/Q _7930_/B VGND VGND VPWR VPWR _7929_/A sky130_fd_sc_hd__and2_2
XFILLER_70_346 VGND VGND VPWR VPWR sky130_fd_sc_hd__decap_3
XFILLER_70_357 VGND VGND VPWR VPWR sky130_fd_sc_hd__decap_3
XFILLER_70_368 VGND VGND VPWR VPWR sky130_fd_sc_hd__decap_3
XFILLER_90_38 VGND VGND VPWR VPWR sky130_fd_sc_hd__decap_3
X_7859_ _7859_/A VGND VGND VPWR VPWR _8366_/D sky130_fd_sc_hd__buf_1
XFILLER_23_284 VGND VGND VPWR VPWR sky130_fd_sc_hd__decap_3
XFILLER_23_43 VGND VGND VPWR VPWR sky130_fd_sc_hd__decap_3
XTAP_TAPCELL_ROW_102_1580 VGND VPWR sky130_fd_sc_hd__tapvpwrvgnd_1
XTAP_TAPCELL_ROW_102_1591 VGND VPWR sky130_fd_sc_hd__tapvpwrvgnd_1
XFILLER_23_76 VGND VGND VPWR VPWR sky130_fd_sc_hd__fill_2
XFILLER_7_439 VGND VGND VPWR VPWR sky130_fd_sc_hd__decap_3
XFILLER_109_334 VGND VGND VPWR VPWR sky130_fd_sc_hd__fill_2
XFILLER_99_47 VGND VGND VPWR VPWR sky130_fd_sc_hd__decap_3
XPHY_EDGE_ROW_30_Right_30 VGND VGND VPWR VPWR sky130_fd_sc_hd__decap_3
XFILLER_3_612 VGND VGND VPWR VPWR sky130_fd_sc_hd__decap_3
XFILLER_2_100 VGND VGND VPWR VPWR sky130_fd_sc_hd__decap_3
XFILLER_2_155 VGND VGND VPWR VPWR sky130_fd_sc_hd__fill_1
XFILLER_78_413 VGND VGND VPWR VPWR sky130_fd_sc_hd__decap_3
XFILLER_78_424 VGND VGND VPWR VPWR sky130_fd_sc_hd__decap_3
XFILLER_93_405 VGND VGND VPWR VPWR sky130_fd_sc_hd__decap_3
XFILLER_48_95 VGND VGND VPWR VPWR sky130_fd_sc_hd__decap_3
XFILLER_59_671 VGND VGND VPWR VPWR sky130_fd_sc_hd__fill_1
XFILLER_59_682 VGND VGND VPWR VPWR sky130_fd_sc_hd__decap_3
XFILLER_19_535 VGND VGND VPWR VPWR sky130_fd_sc_hd__decap_3
XFILLER_58_181 VGND VGND VPWR VPWR sky130_fd_sc_hd__decap_3
XFILLER_86_490 VGND VGND VPWR VPWR sky130_fd_sc_hd__fill_2
XFILLER_93_449 VGND VGND VPWR VPWR sky130_fd_sc_hd__decap_3
XFILLER_0_47 VGND VGND VPWR VPWR sky130_fd_sc_hd__decap_3
XFILLER_0_69 VGND VGND VPWR VPWR sky130_fd_sc_hd__decap_3
XFILLER_34_516 VGND VGND VPWR VPWR sky130_fd_sc_hd__decap_3
XFILLER_46_365 VGND VGND VPWR VPWR sky130_fd_sc_hd__decap_3
XFILLER_73_140 VGND VGND VPWR VPWR sky130_fd_sc_hd__decap_3
XFILLER_74_663 VGND VGND VPWR VPWR sky130_fd_sc_hd__decap_3
XFILLER_61_313 VGND VGND VPWR VPWR sky130_fd_sc_hd__decap_3
XFILLER_64_50 VGND VGND VPWR VPWR sky130_fd_sc_hd__decap_3
XFILLER_73_184 VGND VGND VPWR VPWR sky130_fd_sc_hd__decap_3
XFILLER_74_696 VGND VGND VPWR VPWR sky130_fd_sc_hd__decap_3
XFILLER_14_240 VGND VGND VPWR VPWR sky130_fd_sc_hd__decap_3
XFILLER_61_346 VGND VGND VPWR VPWR sky130_fd_sc_hd__decap_3
XPHY_EDGE_ROW_14_Left_134 VGND VGND VPWR VPWR sky130_fd_sc_hd__decap_3
XFILLER_42_571 VGND VGND VPWR VPWR sky130_fd_sc_hd__decap_3
XTAP_TAPCELL_ROW_64_1085 VGND VPWR sky130_fd_sc_hd__tapvpwrvgnd_1
XFILLER_14_284 VGND VGND VPWR VPWR sky130_fd_sc_hd__decap_3
XTAP_TAPCELL_ROW_64_1096 VGND VPWR sky130_fd_sc_hd__tapvpwrvgnd_1
XTAP_TAPCELL_ROW_40_783 VGND VPWR sky130_fd_sc_hd__tapvpwrvgnd_1
XFILLER_115_337 VGND VGND VPWR VPWR sky130_fd_sc_hd__decap_3
XFILLER_6_483 VGND VGND VPWR VPWR sky130_fd_sc_hd__decap_3
XPHY_EDGE_ROW_23_Left_143 VGND VGND VPWR VPWR sky130_fd_sc_hd__decap_3
X_5210_ _5579_/S _5913_/B _5209_/X VGND VGND VPWR VPWR _5740_/A sky130_fd_sc_hd__a21oi_2
X_6190_ _7732_/B _8245_/Q _6999_/A1 VGND VGND VPWR VPWR _6190_/X sky130_fd_sc_hd__o21a_2
XFILLER_96_221 VGND VGND VPWR VPWR sky130_fd_sc_hd__decap_3
X_5141_ _8222_/Q _8223_/Q _6380_/S VGND VGND VPWR VPWR _5367_/B sky130_fd_sc_hd__mux2_2
XFILLER_111_543 VGND VGND VPWR VPWR sky130_fd_sc_hd__decap_3
XFILLER_69_446 VGND VGND VPWR VPWR sky130_fd_sc_hd__fill_2
X_5072_ _7844_/B _5072_/B VGND VGND VPWR VPWR _5073_/S sky130_fd_sc_hd__nand2_2
XFILLER_56_118 VGND VGND VPWR VPWR sky130_fd_sc_hd__fill_2
XFILLER_56_129 VGND VGND VPWR VPWR sky130_fd_sc_hd__decap_3
XFILLER_69_479 VGND VGND VPWR VPWR sky130_fd_sc_hd__decap_3
XFILLER_96_265 VGND VGND VPWR VPWR sky130_fd_sc_hd__decap_3
X_4023_ _8322_/Q _8325_/Q _8327_/Q _8330_/Q VGND VGND VPWR VPWR _4026_/B sky130_fd_sc_hd__or4_2
XFILLER_37_321 VGND VGND VPWR VPWR sky130_fd_sc_hd__decap_3
XFILLER_49_181 VGND VGND VPWR VPWR sky130_fd_sc_hd__decap_3
XFILLER_65_641 VGND VGND VPWR VPWR sky130_fd_sc_hd__decap_3
XFILLER_25_505 VGND VGND VPWR VPWR sky130_fd_sc_hd__decap_3
XFILLER_37_376 VGND VGND VPWR VPWR sky130_fd_sc_hd__decap_3
XFILLER_65_652 VGND VGND VPWR VPWR sky130_fd_sc_hd__decap_3
XFILLER_25_538 VGND VGND VPWR VPWR sky130_fd_sc_hd__decap_3
XFILLER_52_335 VGND VGND VPWR VPWR sky130_fd_sc_hd__decap_3
XFILLER_80_633 VGND VGND VPWR VPWR sky130_fd_sc_hd__decap_3
XPHY_EDGE_ROW_32_Left_152 VGND VGND VPWR VPWR sky130_fd_sc_hd__decap_3
XTAP_TAPCELL_ROW_48_883 VGND VPWR sky130_fd_sc_hd__tapvpwrvgnd_1
XFILLER_40_508 VGND VGND VPWR VPWR sky130_fd_sc_hd__decap_3
X_7713_ _7783_/A _7709_/X _7712_/X VGND VGND VPWR VPWR _7713_/Y sky130_fd_sc_hd__a21oi_2
X_5974_ _6999_/A1 _5971_/X _5973_/X VGND VGND VPWR VPWR _5974_/X sky130_fd_sc_hd__a21o_2
X_4925_ _8236_/Q _8172_/Q VGND VGND VPWR VPWR _4928_/A sky130_fd_sc_hd__and2b_2
XFILLER_100_48 VGND VGND VPWR VPWR sky130_fd_sc_hd__decap_3
XFILLER_20_221 VGND VGND VPWR VPWR sky130_fd_sc_hd__decap_3
X_7644_ _7636_/Y _7643_/X _7844_/A VGND VGND VPWR VPWR _8357_/D sky130_fd_sc_hd__a21oi_4
X_4856_ _8189_/Q _8253_/Q VGND VGND VPWR VPWR _6561_/B sky130_fd_sc_hd__and2b_2
X_7575_ _7575_/A _7575_/B _7575_/C _7575_/D VGND VGND VPWR VPWR _7579_/B sky130_fd_sc_hd__or4_4
XFILLER_118_120 VGND VGND VPWR VPWR sky130_fd_sc_hd__decap_3
X_6526_ _6527_/B _6527_/C _6592_/D VGND VGND VPWR VPWR _6528_/A sky130_fd_sc_hd__a21oi_2
X_4787_ _8275_/Q _8211_/Q VGND VGND VPWR VPWR _4789_/A sky130_fd_sc_hd__nor2b_2
XFILLER_114_9 VGND VGND VPWR VPWR sky130_fd_sc_hd__decap_3
XFILLER_119_676 VGND VGND VPWR VPWR sky130_fd_sc_hd__decap_3
XPHY_EDGE_ROW_41_Left_161 VGND VGND VPWR VPWR sky130_fd_sc_hd__decap_3
XFILLER_106_337 VGND VGND VPWR VPWR sky130_fd_sc_hd__decap_3
XFILLER_109_79 VGND VGND VPWR VPWR sky130_fd_sc_hd__decap_3
X_6457_ _8223_/Q _5142_/X _6641_/C VGND VGND VPWR VPWR _6457_/X sky130_fd_sc_hd__mux2_2
X_6388_ _5774_/B _6355_/X _6387_/X _7135_/B VGND VGND VPWR VPWR _6388_/X sky130_fd_sc_hd__o22a_2
X_5408_ _6763_/B _5415_/A VGND VGND VPWR VPWR _7612_/A sky130_fd_sc_hd__or2_2
XFILLER_0_637 VGND VGND VPWR VPWR sky130_fd_sc_hd__decap_3
XFILLER_102_521 VGND VGND VPWR VPWR sky130_fd_sc_hd__decap_3
X_8127_ _8400_/CLK _8127_/D VGND VGND VPWR VPWR _8127_/Q sky130_fd_sc_hd__dfxtp_2
X_5339_ _6706_/S _5337_/X _6936_/A2 VGND VGND VPWR VPWR _5339_/Y sky130_fd_sc_hd__o21ai_2
XFILLER_0_659 VGND VGND VPWR VPWR sky130_fd_sc_hd__decap_3
XFILLER_114_392 VGND VGND VPWR VPWR sky130_fd_sc_hd__decap_3
XFILLER_87_243 VGND VGND VPWR VPWR sky130_fd_sc_hd__decap_3
XFILLER_102_587 VGND VGND VPWR VPWR sky130_fd_sc_hd__fill_1
XFILLER_102_598 VGND VGND VPWR VPWR sky130_fd_sc_hd__decap_3
XFILLER_75_405 VGND VGND VPWR VPWR sky130_fd_sc_hd__decap_3
XFILLER_87_287 VGND VGND VPWR VPWR sky130_fd_sc_hd__decap_3
X_8058_ _8389_/CLK _8058_/D VGND VGND VPWR VPWR _8058_/Q sky130_fd_sc_hd__dfxtp_2
XFILLER_75_449 VGND VGND VPWR VPWR sky130_fd_sc_hd__decap_3
XPHY_EDGE_ROW_50_Left_170 VGND VGND VPWR VPWR sky130_fd_sc_hd__decap_3
X_7009_ _8200_/Q _8201_/Q _7009_/C _7009_/D VGND VGND VPWR VPWR _7068_/D sky130_fd_sc_hd__and4_2
XFILLER_28_365 VGND VGND VPWR VPWR sky130_fd_sc_hd__decap_3
XFILLER_55_151 VGND VGND VPWR VPWR sky130_fd_sc_hd__decap_3
XFILLER_90_419 VGND VGND VPWR VPWR sky130_fd_sc_hd__fill_1
XFILLER_16_527 VGND VGND VPWR VPWR sky130_fd_sc_hd__decap_3
XFILLER_28_398 VGND VGND VPWR VPWR sky130_fd_sc_hd__decap_3
XFILLER_43_313 VGND VGND VPWR VPWR sky130_fd_sc_hd__decap_3
XFILLER_56_685 VGND VGND VPWR VPWR sky130_fd_sc_hd__decap_3
XFILLER_71_622 VGND VGND VPWR VPWR sky130_fd_sc_hd__decap_3
XFILLER_83_482 VGND VGND VPWR VPWR sky130_fd_sc_hd__decap_3
XFILLER_34_20 VGND VGND VPWR VPWR sky130_fd_sc_hd__decap_3
XFILLER_43_346 VGND VGND VPWR VPWR sky130_fd_sc_hd__decap_3
XFILLER_34_42 VGND VGND VPWR VPWR sky130_fd_sc_hd__decap_3
XFILLER_43_379 VGND VGND VPWR VPWR sky130_fd_sc_hd__decap_3
XFILLER_11_221 VGND VGND VPWR VPWR sky130_fd_sc_hd__decap_3
XFILLER_8_704 VGND VGND VPWR VPWR sky130_fd_sc_hd__decap_3
XTAP_TAPCELL_ROW_26_599 VGND VPWR sky130_fd_sc_hd__tapvpwrvgnd_1
XFILLER_11_243 VGND VGND VPWR VPWR sky130_fd_sc_hd__decap_3
XFILLER_109_131 VGND VGND VPWR VPWR sky130_fd_sc_hd__decap_3
XFILLER_11_287 VGND VGND VPWR VPWR sky130_fd_sc_hd__decap_3
XFILLER_50_85 VGND VGND VPWR VPWR sky130_fd_sc_hd__decap_3
XFILLER_109_175 VGND VGND VPWR VPWR sky130_fd_sc_hd__decap_3
XFILLER_3_442 VGND VGND VPWR VPWR sky130_fd_sc_hd__decap_3
XTAP_TAPCELL_ROW_115_1760 VGND VPWR sky130_fd_sc_hd__tapvpwrvgnd_1
XFILLER_105_381 VGND VGND VPWR VPWR sky130_fd_sc_hd__decap_3
XFILLER_3_464 VGND VGND VPWR VPWR sky130_fd_sc_hd__decap_3
XFILLER_59_83 VGND VGND VPWR VPWR sky130_fd_sc_hd__fill_2
XFILLER_78_221 VGND VGND VPWR VPWR sky130_fd_sc_hd__decap_3
XFILLER_66_427 VGND VGND VPWR VPWR sky130_fd_sc_hd__decap_3
XFILLER_19_310 VGND VGND VPWR VPWR sky130_fd_sc_hd__decap_3
XFILLER_19_332 VGND VGND VPWR VPWR sky130_fd_sc_hd__decap_3
XFILLER_19_343 VGND VGND VPWR VPWR sky130_fd_sc_hd__decap_3
XFILLER_81_408 VGND VGND VPWR VPWR sky130_fd_sc_hd__decap_3
XFILLER_19_376 VGND VGND VPWR VPWR sky130_fd_sc_hd__decap_3
XFILLER_34_302 VGND VGND VPWR VPWR sky130_fd_sc_hd__decap_3
XFILLER_34_324 VGND VGND VPWR VPWR sky130_fd_sc_hd__decap_3
XFILLER_46_162 VGND VGND VPWR VPWR sky130_fd_sc_hd__decap_3
XFILLER_74_493 VGND VGND VPWR VPWR sky130_fd_sc_hd__decap_3
XFILLER_75_93 VGND VGND VPWR VPWR sky130_fd_sc_hd__decap_3
XTAP_TAPCELL_ROW_66_1114 VGND VPWR sky130_fd_sc_hd__tapvpwrvgnd_1
XFILLER_34_357 VGND VGND VPWR VPWR sky130_fd_sc_hd__decap_3
XTAP_TAPCELL_ROW_45_842 VGND VPWR sky130_fd_sc_hd__tapvpwrvgnd_1
XFILLER_22_519 VGND VGND VPWR VPWR sky130_fd_sc_hd__decap_3
XFILLER_34_379 VGND VGND VPWR VPWR sky130_fd_sc_hd__decap_3
XFILLER_61_165 VGND VGND VPWR VPWR sky130_fd_sc_hd__decap_3
XFILLER_62_699 VGND VGND VPWR VPWR sky130_fd_sc_hd__fill_1
XFILLER_91_92 VGND VGND VPWR VPWR sky130_fd_sc_hd__fill_1
X_5690_ _8166_/Q _5690_/B _5690_/C VGND VGND VPWR VPWR _5944_/C sky130_fd_sc_hd__and3_4
X_4710_ _7898_/B _8159_/Q VGND VGND VPWR VPWR _4711_/A sky130_fd_sc_hd__and2_2
XFILLER_30_563 VGND VGND VPWR VPWR sky130_fd_sc_hd__fill_1
XFILLER_30_574 VGND VGND VPWR VPWR sky130_fd_sc_hd__fill_2
X_4641_ _4641_/A VGND VGND VPWR VPWR _8258_/D sky130_fd_sc_hd__buf_1
X_7360_ _8214_/Q _7359_/X _6687_/A VGND VGND VPWR VPWR _7360_/X sky130_fd_sc_hd__a21o_2
X_4572_ _7898_/B _8090_/Q VGND VGND VPWR VPWR _4573_/A sky130_fd_sc_hd__and2_2
XFILLER_116_657 VGND VGND VPWR VPWR sky130_fd_sc_hd__decap_3
X_7291_ _8276_/Q _5718_/X _5402_/X _4762_/A VGND VGND VPWR VPWR _7291_/X sky130_fd_sc_hd__a22o_2
X_6311_ _8184_/Q _8248_/Q _8288_/Q VGND VGND VPWR VPWR _6311_/X sky130_fd_sc_hd__mux2_2
XTAP_TAPCELL_ROW_77_1265 VGND VPWR sky130_fd_sc_hd__tapvpwrvgnd_1
XTAP_TAPCELL_ROW_77_1254 VGND VPWR sky130_fd_sc_hd__tapvpwrvgnd_1
XFILLER_89_508 VGND VGND VPWR VPWR sky130_fd_sc_hd__decap_3
X_6242_ _5596_/X _5673_/B _6819_/B _6819_/A VGND VGND VPWR VPWR _6243_/B sky130_fd_sc_hd__a22o_2
XFILLER_103_329 VGND VGND VPWR VPWR sky130_fd_sc_hd__decap_3
XTAP_TAPCELL_ROW_90_1432 VGND VPWR sky130_fd_sc_hd__tapvpwrvgnd_1
XFILLER_97_552 VGND VGND VPWR VPWR sky130_fd_sc_hd__decap_3
X_6173_ _6321_/B _5579_/S _6277_/A VGND VGND VPWR VPWR _6173_/Y sky130_fd_sc_hd__a21oi_2
XFILLER_69_276 VGND VGND VPWR VPWR sky130_fd_sc_hd__decap_3
XFILLER_69_287 VGND VGND VPWR VPWR sky130_fd_sc_hd__decap_3
X_5124_ _5124_/A VGND VGND VPWR VPWR _5186_/A sky130_fd_sc_hd__clkbuf_2
XFILLER_57_438 VGND VGND VPWR VPWR sky130_fd_sc_hd__decap_3
XFILLER_57_449 VGND VGND VPWR VPWR sky130_fd_sc_hd__decap_3
XFILLER_84_224 VGND VGND VPWR VPWR sky130_fd_sc_hd__fill_2
XFILLER_84_235 VGND VGND VPWR VPWR sky130_fd_sc_hd__decap_3
X_5055_ _8254_/Q _5053_/B _5054_/Y _4868_/A VGND VGND VPWR VPWR _5055_/X sky130_fd_sc_hd__a211o_2
XFILLER_65_460 VGND VGND VPWR VPWR sky130_fd_sc_hd__decap_3
XFILLER_84_268 VGND VGND VPWR VPWR sky130_fd_sc_hd__decap_3
X_4006_ _8356_/Q _7930_/B VGND VGND VPWR VPWR _4007_/A sky130_fd_sc_hd__and2_2
XFILLER_65_493 VGND VGND VPWR VPWR sky130_fd_sc_hd__decap_3
XFILLER_111_14 VGND VGND VPWR VPWR sky130_fd_sc_hd__decap_3
XFILLER_25_357 VGND VGND VPWR VPWR sky130_fd_sc_hd__decap_3
XFILLER_52_121 VGND VGND VPWR VPWR sky130_fd_sc_hd__decap_3
XFILLER_53_644 VGND VGND VPWR VPWR sky130_fd_sc_hd__decap_3
XFILLER_80_430 VGND VGND VPWR VPWR sky130_fd_sc_hd__decap_3
XFILLER_80_452 VGND VGND VPWR VPWR sky130_fd_sc_hd__decap_3
XFILLER_111_69 VGND VGND VPWR VPWR sky130_fd_sc_hd__decap_3
XFILLER_13_508 VGND VGND VPWR VPWR sky130_fd_sc_hd__decap_3
XFILLER_40_305 VGND VGND VPWR VPWR sky130_fd_sc_hd__decap_3
XFILLER_52_154 VGND VGND VPWR VPWR sky130_fd_sc_hd__decap_3
XFILLER_80_485 VGND VGND VPWR VPWR sky130_fd_sc_hd__fill_2
X_5957_ _5956_/X _5860_/X _5780_/X _5678_/X _7812_/A _7670_/A VGND VGND VPWR VPWR
+ _5957_/X sky130_fd_sc_hd__mux4_2
XFILLER_21_530 VGND VGND VPWR VPWR sky130_fd_sc_hd__decap_3
XFILLER_40_327 VGND VGND VPWR VPWR sky130_fd_sc_hd__decap_3
X_4908_ _8242_/Q VGND VGND VPWR VPWR _4910_/B sky130_fd_sc_hd__inv_2
XFILLER_21_552 VGND VGND VPWR VPWR sky130_fd_sc_hd__decap_3
X_7627_ _6571_/X _7625_/X _7193_/A _7626_/Y VGND VGND VPWR VPWR _7627_/X sky130_fd_sc_hd__a2bb2o_2
X_5888_ _5888_/A _5888_/B _5888_/C VGND VGND VPWR VPWR _5888_/X sky130_fd_sc_hd__and3_2
XTAP_TAPCELL_ROW_23_558 VGND VPWR sky130_fd_sc_hd__tapvpwrvgnd_1
Xrebuffer834 _8253_/Q VGND VGND VPWR VPWR _6504_/A2 sky130_fd_sc_hd__buf_2
X_4839_ _6874_/A _6874_/B _6874_/C _6874_/D VGND VGND VPWR VPWR _4855_/B sky130_fd_sc_hd__or4_2
XFILLER_5_718 VGND VGND VPWR VPWR sky130_fd_sc_hd__decap_3
XFILLER_5_729 VGND VGND VPWR VPWR sky130_fd_sc_hd__decap_3
X_7558_ _6623_/A _6509_/X _6513_/X _7557_/X VGND VGND VPWR VPWR _7567_/C sky130_fd_sc_hd__o22a_2
XFILLER_106_112 VGND VGND VPWR VPWR sky130_fd_sc_hd__decap_3
XFILLER_112_6 VGND VGND VPWR VPWR sky130_fd_sc_hd__decap_3
XFILLER_119_495 VGND VGND VPWR VPWR sky130_fd_sc_hd__decap_3
X_7489_ _8217_/Q _8281_/Q _8218_/Q VGND VGND VPWR VPWR _7490_/C sky130_fd_sc_hd__o21a_2
X_6509_ _7298_/S0 _5919_/B _6508_/X _7626_/A VGND VGND VPWR VPWR _6509_/X sky130_fd_sc_hd__o211a_2
XFILLER_106_156 VGND VGND VPWR VPWR sky130_fd_sc_hd__decap_3
XFILLER_107_657 VGND VGND VPWR VPWR sky130_fd_sc_hd__decap_3
XFILLER_20_66 VGND VGND VPWR VPWR sky130_fd_sc_hd__decap_3
XFILLER_106_189 VGND VGND VPWR VPWR sky130_fd_sc_hd__decap_3
XFILLER_96_48 VGND VGND VPWR VPWR sky130_fd_sc_hd__decap_3
XFILLER_102_362 VGND VGND VPWR VPWR sky130_fd_sc_hd__fill_2
XFILLER_48_405 VGND VGND VPWR VPWR sky130_fd_sc_hd__decap_3
XFILLER_48_427 VGND VGND VPWR VPWR sky130_fd_sc_hd__decap_3
XFILLER_102_395 VGND VGND VPWR VPWR sky130_fd_sc_hd__decap_3
XFILLER_29_64 VGND VGND VPWR VPWR sky130_fd_sc_hd__decap_3
XFILLER_75_213 VGND VGND VPWR VPWR sky130_fd_sc_hd__decap_3
XTAP_TAPCELL_ROW_110_1690 VGND VPWR sky130_fd_sc_hd__tapvpwrvgnd_1
XFILLER_63_419 VGND VGND VPWR VPWR sky130_fd_sc_hd__decap_3
XFILLER_75_279 VGND VGND VPWR VPWR sky130_fd_sc_hd__fill_1
XFILLER_29_696 VGND VGND VPWR VPWR sky130_fd_sc_hd__decap_3
XFILLER_44_611 VGND VGND VPWR VPWR sky130_fd_sc_hd__decap_3
XFILLER_90_227 VGND VGND VPWR VPWR sky130_fd_sc_hd__decap_3
XTAP_TAPCELL_ROW_3_294 VGND VPWR sky130_fd_sc_hd__tapvpwrvgnd_1
XFILLER_45_63 VGND VGND VPWR VPWR sky130_fd_sc_hd__decap_3
XFILLER_71_452 VGND VGND VPWR VPWR sky130_fd_sc_hd__decap_3
XFILLER_43_165 VGND VGND VPWR VPWR sky130_fd_sc_hd__decap_3
XFILLER_44_677 VGND VGND VPWR VPWR sky130_fd_sc_hd__fill_1
XFILLER_71_485 VGND VGND VPWR VPWR sky130_fd_sc_hd__decap_3
XTAP_TAPCELL_ROW_42_801 VGND VPWR sky130_fd_sc_hd__tapvpwrvgnd_1
XFILLER_8_501 VGND VGND VPWR VPWR sky130_fd_sc_hd__decap_3
XTAP_TAPCELL_ROW_61_1055 VGND VPWR sky130_fd_sc_hd__tapvpwrvgnd_1
XFILLER_61_84 VGND VGND VPWR VPWR sky130_fd_sc_hd__decap_3
XFILLER_8_545 VGND VGND VPWR VPWR sky130_fd_sc_hd__decap_3
XFILLER_8_589 VGND VGND VPWR VPWR sky130_fd_sc_hd__decap_3
XANTENNA_6 _4017_/A VGND VGND VPWR VPWR sky130_fd_sc_hd__diode_2
XFILLER_6_35 VGND VGND VPWR VPWR sky130_fd_sc_hd__fill_2
XFILLER_6_46 VGND VGND VPWR VPWR sky130_fd_sc_hd__fill_2
XFILLER_6_79 VGND VGND VPWR VPWR sky130_fd_sc_hd__decap_3
XFILLER_3_250 VGND VGND VPWR VPWR sky130_fd_sc_hd__decap_3
XFILLER_98_338 VGND VGND VPWR VPWR sky130_fd_sc_hd__decap_3
XFILLER_79_552 VGND VGND VPWR VPWR sky130_fd_sc_hd__fill_1
XFILLER_39_405 VGND VGND VPWR VPWR sky130_fd_sc_hd__decap_3
XFILLER_67_714 VGND VGND VPWR VPWR sky130_fd_sc_hd__fill_2
XTAP_TAPCELL_ROW_72_1195 VGND VPWR sky130_fd_sc_hd__tapvpwrvgnd_1
XFILLER_39_438 VGND VGND VPWR VPWR sky130_fd_sc_hd__decap_3
XFILLER_39_449 VGND VGND VPWR VPWR sky130_fd_sc_hd__decap_3
XFILLER_94_522 VGND VGND VPWR VPWR sky130_fd_sc_hd__decap_3
XFILLER_94_533 VGND VGND VPWR VPWR sky130_fd_sc_hd__decap_3
Xsplit443 _8181_/Q VGND VGND VPWR VPWR _7732_/B sky130_fd_sc_hd__clkbuf_8
XFILLER_19_140 VGND VGND VPWR VPWR sky130_fd_sc_hd__decap_3
XFILLER_66_268 VGND VGND VPWR VPWR sky130_fd_sc_hd__decap_3
XFILLER_35_633 VGND VGND VPWR VPWR sky130_fd_sc_hd__decap_3
XFILLER_19_195 VGND VGND VPWR VPWR sky130_fd_sc_hd__decap_3
XFILLER_62_430 VGND VGND VPWR VPWR sky130_fd_sc_hd__decap_3
XFILLER_81_249 VGND VGND VPWR VPWR sky130_fd_sc_hd__decap_3
X_6860_ _8199_/Q _8263_/Q _6859_/X VGND VGND VPWR VPWR _6860_/X sky130_fd_sc_hd__a21o_2
XFILLER_50_614 VGND VGND VPWR VPWR sky130_fd_sc_hd__decap_3
XFILLER_62_463 VGND VGND VPWR VPWR sky130_fd_sc_hd__decap_3
X_6791_ _6791_/A _6791_/B VGND VGND VPWR VPWR _6811_/B sky130_fd_sc_hd__nand2_2
X_5811_ _5897_/A _8235_/Q _5810_/X VGND VGND VPWR VPWR _5812_/B sky130_fd_sc_hd__a21o_2
XFILLER_22_327 VGND VGND VPWR VPWR sky130_fd_sc_hd__decap_3
XFILLER_22_338 VGND VGND VPWR VPWR sky130_fd_sc_hd__decap_3
X_5742_ _6353_/B _5741_/Y _5675_/Y _5477_/X _6277_/A VGND VGND VPWR VPWR _5742_/X
+ sky130_fd_sc_hd__o2111a_2
X_5673_ _5673_/A _5673_/B VGND VGND VPWR VPWR _5673_/Y sky130_fd_sc_hd__nand2_2
XTAP_TAPCELL_ROW_20_517 VGND VPWR sky130_fd_sc_hd__tapvpwrvgnd_1
XFILLER_30_393 VGND VGND VPWR VPWR sky130_fd_sc_hd__decap_3
XPHY_EDGE_ROW_6_Right_6 VGND VGND VPWR VPWR sky130_fd_sc_hd__decap_3
X_7412_ _7619_/A _7490_/D _7411_/X VGND VGND VPWR VPWR _7412_/X sky130_fd_sc_hd__a21o_2
X_8392_ _8392_/CLK _8392_/D VGND VGND VPWR VPWR _8392_/Q sky130_fd_sc_hd__dfxtp_2
X_4624_ _7930_/B _8116_/Q VGND VGND VPWR VPWR _4625_/A sky130_fd_sc_hd__and2_2
XFILLER_116_410 VGND VGND VPWR VPWR sky130_fd_sc_hd__decap_3
XFILLER_116_421 VGND VGND VPWR VPWR sky130_fd_sc_hd__decap_3
Xmax_cap220 _5507_/A VGND VGND VPWR VPWR _5966_/A sky130_fd_sc_hd__clkbuf_8
X_7343_ _7398_/D _7343_/B VGND VGND VPWR VPWR _7343_/X sky130_fd_sc_hd__xor2_2
X_4555_ _4555_/A VGND VGND VPWR VPWR _8215_/D sky130_fd_sc_hd__buf_1
XFILLER_116_465 VGND VGND VPWR VPWR sky130_fd_sc_hd__decap_3
Xmax_cap253 _7796_/A VGND VGND VPWR VPWR _5484_/S sky130_fd_sc_hd__buf_12
Xmax_cap242 _8288_/Q VGND VGND VPWR VPWR _7619_/A sky130_fd_sc_hd__buf_12
Xmax_cap231 _4716_/X VGND VGND VPWR VPWR _6910_/A sky130_fd_sc_hd__buf_6
X_7274_ _7274_/A _7274_/B _7273_/X VGND VGND VPWR VPWR _7274_/X sky130_fd_sc_hd__or3b_4
X_4486_ _7898_/B _8047_/Q VGND VGND VPWR VPWR _4487_/A sky130_fd_sc_hd__and2_2
XFILLER_103_137 VGND VGND VPWR VPWR sky130_fd_sc_hd__decap_3
X_6225_ _7725_/B _8246_/Q _6086_/A VGND VGND VPWR VPWR _6225_/Y sky130_fd_sc_hd__a21oi_2
XFILLER_112_660 VGND VGND VPWR VPWR sky130_fd_sc_hd__decap_3
XFILLER_85_511 VGND VGND VPWR VPWR sky130_fd_sc_hd__decap_3
X_6156_ _8180_/Q _8244_/Q _8288_/Q VGND VGND VPWR VPWR _6156_/X sky130_fd_sc_hd__mux2_2
XFILLER_57_213 VGND VGND VPWR VPWR sky130_fd_sc_hd__decap_3
XFILLER_85_533 VGND VGND VPWR VPWR sky130_fd_sc_hd__decap_3
XFILLER_97_393 VGND VGND VPWR VPWR sky130_fd_sc_hd__fill_2
X_5107_ _5107_/A _5107_/B VGND VGND VPWR VPWR _5108_/A sky130_fd_sc_hd__nor2_2
XFILLER_57_257 VGND VGND VPWR VPWR sky130_fd_sc_hd__decap_3
X_6087_ _5585_/A _6084_/A _6086_/Y _8290_/Q VGND VGND VPWR VPWR _6087_/X sky130_fd_sc_hd__o2bb2a_2
XFILLER_26_611 VGND VGND VPWR VPWR sky130_fd_sc_hd__decap_3
XFILLER_38_471 VGND VGND VPWR VPWR sky130_fd_sc_hd__fill_2
XFILLER_45_419 VGND VGND VPWR VPWR sky130_fd_sc_hd__decap_3
XFILLER_72_227 VGND VGND VPWR VPWR sky130_fd_sc_hd__decap_3
X_5038_ _4907_/A _4909_/Y _5037_/Y _6138_/B VGND VGND VPWR VPWR _5038_/X sky130_fd_sc_hd__o31a_2
XTAP_TAPCELL_ROW_28_628 VGND VPWR sky130_fd_sc_hd__tapvpwrvgnd_1
XTAP_TAPCELL_ROW_28_617 VGND VPWR sky130_fd_sc_hd__tapvpwrvgnd_1
XFILLER_25_132 VGND VGND VPWR VPWR sky130_fd_sc_hd__fill_2
XFILLER_26_666 VGND VGND VPWR VPWR sky130_fd_sc_hd__decap_3
XFILLER_38_493 VGND VGND VPWR VPWR sky130_fd_sc_hd__fill_2
XFILLER_53_441 VGND VGND VPWR VPWR sky130_fd_sc_hd__decap_3
XFILLER_65_290 VGND VGND VPWR VPWR sky130_fd_sc_hd__decap_3
XTAP_TAPCELL_ROW_0_242 VGND VPWR sky130_fd_sc_hd__tapvpwrvgnd_1
XTAP_TAPCELL_ROW_0_253 VGND VPWR sky130_fd_sc_hd__tapvpwrvgnd_1
XFILLER_13_305 VGND VGND VPWR VPWR sky130_fd_sc_hd__decap_3
XFILLER_26_699 VGND VGND VPWR VPWR sky130_fd_sc_hd__fill_1
XFILLER_41_603 VGND VGND VPWR VPWR sky130_fd_sc_hd__decap_3
XFILLER_53_452 VGND VGND VPWR VPWR sky130_fd_sc_hd__decap_3
XTAP_TAPCELL_ROW_0_264 VGND VPWR sky130_fd_sc_hd__tapvpwrvgnd_1
XFILLER_25_187 VGND VGND VPWR VPWR sky130_fd_sc_hd__decap_3
XFILLER_40_113 VGND VGND VPWR VPWR sky130_fd_sc_hd__decap_3
XFILLER_41_636 VGND VGND VPWR VPWR sky130_fd_sc_hd__decap_3
XFILLER_41_658 VGND VGND VPWR VPWR sky130_fd_sc_hd__decap_3
X_6989_ _8202_/Q _6988_/B _8203_/Q VGND VGND VPWR VPWR _6989_/Y sky130_fd_sc_hd__o21ai_2
XFILLER_15_77 VGND VGND VPWR VPWR sky130_fd_sc_hd__fill_2
XFILLER_40_168 VGND VGND VPWR VPWR sky130_fd_sc_hd__decap_3
XFILLER_41_669 VGND VGND VPWR VPWR sky130_fd_sc_hd__decap_3
XFILLER_21_371 VGND VGND VPWR VPWR sky130_fd_sc_hd__decap_3
XFILLER_21_393 VGND VGND VPWR VPWR sky130_fd_sc_hd__decap_3
XFILLER_110_3 VGND VGND VPWR VPWR sky130_fd_sc_hd__fill_2
XFILLER_119_281 VGND VGND VPWR VPWR sky130_fd_sc_hd__decap_3
XFILLER_31_76 VGND VGND VPWR VPWR sky130_fd_sc_hd__decap_3
XFILLER_107_432 VGND VGND VPWR VPWR sky130_fd_sc_hd__fill_1
XFILLER_107_443 VGND VGND VPWR VPWR sky130_fd_sc_hd__decap_3
XFILLER_5_548 VGND VGND VPWR VPWR sky130_fd_sc_hd__decap_3
Xrebuffer686 _7031_/Y VGND VGND VPWR VPWR _7032_/B sky130_fd_sc_hd__buf_2
XFILLER_107_476 VGND VGND VPWR VPWR sky130_fd_sc_hd__decap_3
XFILLER_1_732 VGND VGND VPWR VPWR sky130_fd_sc_hd__fill_1
XFILLER_0_231 VGND VGND VPWR VPWR sky130_fd_sc_hd__fill_2
XFILLER_0_253 VGND VGND VPWR VPWR sky130_fd_sc_hd__decap_3
XFILLER_103_671 VGND VGND VPWR VPWR sky130_fd_sc_hd__fill_1
Xinput110 operand_b[46] VGND VGND VPWR VPWR _4396_/B sky130_fd_sc_hd__clkdlybuf4s25_1
XTAP_TAPCELL_ROW_8_364 VGND VPWR sky130_fd_sc_hd__tapvpwrvgnd_1
XFILLER_48_224 VGND VGND VPWR VPWR sky130_fd_sc_hd__decap_3
XFILLER_76_522 VGND VGND VPWR VPWR sky130_fd_sc_hd__decap_3
XFILLER_76_533 VGND VGND VPWR VPWR sky130_fd_sc_hd__decap_3
XFILLER_88_382 VGND VGND VPWR VPWR sky130_fd_sc_hd__decap_3
Xinput132 operand_b[8] VGND VGND VPWR VPWR _4320_/B sky130_fd_sc_hd__clkdlybuf4s25_1
Xinput121 operand_b[56] VGND VGND VPWR VPWR _4416_/B sky130_fd_sc_hd__clkdlybuf4s25_1
XFILLER_102_192 VGND VGND VPWR VPWR sky130_fd_sc_hd__decap_3
XFILLER_48_268 VGND VGND VPWR VPWR sky130_fd_sc_hd__decap_3
XFILLER_56_40 VGND VGND VPWR VPWR sky130_fd_sc_hd__decap_3
XFILLER_91_503 VGND VGND VPWR VPWR sky130_fd_sc_hd__fill_1
XFILLER_17_600 VGND VGND VPWR VPWR sky130_fd_sc_hd__decap_3
XFILLER_29_482 VGND VGND VPWR VPWR sky130_fd_sc_hd__decap_3
XFILLER_56_73 VGND VGND VPWR VPWR sky130_fd_sc_hd__decap_3
XFILLER_91_525 VGND VGND VPWR VPWR sky130_fd_sc_hd__decap_3
XFILLER_44_430 VGND VGND VPWR VPWR sky130_fd_sc_hd__decap_3
XFILLER_63_249 VGND VGND VPWR VPWR sky130_fd_sc_hd__decap_3
XFILLER_91_547 VGND VGND VPWR VPWR sky130_fd_sc_hd__fill_2
XFILLER_16_165 VGND VGND VPWR VPWR sky130_fd_sc_hd__decap_3
XFILLER_32_614 VGND VGND VPWR VPWR sky130_fd_sc_hd__decap_3
XFILLER_44_463 VGND VGND VPWR VPWR sky130_fd_sc_hd__decap_3
XTAP_TAPCELL_ROW_55_970 VGND VPWR sky130_fd_sc_hd__tapvpwrvgnd_1
XFILLER_31_113 VGND VGND VPWR VPWR sky130_fd_sc_hd__decap_3
XFILLER_71_271 VGND VGND VPWR VPWR sky130_fd_sc_hd__decap_3
XFILLER_71_293 VGND VGND VPWR VPWR sky130_fd_sc_hd__decap_3
XFILLER_31_146 VGND VGND VPWR VPWR sky130_fd_sc_hd__decap_3
XFILLER_72_83 VGND VGND VPWR VPWR sky130_fd_sc_hd__fill_1
XFILLER_12_371 VGND VGND VPWR VPWR sky130_fd_sc_hd__decap_3
XFILLER_12_382 VGND VGND VPWR VPWR sky130_fd_sc_hd__decap_3
XPHY_EDGE_ROW_59_Right_59 VGND VGND VPWR VPWR sky130_fd_sc_hd__decap_3
XFILLER_118_719 VGND VGND VPWR VPWR sky130_fd_sc_hd__decap_3
XFILLER_75_6 VGND VGND VPWR VPWR sky130_fd_sc_hd__decap_3
XFILLER_99_603 VGND VGND VPWR VPWR sky130_fd_sc_hd__decap_3
XFILLER_98_102 VGND VGND VPWR VPWR sky130_fd_sc_hd__fill_2
X_4340_ _7898_/B _4340_/B VGND VGND VPWR VPWR _4341_/A sky130_fd_sc_hd__and2_2
XTAP_TAPCELL_ROW_74_1224 VGND VPWR sky130_fd_sc_hd__tapvpwrvgnd_1
X_4271_ _4271_/A VGND VGND VPWR VPWR _8073_/D sky130_fd_sc_hd__buf_1
XFILLER_67_500 VGND VGND VPWR VPWR sky130_fd_sc_hd__decap_3
XFILLER_79_360 VGND VGND VPWR VPWR sky130_fd_sc_hd__decap_3
XFILLER_98_168 VGND VGND VPWR VPWR sky130_fd_sc_hd__decap_3
X_6010_ _7626_/A VGND VGND VPWR VPWR _6529_/A sky130_fd_sc_hd__buf_1
XFILLER_67_533 VGND VGND VPWR VPWR sky130_fd_sc_hd__decap_3
XFILLER_79_393 VGND VGND VPWR VPWR sky130_fd_sc_hd__decap_3
XPHY_EDGE_ROW_68_Right_68 VGND VGND VPWR VPWR sky130_fd_sc_hd__decap_3
XFILLER_67_577 VGND VGND VPWR VPWR sky130_fd_sc_hd__decap_3
XFILLER_82_503 VGND VGND VPWR VPWR sky130_fd_sc_hd__decap_3
XFILLER_94_341 VGND VGND VPWR VPWR sky130_fd_sc_hd__decap_3
XFILLER_94_352 VGND VGND VPWR VPWR sky130_fd_sc_hd__decap_3
XFILLER_39_279 VGND VGND VPWR VPWR sky130_fd_sc_hd__fill_1
XFILLER_54_227 VGND VGND VPWR VPWR sky130_fd_sc_hd__decap_3
XFILLER_94_374 VGND VGND VPWR VPWR sky130_fd_sc_hd__decap_3
XPHY_EDGE_ROW_6_Left_126 VGND VGND VPWR VPWR sky130_fd_sc_hd__decap_3
X_7961_ _8388_/CLK _7961_/D VGND VGND VPWR VPWR _7961_/Q sky130_fd_sc_hd__dfxtp_2
XFILLER_35_441 VGND VGND VPWR VPWR sky130_fd_sc_hd__decap_3
XFILLER_82_547 VGND VGND VPWR VPWR sky130_fd_sc_hd__fill_1
X_7892_ _8316_/Q _7898_/B VGND VGND VPWR VPWR _7893_/A sky130_fd_sc_hd__and2_2
X_6912_ _8264_/Q _6885_/B _6911_/X VGND VGND VPWR VPWR _6913_/B sky130_fd_sc_hd__o21a_2
XFILLER_35_452 VGND VGND VPWR VPWR sky130_fd_sc_hd__fill_1
X_6843_ _7209_/A _6815_/Y _6824_/X _6842_/X VGND VGND VPWR VPWR _6843_/X sky130_fd_sc_hd__a211o_2
XTAP_TAPCELL_ROW_85_1364 VGND VPWR sky130_fd_sc_hd__tapvpwrvgnd_1
XFILLER_22_124 VGND VGND VPWR VPWR sky130_fd_sc_hd__fill_2
XFILLER_23_647 VGND VGND VPWR VPWR sky130_fd_sc_hd__decap_3
XFILLER_50_433 VGND VGND VPWR VPWR sky130_fd_sc_hd__decap_3
XFILLER_62_271 VGND VGND VPWR VPWR sky130_fd_sc_hd__decap_3
XPHY_EDGE_ROW_77_Right_77 VGND VGND VPWR VPWR sky130_fd_sc_hd__decap_3
X_6774_ _7195_/B _6839_/B _6773_/X _6497_/B VGND VGND VPWR VPWR _6774_/X sky130_fd_sc_hd__o22a_2
X_3986_ _8346_/Q _7930_/B VGND VGND VPWR VPWR _3987_/A sky130_fd_sc_hd__and2_2
X_5725_ _7783_/B _5725_/B VGND VGND VPWR VPWR _5725_/X sky130_fd_sc_hd__and2_2
XTAP_TAPCELL_ROW_33_686 VGND VPWR sky130_fd_sc_hd__tapvpwrvgnd_1
XFILLER_30_190 VGND VGND VPWR VPWR sky130_fd_sc_hd__decap_3
X_5656_ _8230_/Q _5656_/B _5656_/C _5656_/D VGND VGND VPWR VPWR _5656_/X sky130_fd_sc_hd__and4_2
XFILLER_108_218 VGND VGND VPWR VPWR sky130_fd_sc_hd__decap_3
X_4607_ _4607_/A VGND VGND VPWR VPWR _8241_/D sky130_fd_sc_hd__buf_1
X_8375_ _8379_/CLK _8375_/D VGND VGND VPWR VPWR _8375_/Q sky130_fd_sc_hd__dfxtp_2
X_5587_ _5587_/A VGND VGND VPWR VPWR _5587_/X sky130_fd_sc_hd__buf_1
XFILLER_117_24 VGND VGND VPWR VPWR sky130_fd_sc_hd__decap_3
XFILLER_89_102 VGND VGND VPWR VPWR sky130_fd_sc_hd__decap_3
XFILLER_89_113 VGND VGND VPWR VPWR sky130_fd_sc_hd__fill_2
X_7326_ _7398_/A VGND VGND VPWR VPWR _7326_/Y sky130_fd_sc_hd__inv_2
X_4538_ _7898_/B _8073_/Q VGND VGND VPWR VPWR _4539_/A sky130_fd_sc_hd__and2_2
XFILLER_104_424 VGND VGND VPWR VPWR sky130_fd_sc_hd__decap_3
XFILLER_117_57 VGND VGND VPWR VPWR sky130_fd_sc_hd__fill_1
X_7257_ _8211_/Q _8275_/Q VGND VGND VPWR VPWR _7257_/X sky130_fd_sc_hd__or2_2
X_4469_ _4469_/A VGND VGND VPWR VPWR _8172_/D sky130_fd_sc_hd__buf_1
XFILLER_77_308 VGND VGND VPWR VPWR sky130_fd_sc_hd__decap_3
XPHY_EDGE_ROW_86_Right_86 VGND VGND VPWR VPWR sky130_fd_sc_hd__decap_3
X_6208_ _6203_/Y _6205_/Y _6207_/X _6721_/A VGND VGND VPWR VPWR _6208_/X sky130_fd_sc_hd__o2bb2a_2
XFILLER_58_533 VGND VGND VPWR VPWR sky130_fd_sc_hd__decap_3
X_7188_ _5396_/A _7185_/X _7187_/X VGND VGND VPWR VPWR _7188_/Y sky130_fd_sc_hd__o21ai_2
XTAP_TAPCELL_ROW_5_323 VGND VPWR sky130_fd_sc_hd__tapvpwrvgnd_1
XFILLER_100_663 VGND VGND VPWR VPWR sky130_fd_sc_hd__decap_3
XFILLER_18_408 VGND VGND VPWR VPWR sky130_fd_sc_hd__decap_3
XFILLER_58_555 VGND VGND VPWR VPWR sky130_fd_sc_hd__decap_3
XFILLER_58_566 VGND VGND VPWR VPWR sky130_fd_sc_hd__decap_3
XFILLER_85_352 VGND VGND VPWR VPWR sky130_fd_sc_hd__decap_3
XFILLER_97_190 VGND VGND VPWR VPWR sky130_fd_sc_hd__decap_3
X_6139_ _6395_/A _5929_/X _6138_/X VGND VGND VPWR VPWR _6140_/B sky130_fd_sc_hd__o21ai_2
XFILLER_73_514 VGND VGND VPWR VPWR sky130_fd_sc_hd__decap_3
XFILLER_85_363 VGND VGND VPWR VPWR sky130_fd_sc_hd__decap_3
XFILLER_85_374 VGND VGND VPWR VPWR sky130_fd_sc_hd__decap_3
XFILLER_85_396 VGND VGND VPWR VPWR sky130_fd_sc_hd__decap_3
XFILLER_26_32 VGND VGND VPWR VPWR sky130_fd_sc_hd__fill_2
XFILLER_26_430 VGND VGND VPWR VPWR sky130_fd_sc_hd__decap_3
XFILLER_45_249 VGND VGND VPWR VPWR sky130_fd_sc_hd__decap_3
XFILLER_26_474 VGND VGND VPWR VPWR sky130_fd_sc_hd__fill_2
XFILLER_41_411 VGND VGND VPWR VPWR sky130_fd_sc_hd__decap_3
XFILLER_41_433 VGND VGND VPWR VPWR sky130_fd_sc_hd__decap_3
XPHY_EDGE_ROW_95_Right_95 VGND VGND VPWR VPWR sky130_fd_sc_hd__decap_3
XFILLER_13_135 VGND VGND VPWR VPWR sky130_fd_sc_hd__decap_3
XFILLER_41_455 VGND VGND VPWR VPWR sky130_fd_sc_hd__decap_3
XFILLER_42_20 VGND VGND VPWR VPWR sky130_fd_sc_hd__decap_3
XTAP_TAPCELL_ROW_52_940 VGND VPWR sky130_fd_sc_hd__tapvpwrvgnd_1
XFILLER_41_477 VGND VGND VPWR VPWR sky130_fd_sc_hd__decap_3
XFILLER_42_97 VGND VGND VPWR VPWR sky130_fd_sc_hd__fill_1
Xrebuffer450 _6907_/X VGND VGND VPWR VPWR _6909_/B sky130_fd_sc_hd__buf_4
XFILLER_5_334 VGND VGND VPWR VPWR sky130_fd_sc_hd__fill_2
XFILLER_107_262 VGND VGND VPWR VPWR sky130_fd_sc_hd__decap_3
XFILLER_107_284 VGND VGND VPWR VPWR sky130_fd_sc_hd__decap_3
XFILLER_95_105 VGND VGND VPWR VPWR sky130_fd_sc_hd__decap_3
XFILLER_96_606 VGND VGND VPWR VPWR sky130_fd_sc_hd__decap_3
XFILLER_110_427 VGND VGND VPWR VPWR sky130_fd_sc_hd__decap_3
XFILLER_3_69 VGND VGND VPWR VPWR sky130_fd_sc_hd__decap_3
XFILLER_49_511 VGND VGND VPWR VPWR sky130_fd_sc_hd__decap_3
XFILLER_67_50 VGND VGND VPWR VPWR sky130_fd_sc_hd__decap_3
XFILLER_95_116 VGND VGND VPWR VPWR sky130_fd_sc_hd__decap_3
XFILLER_95_127 VGND VGND VPWR VPWR sky130_fd_sc_hd__decap_3
XPHY_EDGE_ROW_79_Left_199 VGND VGND VPWR VPWR sky130_fd_sc_hd__decap_3
XFILLER_67_72 VGND VGND VPWR VPWR sky130_fd_sc_hd__decap_3
XFILLER_49_577 VGND VGND VPWR VPWR sky130_fd_sc_hd__fill_1
XFILLER_76_374 VGND VGND VPWR VPWR sky130_fd_sc_hd__fill_1
XFILLER_64_536 VGND VGND VPWR VPWR sky130_fd_sc_hd__decap_3
XFILLER_64_569 VGND VGND VPWR VPWR sky130_fd_sc_hd__decap_3
XFILLER_17_452 VGND VGND VPWR VPWR sky130_fd_sc_hd__decap_3
XFILLER_51_208 VGND VGND VPWR VPWR sky130_fd_sc_hd__decap_3
XFILLER_83_60 VGND VGND VPWR VPWR sky130_fd_sc_hd__decap_3
XFILLER_91_366 VGND VGND VPWR VPWR sky130_fd_sc_hd__decap_3
XFILLER_32_411 VGND VGND VPWR VPWR sky130_fd_sc_hd__decap_3
XFILLER_32_433 VGND VGND VPWR VPWR sky130_fd_sc_hd__decap_3
XFILLER_44_271 VGND VGND VPWR VPWR sky130_fd_sc_hd__decap_3
XFILLER_83_93 VGND VGND VPWR VPWR sky130_fd_sc_hd__fill_1
XFILLER_32_455 VGND VGND VPWR VPWR sky130_fd_sc_hd__decap_3
XFILLER_44_293 VGND VGND VPWR VPWR sky130_fd_sc_hd__decap_3
XFILLER_32_477 VGND VGND VPWR VPWR sky130_fd_sc_hd__decap_3
XFILLER_13_691 VGND VGND VPWR VPWR sky130_fd_sc_hd__fill_2
X_5510_ _8164_/Q _5511_/B _6620_/A VGND VGND VPWR VPWR _5512_/A sky130_fd_sc_hd__a21o_2
XTAP_TAPCELL_ROW_80_1294 VGND VPWR sky130_fd_sc_hd__tapvpwrvgnd_1
XTAP_TAPCELL_ROW_30_645 VGND VPWR sky130_fd_sc_hd__tapvpwrvgnd_1
XFILLER_73_3 VGND VGND VPWR VPWR sky130_fd_sc_hd__decap_3
XFILLER_8_150 VGND VGND VPWR VPWR sky130_fd_sc_hd__decap_3
XFILLER_9_673 VGND VGND VPWR VPWR sky130_fd_sc_hd__fill_1
X_6490_ _6490_/A _8183_/Q _8185_/Q _8186_/Q VGND VGND VPWR VPWR _6491_/D sky130_fd_sc_hd__and4_2
XFILLER_8_194 VGND VGND VPWR VPWR sky130_fd_sc_hd__fill_2
X_5441_ _7783_/A _6380_/S _5364_/Y _5439_/X VGND VGND VPWR VPWR _5441_/X sky130_fd_sc_hd__o31a_2
XFILLER_114_711 VGND VGND VPWR VPWR sky130_fd_sc_hd__decap_3
XFILLER_99_411 VGND VGND VPWR VPWR sky130_fd_sc_hd__decap_3
XTAP_TAPCELL_ROW_10_391 VGND VPWR sky130_fd_sc_hd__tapvpwrvgnd_1
X_8160_ _8360_/CLK _8160_/D VGND VGND VPWR VPWR _8160_/Q sky130_fd_sc_hd__dfxtp_4
X_5372_ _7825_/A _5359_/X _5371_/Y _5857_/A VGND VGND VPWR VPWR _5372_/X sky130_fd_sc_hd__o211a_2
XFILLER_113_210 VGND VGND VPWR VPWR sky130_fd_sc_hd__fill_2
XFILLER_113_221 VGND VGND VPWR VPWR sky130_fd_sc_hd__decap_3
X_8091_ _8226_/CLK _8091_/D VGND VGND VPWR VPWR _8091_/Q sky130_fd_sc_hd__dfxtp_2
X_7111_ _7069_/X _7228_/B VGND VGND VPWR VPWR _7111_/X sky130_fd_sc_hd__and2b_2
X_4323_ _4323_/A VGND VGND VPWR VPWR _8099_/D sky130_fd_sc_hd__buf_1
XFILLER_113_254 VGND VGND VPWR VPWR sky130_fd_sc_hd__decap_3
XFILLER_59_308 VGND VGND VPWR VPWR sky130_fd_sc_hd__decap_3
XFILLER_87_617 VGND VGND VPWR VPWR sky130_fd_sc_hd__fill_2
X_7042_ _8269_/Q _5323_/Y _5587_/X VGND VGND VPWR VPWR _7042_/Y sky130_fd_sc_hd__a21oi_2
XFILLER_101_416 VGND VGND VPWR VPWR sky130_fd_sc_hd__decap_3
XFILLER_86_138 VGND VGND VPWR VPWR sky130_fd_sc_hd__fill_2
X_4254_ _7898_/B _4254_/B VGND VGND VPWR VPWR _4255_/A sky130_fd_sc_hd__and2_2
XFILLER_67_352 VGND VGND VPWR VPWR sky130_fd_sc_hd__decap_3
XFILLER_86_149 VGND VGND VPWR VPWR sky130_fd_sc_hd__decap_3
X_4185_ _4185_/A VGND VGND VPWR VPWR _8030_/D sky130_fd_sc_hd__buf_1
XFILLER_67_385 VGND VGND VPWR VPWR sky130_fd_sc_hd__decap_3
XFILLER_27_249 VGND VGND VPWR VPWR sky130_fd_sc_hd__fill_2
XFILLER_67_396 VGND VGND VPWR VPWR sky130_fd_sc_hd__decap_3
X_7944_ _8349_/CLK _7944_/D VGND VGND VPWR VPWR _7944_/Q sky130_fd_sc_hd__dfxtp_2
XTAP_TAPCELL_ROW_38_756 VGND VPWR sky130_fd_sc_hd__tapvpwrvgnd_1
XFILLER_82_355 VGND VGND VPWR VPWR sky130_fd_sc_hd__fill_2
XFILLER_82_377 VGND VGND VPWR VPWR sky130_fd_sc_hd__decap_3
XFILLER_23_411 VGND VGND VPWR VPWR sky130_fd_sc_hd__decap_3
XFILLER_35_260 VGND VGND VPWR VPWR sky130_fd_sc_hd__decap_3
X_7875_ _7875_/A VGND VGND VPWR VPWR _8374_/D sky130_fd_sc_hd__buf_1
XFILLER_23_433 VGND VGND VPWR VPWR sky130_fd_sc_hd__decap_3
XFILLER_23_455 VGND VGND VPWR VPWR sky130_fd_sc_hd__decap_3
XFILLER_35_293 VGND VGND VPWR VPWR sky130_fd_sc_hd__decap_3
X_6826_ _6826_/A _6853_/B VGND VGND VPWR VPWR _6927_/B sky130_fd_sc_hd__nor2_2
XTAP_TAPCELL_ROW_18_491 VGND VPWR sky130_fd_sc_hd__tapvpwrvgnd_1
X_6757_ _6757_/A _6757_/B VGND VGND VPWR VPWR _6757_/Y sky130_fd_sc_hd__nand2_2
XFILLER_109_505 VGND VGND VPWR VPWR sky130_fd_sc_hd__decap_3
X_5708_ _8231_/Q _5664_/X _5707_/X VGND VGND VPWR VPWR _5709_/B sky130_fd_sc_hd__o21ai_2
X_3969_ _3969_/A VGND VGND VPWR VPWR _7933_/D sky130_fd_sc_hd__buf_1
X_6688_ _5350_/Y _6641_/X _6686_/X _6687_/X VGND VGND VPWR VPWR _6688_/X sky130_fd_sc_hd__a211o_2
XTAP_TAPCELL_ROW_98_1533 VGND VPWR sky130_fd_sc_hd__tapvpwrvgnd_1
X_5639_ _5635_/X _5636_/X _5637_/X _5638_/X _5671_/A _6321_/B VGND VGND VPWR VPWR
+ _5639_/X sky130_fd_sc_hd__mux4_2
X_8358_ _8359_/CLK _8358_/D VGND VGND VPWR VPWR _8358_/Q sky130_fd_sc_hd__dfxtp_2
XFILLER_104_221 VGND VGND VPWR VPWR sky130_fd_sc_hd__decap_3
X_7309_ _7309_/A _7383_/B VGND VGND VPWR VPWR _7309_/Y sky130_fd_sc_hd__nand2_2
XFILLER_104_265 VGND VGND VPWR VPWR sky130_fd_sc_hd__decap_3
X_8289_ clkload6/A _8289_/D VGND VGND VPWR VPWR _8289_/Q sky130_fd_sc_hd__dfxtp_2
XFILLER_104_287 VGND VGND VPWR VPWR sky130_fd_sc_hd__decap_3
XFILLER_77_116 VGND VGND VPWR VPWR sky130_fd_sc_hd__decap_3
XFILLER_19_706 VGND VGND VPWR VPWR sky130_fd_sc_hd__decap_3
XFILLER_58_330 VGND VGND VPWR VPWR sky130_fd_sc_hd__decap_3
XFILLER_93_609 VGND VGND VPWR VPWR sky130_fd_sc_hd__decap_3
XFILLER_18_205 VGND VGND VPWR VPWR sky130_fd_sc_hd__decap_3
XFILLER_46_503 VGND VGND VPWR VPWR sky130_fd_sc_hd__fill_2
XFILLER_58_363 VGND VGND VPWR VPWR sky130_fd_sc_hd__fill_1
XFILLER_58_374 VGND VGND VPWR VPWR sky130_fd_sc_hd__decap_3
XFILLER_73_300 VGND VGND VPWR VPWR sky130_fd_sc_hd__decap_3
XFILLER_92_119 VGND VGND VPWR VPWR sky130_fd_sc_hd__decap_3
XFILLER_100_482 VGND VGND VPWR VPWR sky130_fd_sc_hd__fill_1
XFILLER_100_493 VGND VGND VPWR VPWR sky130_fd_sc_hd__decap_3
XFILLER_18_249 VGND VGND VPWR VPWR sky130_fd_sc_hd__decap_3
XFILLER_46_547 VGND VGND VPWR VPWR sky130_fd_sc_hd__decap_3
XFILLER_46_558 VGND VGND VPWR VPWR sky130_fd_sc_hd__decap_3
XFILLER_85_182 VGND VGND VPWR VPWR sky130_fd_sc_hd__decap_3
XFILLER_61_517 VGND VGND VPWR VPWR sky130_fd_sc_hd__decap_3
XFILLER_73_377 VGND VGND VPWR VPWR sky130_fd_sc_hd__decap_3
XTAP_TAPCELL_ROW_107_1651 VGND VPWR sky130_fd_sc_hd__tapvpwrvgnd_1
XFILLER_14_400 VGND VGND VPWR VPWR sky130_fd_sc_hd__decap_3
XFILLER_14_411 VGND VGND VPWR VPWR sky130_fd_sc_hd__fill_2
XFILLER_26_271 VGND VGND VPWR VPWR sky130_fd_sc_hd__decap_3
XFILLER_33_219 VGND VGND VPWR VPWR sky130_fd_sc_hd__decap_3
XFILLER_54_580 VGND VGND VPWR VPWR sky130_fd_sc_hd__decap_3
XFILLER_53_63 VGND VGND VPWR VPWR sky130_fd_sc_hd__decap_3
XFILLER_14_488 VGND VGND VPWR VPWR sky130_fd_sc_hd__decap_3
XFILLER_41_274 VGND VGND VPWR VPWR sky130_fd_sc_hd__decap_3
XFILLER_53_96 VGND VGND VPWR VPWR sky130_fd_sc_hd__decap_3
XFILLER_6_643 VGND VGND VPWR VPWR sky130_fd_sc_hd__fill_1
XTAP_TAPCELL_ROW_58_1016 VGND VPWR sky130_fd_sc_hd__tapvpwrvgnd_1
XTAP_TAPCELL_ROW_118_1791 VGND VPWR sky130_fd_sc_hd__tapvpwrvgnd_1
Xrebuffer291 rebuffer508/X VGND VGND VPWR VPWR _7473_/A2 sky130_fd_sc_hd__buf_6
Xrebuffer280 _6601_/X VGND VGND VPWR VPWR _6603_/B sky130_fd_sc_hd__buf_2
XFILLER_6_698 VGND VGND VPWR VPWR sky130_fd_sc_hd__fill_2
XFILLER_111_703 VGND VGND VPWR VPWR sky130_fd_sc_hd__fill_2
XFILLER_69_617 VGND VGND VPWR VPWR sky130_fd_sc_hd__decap_3
XFILLER_78_60 VGND VGND VPWR VPWR sky130_fd_sc_hd__fill_2
XPHY_EDGE_ROW_87_Left_207 VGND VGND VPWR VPWR sky130_fd_sc_hd__decap_3
XFILLER_110_224 VGND VGND VPWR VPWR sky130_fd_sc_hd__fill_1
XFILLER_69_639 VGND VGND VPWR VPWR sky130_fd_sc_hd__decap_3
XFILLER_96_414 VGND VGND VPWR VPWR sky130_fd_sc_hd__decap_3
XFILLER_96_436 VGND VGND VPWR VPWR sky130_fd_sc_hd__decap_3
XFILLER_68_149 VGND VGND VPWR VPWR sky130_fd_sc_hd__decap_3
XFILLER_77_650 VGND VGND VPWR VPWR sky130_fd_sc_hd__decap_3
XFILLER_84_609 VGND VGND VPWR VPWR sky130_fd_sc_hd__fill_1
XFILLER_110_268 VGND VGND VPWR VPWR sky130_fd_sc_hd__decap_3
XFILLER_37_514 VGND VGND VPWR VPWR sky130_fd_sc_hd__fill_2
XFILLER_37_525 VGND VGND VPWR VPWR sky130_fd_sc_hd__decap_3
XFILLER_49_352 VGND VGND VPWR VPWR sky130_fd_sc_hd__decap_3
XFILLER_64_300 VGND VGND VPWR VPWR sky130_fd_sc_hd__decap_3
XFILLER_83_119 VGND VGND VPWR VPWR sky130_fd_sc_hd__fill_1
XFILLER_37_558 VGND VGND VPWR VPWR sky130_fd_sc_hd__fill_2
XFILLER_64_333 VGND VGND VPWR VPWR sky130_fd_sc_hd__decap_3
XFILLER_76_193 VGND VGND VPWR VPWR sky130_fd_sc_hd__decap_3
XFILLER_92_620 VGND VGND VPWR VPWR sky130_fd_sc_hd__decap_3
XFILLER_64_377 VGND VGND VPWR VPWR sky130_fd_sc_hd__fill_1
XFILLER_92_686 VGND VGND VPWR VPWR sky130_fd_sc_hd__decap_3
X_5990_ _7193_/A _5983_/X _5987_/Y _5989_/Y VGND VGND VPWR VPWR _5990_/Y sky130_fd_sc_hd__a22oi_2
XTAP_TAPCELL_ROW_69_1156 VGND VPWR sky130_fd_sc_hd__tapvpwrvgnd_1
XFILLER_17_260 VGND VGND VPWR VPWR sky130_fd_sc_hd__decap_3
XFILLER_52_539 VGND VGND VPWR VPWR sky130_fd_sc_hd__decap_3
XFILLER_64_399 VGND VGND VPWR VPWR sky130_fd_sc_hd__decap_3
XFILLER_91_196 VGND VGND VPWR VPWR sky130_fd_sc_hd__decap_3
X_4941_ _4941_/A _4941_/B VGND VGND VPWR VPWR _4970_/A sky130_fd_sc_hd__or2_2
XTAP_TAPCELL_ROW_82_1323 VGND VPWR sky130_fd_sc_hd__tapvpwrvgnd_1
XTAP_TAPCELL_ROW_35_715 VGND VPWR sky130_fd_sc_hd__tapvpwrvgnd_1
XFILLER_17_293 VGND VGND VPWR VPWR sky130_fd_sc_hd__decap_3
XPHY_EDGE_ROW_96_Left_216 VGND VGND VPWR VPWR sky130_fd_sc_hd__decap_3
X_7660_ _7660_/A VGND VGND VPWR VPWR _7660_/X sky130_fd_sc_hd__buf_1
X_4872_ _8248_/Q _8184_/Q VGND VGND VPWR VPWR _6400_/A sky130_fd_sc_hd__or2b_2
XFILLER_60_561 VGND VGND VPWR VPWR sky130_fd_sc_hd__fill_1
XTAP_TAPCELL_ROW_15_450 VGND VPWR sky130_fd_sc_hd__tapvpwrvgnd_1
X_6611_ _8192_/Q _5337_/X _5718_/A _8256_/Q VGND VGND VPWR VPWR _6611_/X sky130_fd_sc_hd__a2bb2o_2
XFILLER_20_436 VGND VGND VPWR VPWR sky130_fd_sc_hd__fill_1
X_7591_ _8222_/Q _8221_/Q _7796_/A VGND VGND VPWR VPWR _7591_/X sky130_fd_sc_hd__mux2_2
X_6542_ _8289_/Q _6592_/D _6541_/Y _8290_/Q VGND VGND VPWR VPWR _6542_/X sky130_fd_sc_hd__o22a_2
X_6473_ _8186_/Q _4886_/B _6472_/X _6564_/C _6564_/B VGND VGND VPWR VPWR _6476_/B
+ sky130_fd_sc_hd__o2111a_2
X_8212_ _8226_/CLK _8212_/D VGND VGND VPWR VPWR _8212_/Q sky130_fd_sc_hd__dfxtp_2
Xoutput200 _7965_/Q VGND VGND VPWR VPWR result[7] sky130_fd_sc_hd__clkdlybuf4s25_1
X_5424_ split/A _5411_/B _5319_/A _5423_/X _8163_/Q VGND VGND VPWR VPWR _5424_/X sky130_fd_sc_hd__o311a_2
X_8143_ _8280_/CLK _8143_/D VGND VGND VPWR VPWR _8143_/Q sky130_fd_sc_hd__dfxtp_2
XFILLER_58_19 VGND VGND VPWR VPWR sky130_fd_sc_hd__decap_3
XFILLER_99_263 VGND VGND VPWR VPWR sky130_fd_sc_hd__decap_3
X_5355_ _5353_/X _5354_/X _5596_/S VGND VGND VPWR VPWR _5355_/X sky130_fd_sc_hd__mux2_2
XTAP_TAPCELL_ROW_93_1474 VGND VPWR sky130_fd_sc_hd__tapvpwrvgnd_1
XTAP_TAPCELL_ROW_93_1463 VGND VPWR sky130_fd_sc_hd__tapvpwrvgnd_1
XFILLER_59_105 VGND VGND VPWR VPWR sky130_fd_sc_hd__decap_3
X_8074_ _8228_/CLK _8074_/D VGND VGND VPWR VPWR _8074_/Q sky130_fd_sc_hd__dfxtp_2
X_5286_ _5286_/A _8292_/Q VGND VGND VPWR VPWR _5288_/A sky130_fd_sc_hd__and2_2
X_4306_ _7898_/B _4306_/B VGND VGND VPWR VPWR _4307_/A sky130_fd_sc_hd__and2_2
XFILLER_101_246 VGND VGND VPWR VPWR sky130_fd_sc_hd__decap_3
XFILLER_75_609 VGND VGND VPWR VPWR sky130_fd_sc_hd__decap_3
X_7025_ _5966_/X _6995_/X _6996_/Y _7024_/X _7930_/B VGND VGND VPWR VPWR _8338_/D
+ sky130_fd_sc_hd__o311a_2
X_4237_ _4237_/A VGND VGND VPWR VPWR _8056_/D sky130_fd_sc_hd__buf_1
XFILLER_101_279 VGND VGND VPWR VPWR sky130_fd_sc_hd__fill_1
XFILLER_114_47 VGND VGND VPWR VPWR sky130_fd_sc_hd__decap_3
XFILLER_28_525 VGND VGND VPWR VPWR sky130_fd_sc_hd__decap_3
XFILLER_68_694 VGND VGND VPWR VPWR sky130_fd_sc_hd__decap_3
XFILLER_74_29 VGND VGND VPWR VPWR sky130_fd_sc_hd__decap_3
XFILLER_83_631 VGND VGND VPWR VPWR sky130_fd_sc_hd__decap_3
X_4168_ _7930_/B _7954_/Q VGND VGND VPWR VPWR _4169_/A sky130_fd_sc_hd__and2_2
XFILLER_82_141 VGND VGND VPWR VPWR sky130_fd_sc_hd__decap_3
XFILLER_83_664 VGND VGND VPWR VPWR sky130_fd_sc_hd__decap_3
X_4099_ _4099_/A VGND VGND VPWR VPWR _7987_/D sky130_fd_sc_hd__buf_1
XFILLER_43_539 VGND VGND VPWR VPWR sky130_fd_sc_hd__decap_3
XFILLER_55_399 VGND VGND VPWR VPWR sky130_fd_sc_hd__decap_3
XFILLER_70_336 VGND VGND VPWR VPWR sky130_fd_sc_hd__fill_2
XFILLER_82_185 VGND VGND VPWR VPWR sky130_fd_sc_hd__decap_3
X_7927_ _7927_/A VGND VGND VPWR VPWR _8400_/D sky130_fd_sc_hd__buf_1
XFILLER_23_241 VGND VGND VPWR VPWR sky130_fd_sc_hd__fill_1
X_7858_ _8299_/Q _7930_/B VGND VGND VPWR VPWR _7859_/A sky130_fd_sc_hd__and2_2
XFILLER_51_561 VGND VGND VPWR VPWR sky130_fd_sc_hd__decap_3
XFILLER_51_583 VGND VGND VPWR VPWR sky130_fd_sc_hd__decap_3
X_6809_ _6848_/C _6848_/D VGND VGND VPWR VPWR _6810_/B sky130_fd_sc_hd__nand2_2
XFILLER_11_447 VGND VGND VPWR VPWR sky130_fd_sc_hd__fill_1
XTAP_TAPCELL_ROW_102_1581 VGND VPWR sky130_fd_sc_hd__tapvpwrvgnd_1
X_7789_ _7670_/A _7747_/A _7787_/Y _7788_/Y VGND VGND VPWR VPWR _7789_/X sky130_fd_sc_hd__a31o_2
XFILLER_99_26 VGND VGND VPWR VPWR sky130_fd_sc_hd__decap_3
XFILLER_109_379 VGND VGND VPWR VPWR sky130_fd_sc_hd__decap_3
XFILLER_2_112 VGND VGND VPWR VPWR sky130_fd_sc_hd__decap_3
XFILLER_3_3 VGND VGND VPWR VPWR sky130_fd_sc_hd__fill_2
XFILLER_105_574 VGND VGND VPWR VPWR sky130_fd_sc_hd__decap_3
XFILLER_59_650 VGND VGND VPWR VPWR sky130_fd_sc_hd__decap_3
XFILLER_19_514 VGND VGND VPWR VPWR sky130_fd_sc_hd__decap_3
XFILLER_48_85 VGND VGND VPWR VPWR sky130_fd_sc_hd__decap_3
XFILLER_65_119 VGND VGND VPWR VPWR sky130_fd_sc_hd__decap_3
XFILLER_93_428 VGND VGND VPWR VPWR sky130_fd_sc_hd__decap_3
XFILLER_0_15 VGND VGND VPWR VPWR sky130_fd_sc_hd__decap_3
XFILLER_19_547 VGND VGND VPWR VPWR sky130_fd_sc_hd__decap_3
XFILLER_46_333 VGND VGND VPWR VPWR sky130_fd_sc_hd__decap_3
XFILLER_59_694 VGND VGND VPWR VPWR sky130_fd_sc_hd__fill_2
XFILLER_86_480 VGND VGND VPWR VPWR sky130_fd_sc_hd__fill_1
XFILLER_34_506 VGND VGND VPWR VPWR sky130_fd_sc_hd__fill_1
XFILLER_46_355 VGND VGND VPWR VPWR sky130_fd_sc_hd__decap_3
XFILLER_73_152 VGND VGND VPWR VPWR sky130_fd_sc_hd__decap_3
XFILLER_34_528 VGND VGND VPWR VPWR sky130_fd_sc_hd__decap_3
XFILLER_46_399 VGND VGND VPWR VPWR sky130_fd_sc_hd__decap_3
XFILLER_64_73 VGND VGND VPWR VPWR sky130_fd_sc_hd__fill_2
XFILLER_61_358 VGND VGND VPWR VPWR sky130_fd_sc_hd__decap_3
XFILLER_61_369 VGND VGND VPWR VPWR sky130_fd_sc_hd__decap_3
XFILLER_30_701 VGND VGND VPWR VPWR sky130_fd_sc_hd__decap_3
XFILLER_42_561 VGND VGND VPWR VPWR sky130_fd_sc_hd__decap_3
XFILLER_14_296 VGND VGND VPWR VPWR sky130_fd_sc_hd__decap_3
XFILLER_9_57 VGND VGND VPWR VPWR sky130_fd_sc_hd__decap_3
XTAP_TAPCELL_ROW_12_420 VGND VPWR sky130_fd_sc_hd__tapvpwrvgnd_1
XTAP_TAPCELL_ROW_64_1097 VGND VPWR sky130_fd_sc_hd__tapvpwrvgnd_1
XTAP_TAPCELL_ROW_64_1086 VGND VPWR sky130_fd_sc_hd__tapvpwrvgnd_1
XFILLER_10_480 VGND VGND VPWR VPWR sky130_fd_sc_hd__decap_3
XFILLER_80_94 VGND VGND VPWR VPWR sky130_fd_sc_hd__decap_3
XTAP_TAPCELL_ROW_40_784 VGND VPWR sky130_fd_sc_hd__tapvpwrvgnd_1
XTAP_TAPCELL_ROW_40_773 VGND VPWR sky130_fd_sc_hd__tapvpwrvgnd_1
XFILLER_115_349 VGND VGND VPWR VPWR sky130_fd_sc_hd__decap_3
XFILLER_108_390 VGND VGND VPWR VPWR sky130_fd_sc_hd__decap_3
XFILLER_111_522 VGND VGND VPWR VPWR sky130_fd_sc_hd__decap_3
XFILLER_36_3 VGND VGND VPWR VPWR sky130_fd_sc_hd__decap_3
XFILLER_96_200 VGND VGND VPWR VPWR sky130_fd_sc_hd__decap_3
X_5140_ _8220_/Q _8221_/Q _5484_/S VGND VGND VPWR VPWR _5140_/X sky130_fd_sc_hd__mux2_2
XFILLER_111_555 VGND VGND VPWR VPWR sky130_fd_sc_hd__decap_3
XFILLER_96_233 VGND VGND VPWR VPWR sky130_fd_sc_hd__decap_3
X_5071_ _5071_/A _7843_/B _7649_/A VGND VGND VPWR VPWR _5072_/B sky130_fd_sc_hd__or3b_2
XFILLER_96_277 VGND VGND VPWR VPWR sky130_fd_sc_hd__fill_2
X_4022_ _8323_/Q _8350_/Q _8353_/Q _8352_/Q VGND VGND VPWR VPWR _4026_/A sky130_fd_sc_hd__or4_2
XFILLER_37_333 VGND VGND VPWR VPWR sky130_fd_sc_hd__decap_3
XFILLER_49_193 VGND VGND VPWR VPWR sky130_fd_sc_hd__decap_3
XFILLER_77_480 VGND VGND VPWR VPWR sky130_fd_sc_hd__decap_3
XFILLER_96_299 VGND VGND VPWR VPWR sky130_fd_sc_hd__decap_3
XFILLER_65_664 VGND VGND VPWR VPWR sky130_fd_sc_hd__decap_3
XFILLER_92_461 VGND VGND VPWR VPWR sky130_fd_sc_hd__decap_3
XFILLER_25_517 VGND VGND VPWR VPWR sky130_fd_sc_hd__fill_2
XFILLER_37_388 VGND VGND VPWR VPWR sky130_fd_sc_hd__decap_3
XFILLER_37_399 VGND VGND VPWR VPWR sky130_fd_sc_hd__decap_3
XFILLER_52_303 VGND VGND VPWR VPWR sky130_fd_sc_hd__decap_3
XFILLER_64_185 VGND VGND VPWR VPWR sky130_fd_sc_hd__decap_3
XFILLER_80_612 VGND VGND VPWR VPWR sky130_fd_sc_hd__fill_2
XFILLER_80_623 VGND VGND VPWR VPWR sky130_fd_sc_hd__fill_1
X_5973_ _5396_/A _6022_/B _5972_/Y _5402_/X _6039_/B VGND VGND VPWR VPWR _5973_/X
+ sky130_fd_sc_hd__a32o_2
XTAP_TAPCELL_ROW_48_884 VGND VPWR sky130_fd_sc_hd__tapvpwrvgnd_1
XFILLER_52_347 VGND VGND VPWR VPWR sky130_fd_sc_hd__decap_3
XFILLER_80_645 VGND VGND VPWR VPWR sky130_fd_sc_hd__decap_3
X_7712_ _7754_/A _7710_/Y _7711_/Y _7796_/A VGND VGND VPWR VPWR _7712_/X sky130_fd_sc_hd__a22o_2
X_4924_ _6039_/B _4923_/X VGND VGND VPWR VPWR _5998_/S sky130_fd_sc_hd__or2b_2
XFILLER_33_550 VGND VGND VPWR VPWR sky130_fd_sc_hd__decap_3
XFILLER_33_561 VGND VGND VPWR VPWR sky130_fd_sc_hd__fill_2
XFILLER_33_572 VGND VGND VPWR VPWR sky130_fd_sc_hd__decap_3
XFILLER_20_200 VGND VGND VPWR VPWR sky130_fd_sc_hd__decap_3
XFILLER_20_233 VGND VGND VPWR VPWR sky130_fd_sc_hd__decap_3
XFILLER_33_594 VGND VGND VPWR VPWR sky130_fd_sc_hd__decap_3
XFILLER_60_391 VGND VGND VPWR VPWR sky130_fd_sc_hd__decap_3
X_7643_ _5714_/X _7844_/D _7640_/Y _7642_/X VGND VGND VPWR VPWR _7643_/X sky130_fd_sc_hd__o31a_2
X_4855_ _4855_/A _4855_/B _4854_/X VGND VGND VPWR VPWR _4971_/B sky130_fd_sc_hd__or3b_2
XFILLER_119_611 VGND VGND VPWR VPWR sky130_fd_sc_hd__decap_3
XFILLER_20_266 VGND VGND VPWR VPWR sky130_fd_sc_hd__fill_2
X_7574_ _8220_/Q _7574_/B VGND VGND VPWR VPWR _7575_/D sky130_fd_sc_hd__or2_2
X_4786_ _4786_/A _4786_/B VGND VGND VPWR VPWR _7226_/A sky130_fd_sc_hd__nand2_2
XFILLER_109_14 VGND VGND VPWR VPWR sky130_fd_sc_hd__decap_3
X_6525_ _6525_/A1 _6483_/A _6483_/B _6496_/Y VGND VGND VPWR VPWR _6527_/C sky130_fd_sc_hd__a31o_4
XFILLER_106_305 VGND VGND VPWR VPWR sky130_fd_sc_hd__decap_3
XFILLER_109_36 VGND VGND VPWR VPWR sky130_fd_sc_hd__decap_3
XFILLER_118_165 VGND VGND VPWR VPWR sky130_fd_sc_hd__fill_2
XFILLER_119_666 VGND VGND VPWR VPWR sky130_fd_sc_hd__decap_3
XFILLER_119_688 VGND VGND VPWR VPWR sky130_fd_sc_hd__decap_3
XFILLER_106_349 VGND VGND VPWR VPWR sky130_fd_sc_hd__decap_3
X_6456_ _8229_/Q _6455_/X _5124_/A VGND VGND VPWR VPWR _6456_/Y sky130_fd_sc_hd__o21ai_2
X_6387_ _6353_/A _5775_/X _6067_/Y VGND VGND VPWR VPWR _6387_/X sky130_fd_sc_hd__o21a_2
X_5407_ _5407_/A VGND VGND VPWR VPWR _5407_/X sky130_fd_sc_hd__buf_1
XFILLER_114_371 VGND VGND VPWR VPWR sky130_fd_sc_hd__decap_3
XFILLER_87_211 VGND VGND VPWR VPWR sky130_fd_sc_hd__decap_3
X_8126_ _8397_/CLK _8126_/D VGND VGND VPWR VPWR _8126_/Q sky130_fd_sc_hd__dfxtp_2
X_5338_ _5338_/A VGND VGND VPWR VPWR _5338_/X sky130_fd_sc_hd__clkbuf_1
XFILLER_48_609 VGND VGND VPWR VPWR sky130_fd_sc_hd__decap_3
XFILLER_85_17 VGND VGND VPWR VPWR sky130_fd_sc_hd__decap_3
X_8057_ clkload4/A _8057_/D VGND VGND VPWR VPWR _8057_/Q sky130_fd_sc_hd__dfxtp_2
XFILLER_47_108 VGND VGND VPWR VPWR sky130_fd_sc_hd__decap_3
XFILLER_75_417 VGND VGND VPWR VPWR sky130_fd_sc_hd__decap_3
XFILLER_85_39 VGND VGND VPWR VPWR sky130_fd_sc_hd__decap_3
XFILLER_87_255 VGND VGND VPWR VPWR sky130_fd_sc_hd__fill_2
XFILLER_87_266 VGND VGND VPWR VPWR sky130_fd_sc_hd__decap_3
XFILLER_87_277 VGND VGND VPWR VPWR sky130_fd_sc_hd__decap_3
X_7008_ _8195_/Q _8196_/Q _8202_/Q _8203_/Q VGND VGND VPWR VPWR _7009_/D sky130_fd_sc_hd__and4_2
X_5269_ _6708_/A VGND VGND VPWR VPWR _6819_/A sky130_fd_sc_hd__buf_1
XFILLER_56_642 VGND VGND VPWR VPWR sky130_fd_sc_hd__fill_2
XFILLER_68_480 VGND VGND VPWR VPWR sky130_fd_sc_hd__decap_3
XFILLER_87_299 VGND VGND VPWR VPWR sky130_fd_sc_hd__decap_3
XFILLER_16_506 VGND VGND VPWR VPWR sky130_fd_sc_hd__decap_3
XFILLER_83_461 VGND VGND VPWR VPWR sky130_fd_sc_hd__decap_3
XFILLER_18_99 VGND VGND VPWR VPWR sky130_fd_sc_hd__decap_3
XFILLER_28_377 VGND VGND VPWR VPWR sky130_fd_sc_hd__decap_3
XFILLER_43_325 VGND VGND VPWR VPWR sky130_fd_sc_hd__decap_3
XFILLER_56_697 VGND VGND VPWR VPWR sky130_fd_sc_hd__decap_3
XFILLER_70_100 VGND VGND VPWR VPWR sky130_fd_sc_hd__decap_3
XFILLER_83_494 VGND VGND VPWR VPWR sky130_fd_sc_hd__decap_3
XFILLER_70_144 VGND VGND VPWR VPWR sky130_fd_sc_hd__decap_3
XFILLER_71_656 VGND VGND VPWR VPWR sky130_fd_sc_hd__fill_1
XFILLER_71_667 VGND VGND VPWR VPWR sky130_fd_sc_hd__decap_3
XTAP_TAPCELL_ROW_104_1610 VGND VPWR sky130_fd_sc_hd__tapvpwrvgnd_1
XFILLER_24_550 VGND VGND VPWR VPWR sky130_fd_sc_hd__decap_3
XFILLER_70_177 VGND VGND VPWR VPWR sky130_fd_sc_hd__decap_3
XFILLER_51_391 VGND VGND VPWR VPWR sky130_fd_sc_hd__fill_1
XFILLER_8_716 VGND VGND VPWR VPWR sky130_fd_sc_hd__decap_3
XFILLER_11_277 VGND VGND VPWR VPWR sky130_fd_sc_hd__decap_3
XFILLER_11_299 VGND VGND VPWR VPWR sky130_fd_sc_hd__decap_3
XFILLER_7_215 VGND VGND VPWR VPWR sky130_fd_sc_hd__fill_2
XFILLER_109_165 VGND VGND VPWR VPWR sky130_fd_sc_hd__decap_3
XFILLER_50_75 VGND VGND VPWR VPWR sky130_fd_sc_hd__decap_3
XFILLER_109_187 VGND VGND VPWR VPWR sky130_fd_sc_hd__decap_3
XFILLER_3_421 VGND VGND VPWR VPWR sky130_fd_sc_hd__decap_3
XFILLER_50_97 VGND VGND VPWR VPWR sky130_fd_sc_hd__decap_3
XTAP_TAPCELL_ROW_115_1750 VGND VPWR sky130_fd_sc_hd__tapvpwrvgnd_1
XFILLER_59_40 VGND VGND VPWR VPWR sky130_fd_sc_hd__decap_3
XFILLER_78_200 VGND VGND VPWR VPWR sky130_fd_sc_hd__decap_3
XFILLER_39_609 VGND VGND VPWR VPWR sky130_fd_sc_hd__decap_3
XFILLER_3_498 VGND VGND VPWR VPWR sky130_fd_sc_hd__decap_3
XFILLER_78_233 VGND VGND VPWR VPWR sky130_fd_sc_hd__decap_3
XFILLER_66_406 VGND VGND VPWR VPWR sky130_fd_sc_hd__decap_3
XFILLER_47_620 VGND VGND VPWR VPWR sky130_fd_sc_hd__decap_3
XFILLER_78_288 VGND VGND VPWR VPWR sky130_fd_sc_hd__decap_3
XFILLER_78_299 VGND VGND VPWR VPWR sky130_fd_sc_hd__decap_3
XFILLER_93_225 VGND VGND VPWR VPWR sky130_fd_sc_hd__decap_3
XFILLER_19_355 VGND VGND VPWR VPWR sky130_fd_sc_hd__decap_3
XFILLER_46_141 VGND VGND VPWR VPWR sky130_fd_sc_hd__decap_3
XFILLER_19_399 VGND VGND VPWR VPWR sky130_fd_sc_hd__decap_3
XFILLER_46_174 VGND VGND VPWR VPWR sky130_fd_sc_hd__decap_3
XFILLER_62_601 VGND VGND VPWR VPWR sky130_fd_sc_hd__decap_3
XFILLER_62_634 VGND VGND VPWR VPWR sky130_fd_sc_hd__decap_3
XFILLER_74_472 VGND VGND VPWR VPWR sky130_fd_sc_hd__decap_3
XTAP_TAPCELL_ROW_66_1115 VGND VPWR sky130_fd_sc_hd__tapvpwrvgnd_1
XFILLER_34_336 VGND VGND VPWR VPWR sky130_fd_sc_hd__decap_3
XFILLER_61_122 VGND VGND VPWR VPWR sky130_fd_sc_hd__decap_3
XFILLER_61_144 VGND VGND VPWR VPWR sky130_fd_sc_hd__decap_3
XTAP_TAPCELL_ROW_45_843 VGND VPWR sky130_fd_sc_hd__tapvpwrvgnd_1
XFILLER_15_561 VGND VGND VPWR VPWR sky130_fd_sc_hd__decap_3
XFILLER_30_531 VGND VGND VPWR VPWR sky130_fd_sc_hd__fill_1
XFILLER_42_391 VGND VGND VPWR VPWR sky130_fd_sc_hd__decap_3
XFILLER_61_188 VGND VGND VPWR VPWR sky130_fd_sc_hd__decap_3
XFILLER_91_71 VGND VGND VPWR VPWR sky130_fd_sc_hd__decap_3
X_4640_ _7930_/B _8124_/Q VGND VGND VPWR VPWR _4641_/A sky130_fd_sc_hd__and2_2
XFILLER_30_597 VGND VGND VPWR VPWR sky130_fd_sc_hd__decap_3
X_6310_ _6769_/A _6309_/X _5701_/X _8184_/Q VGND VGND VPWR VPWR _6310_/X sky130_fd_sc_hd__o2bb2a_2
X_4571_ _4571_/A VGND VGND VPWR VPWR _8223_/D sky130_fd_sc_hd__buf_1
XFILLER_115_113 VGND VGND VPWR VPWR sky130_fd_sc_hd__decap_3
X_7290_ _7398_/B _7290_/B VGND VGND VPWR VPWR _7290_/Y sky130_fd_sc_hd__xnor2_2
XTAP_TAPCELL_ROW_77_1255 VGND VPWR sky130_fd_sc_hd__tapvpwrvgnd_1
XFILLER_115_157 VGND VGND VPWR VPWR sky130_fd_sc_hd__decap_3
XFILLER_116_669 VGND VGND VPWR VPWR sky130_fd_sc_hd__decap_3
X_6241_ _6240_/X _5957_/X _6507_/S VGND VGND VPWR VPWR _6819_/B sky130_fd_sc_hd__mux2_2
XTAP_TAPCELL_ROW_77_1266 VGND VPWR sky130_fd_sc_hd__tapvpwrvgnd_1
XFILLER_69_211 VGND VGND VPWR VPWR sky130_fd_sc_hd__decap_3
X_6172_ _6172_/A VGND VGND VPWR VPWR _6623_/B sky130_fd_sc_hd__inv_2
XTAP_TAPCELL_ROW_90_1433 VGND VPWR sky130_fd_sc_hd__tapvpwrvgnd_1
XFILLER_111_330 VGND VGND VPWR VPWR sky130_fd_sc_hd__decap_3
XFILLER_97_531 VGND VGND VPWR VPWR sky130_fd_sc_hd__decap_3
X_5123_ _5857_/A VGND VGND VPWR VPWR _5124_/A sky130_fd_sc_hd__clkbuf_2
XFILLER_111_363 VGND VGND VPWR VPWR sky130_fd_sc_hd__decap_3
XFILLER_84_203 VGND VGND VPWR VPWR sky130_fd_sc_hd__decap_3
XFILLER_97_586 VGND VGND VPWR VPWR sky130_fd_sc_hd__decap_3
XFILLER_29_119 VGND VGND VPWR VPWR sky130_fd_sc_hd__decap_3
XFILLER_69_299 VGND VGND VPWR VPWR sky130_fd_sc_hd__decap_3
X_5054_ _8190_/Q _5054_/B VGND VGND VPWR VPWR _5054_/Y sky130_fd_sc_hd__nor2_2
XFILLER_38_642 VGND VGND VPWR VPWR sky130_fd_sc_hd__fill_2
XFILLER_72_409 VGND VGND VPWR VPWR sky130_fd_sc_hd__decap_3
XFILLER_84_247 VGND VGND VPWR VPWR sky130_fd_sc_hd__decap_3
X_4005_ _4005_/A VGND VGND VPWR VPWR _7951_/D sky130_fd_sc_hd__buf_1
XFILLER_25_303 VGND VGND VPWR VPWR sky130_fd_sc_hd__decap_3
XFILLER_52_100 VGND VGND VPWR VPWR sky130_fd_sc_hd__decap_3
XFILLER_53_623 VGND VGND VPWR VPWR sky130_fd_sc_hd__decap_3
XFILLER_65_472 VGND VGND VPWR VPWR sky130_fd_sc_hd__decap_3
XFILLER_111_26 VGND VGND VPWR VPWR sky130_fd_sc_hd__decap_3
XFILLER_37_196 VGND VGND VPWR VPWR sky130_fd_sc_hd__decap_3
XFILLER_52_133 VGND VGND VPWR VPWR sky130_fd_sc_hd__decap_3
XFILLER_53_656 VGND VGND VPWR VPWR sky130_fd_sc_hd__fill_1
XFILLER_52_166 VGND VGND VPWR VPWR sky130_fd_sc_hd__decap_3
XFILLER_80_464 VGND VGND VPWR VPWR sky130_fd_sc_hd__decap_3
X_5956_ _6024_/A _8173_/Q _6380_/S VGND VGND VPWR VPWR _5956_/X sky130_fd_sc_hd__mux2_2
XFILLER_33_391 VGND VGND VPWR VPWR sky130_fd_sc_hd__fill_1
XFILLER_52_188 VGND VGND VPWR VPWR sky130_fd_sc_hd__decap_3
XFILLER_80_497 VGND VGND VPWR VPWR sky130_fd_sc_hd__fill_1
X_5887_ _5027_/B _5029_/X _8236_/Q _5884_/B VGND VGND VPWR VPWR _5887_/X sky130_fd_sc_hd__a211o_4
X_4907_ _4907_/A _5037_/B VGND VGND VPWR VPWR _6046_/A sky130_fd_sc_hd__or2_2
X_7626_ _7626_/A _7626_/B VGND VGND VPWR VPWR _7626_/Y sky130_fd_sc_hd__nand2_2
X_4838_ _5004_/B _4838_/B VGND VGND VPWR VPWR _6874_/D sky130_fd_sc_hd__or2_2
XTAP_TAPCELL_ROW_23_559 VGND VPWR sky130_fd_sc_hd__tapvpwrvgnd_1
XFILLER_119_430 VGND VGND VPWR VPWR sky130_fd_sc_hd__decap_3
XFILLER_21_597 VGND VGND VPWR VPWR sky130_fd_sc_hd__decap_3
XFILLER_107_603 VGND VGND VPWR VPWR sky130_fd_sc_hd__decap_3
XFILLER_119_452 VGND VGND VPWR VPWR sky130_fd_sc_hd__decap_3
X_7557_ _6109_/A _7556_/X _6529_/A VGND VGND VPWR VPWR _7557_/X sky130_fd_sc_hd__o21a_2
Xrebuffer835 _6801_/X VGND VGND VPWR VPWR _6802_/C sky130_fd_sc_hd__buf_2
X_4769_ _8215_/Q _4769_/B VGND VGND VPWR VPWR _7372_/B sky130_fd_sc_hd__nand2_2
XFILLER_106_124 VGND VGND VPWR VPWR sky130_fd_sc_hd__fill_2
XFILLER_107_636 VGND VGND VPWR VPWR sky130_fd_sc_hd__decap_3
XFILLER_4_229 VGND VGND VPWR VPWR sky130_fd_sc_hd__decap_3
X_7488_ _7486_/Y _7490_/B _7488_/C _7490_/D VGND VGND VPWR VPWR _7488_/X sky130_fd_sc_hd__and4b_2
X_6508_ _7825_/A _6508_/B VGND VGND VPWR VPWR _6508_/X sky130_fd_sc_hd__or2_2
XFILLER_106_135 VGND VGND VPWR VPWR sky130_fd_sc_hd__decap_3
X_6439_ _8250_/Q _6411_/B _6438_/X VGND VGND VPWR VPWR _6439_/X sky130_fd_sc_hd__o21a_2
XFILLER_106_168 VGND VGND VPWR VPWR sky130_fd_sc_hd__decap_3
XFILLER_0_424 VGND VGND VPWR VPWR sky130_fd_sc_hd__decap_3
XFILLER_88_542 VGND VGND VPWR VPWR sky130_fd_sc_hd__decap_3
XFILLER_96_38 VGND VGND VPWR VPWR sky130_fd_sc_hd__fill_1
X_8109_ _8380_/CLK _8109_/D VGND VGND VPWR VPWR _8109_/Q sky130_fd_sc_hd__dfxtp_2
XFILLER_102_341 VGND VGND VPWR VPWR sky130_fd_sc_hd__decap_3
XFILLER_76_704 VGND VGND VPWR VPWR sky130_fd_sc_hd__decap_3
XFILLER_102_374 VGND VGND VPWR VPWR sky130_fd_sc_hd__decap_3
XFILLER_29_54 VGND VGND VPWR VPWR sky130_fd_sc_hd__fill_2
XFILLER_29_87 VGND VGND VPWR VPWR sky130_fd_sc_hd__decap_3
XFILLER_48_439 VGND VGND VPWR VPWR sky130_fd_sc_hd__decap_3
XFILLER_75_225 VGND VGND VPWR VPWR sky130_fd_sc_hd__decap_3
XTAP_TAPCELL_ROW_110_1691 VGND VPWR sky130_fd_sc_hd__tapvpwrvgnd_1
XFILLER_28_141 VGND VGND VPWR VPWR sky130_fd_sc_hd__fill_2
XFILLER_29_653 VGND VGND VPWR VPWR sky130_fd_sc_hd__decap_3
XFILLER_75_247 VGND VGND VPWR VPWR sky130_fd_sc_hd__decap_3
XFILLER_91_718 VGND VGND VPWR VPWR sky130_fd_sc_hd__decap_3
XFILLER_16_303 VGND VGND VPWR VPWR sky130_fd_sc_hd__decap_3
XFILLER_44_623 VGND VGND VPWR VPWR sky130_fd_sc_hd__decap_3
XFILLER_56_483 VGND VGND VPWR VPWR sky130_fd_sc_hd__decap_3
XFILLER_91_729 VGND VGND VPWR VPWR sky130_fd_sc_hd__decap_3
XTAP_TAPCELL_ROW_3_295 VGND VPWR sky130_fd_sc_hd__tapvpwrvgnd_1
XFILLER_16_336 VGND VGND VPWR VPWR sky130_fd_sc_hd__decap_3
XFILLER_43_122 VGND VGND VPWR VPWR sky130_fd_sc_hd__fill_1
XFILLER_44_645 VGND VGND VPWR VPWR sky130_fd_sc_hd__decap_3
XFILLER_71_431 VGND VGND VPWR VPWR sky130_fd_sc_hd__decap_3
XFILLER_43_144 VGND VGND VPWR VPWR sky130_fd_sc_hd__decap_3
XFILLER_71_475 VGND VGND VPWR VPWR sky130_fd_sc_hd__fill_1
XTAP_TAPCELL_ROW_42_802 VGND VPWR sky130_fd_sc_hd__tapvpwrvgnd_1
XFILLER_24_380 VGND VGND VPWR VPWR sky130_fd_sc_hd__fill_1
XFILLER_71_497 VGND VGND VPWR VPWR sky130_fd_sc_hd__decap_3
XFILLER_12_531 VGND VGND VPWR VPWR sky130_fd_sc_hd__fill_1
XFILLER_12_542 VGND VGND VPWR VPWR sky130_fd_sc_hd__decap_3
XFILLER_12_553 VGND VGND VPWR VPWR sky130_fd_sc_hd__decap_3
XFILLER_61_30 VGND VGND VPWR VPWR sky130_fd_sc_hd__decap_3
XFILLER_61_52 VGND VGND VPWR VPWR sky130_fd_sc_hd__decap_3
XTAP_TAPCELL_ROW_61_1056 VGND VPWR sky130_fd_sc_hd__tapvpwrvgnd_1
XFILLER_12_586 VGND VGND VPWR VPWR sky130_fd_sc_hd__fill_2
XFILLER_61_96 VGND VGND VPWR VPWR sky130_fd_sc_hd__decap_3
XFILLER_8_557 VGND VGND VPWR VPWR sky130_fd_sc_hd__decap_3
XFILLER_8_579 VGND VGND VPWR VPWR sky130_fd_sc_hd__decap_3
XANTENNA_7 _4017_/A VGND VGND VPWR VPWR sky130_fd_sc_hd__diode_2
XFILLER_4_730 VGND VGND VPWR VPWR sky130_fd_sc_hd__decap_3
XFILLER_113_617 VGND VGND VPWR VPWR sky130_fd_sc_hd__fill_1
XFILLER_98_328 VGND VGND VPWR VPWR sky130_fd_sc_hd__decap_3
XFILLER_3_284 VGND VGND VPWR VPWR sky130_fd_sc_hd__decap_3
XFILLER_79_520 VGND VGND VPWR VPWR sky130_fd_sc_hd__decap_3
XFILLER_105_190 VGND VGND VPWR VPWR sky130_fd_sc_hd__decap_3
XFILLER_39_417 VGND VGND VPWR VPWR sky130_fd_sc_hd__decap_3
XFILLER_94_501 VGND VGND VPWR VPWR sky130_fd_sc_hd__decap_3
XFILLER_66_203 VGND VGND VPWR VPWR sky130_fd_sc_hd__decap_3
XFILLER_66_236 VGND VGND VPWR VPWR sky130_fd_sc_hd__decap_3
XFILLER_94_545 VGND VGND VPWR VPWR sky130_fd_sc_hd__fill_2
XTAP_TAPCELL_ROW_72_1196 VGND VPWR sky130_fd_sc_hd__tapvpwrvgnd_1
XFILLER_54_409 VGND VGND VPWR VPWR sky130_fd_sc_hd__decap_3
XFILLER_82_707 VGND VGND VPWR VPWR sky130_fd_sc_hd__fill_2
XFILLER_19_152 VGND VGND VPWR VPWR sky130_fd_sc_hd__decap_3
XFILLER_35_612 VGND VGND VPWR VPWR sky130_fd_sc_hd__decap_3
XFILLER_81_206 VGND VGND VPWR VPWR sky130_fd_sc_hd__decap_3
XFILLER_81_228 VGND VGND VPWR VPWR sky130_fd_sc_hd__decap_3
XFILLER_82_729 VGND VGND VPWR VPWR sky130_fd_sc_hd__decap_3
XFILLER_19_185 VGND VGND VPWR VPWR sky130_fd_sc_hd__decap_3
XFILLER_35_645 VGND VGND VPWR VPWR sky130_fd_sc_hd__decap_3
XFILLER_62_442 VGND VGND VPWR VPWR sky130_fd_sc_hd__decap_3
XFILLER_34_144 VGND VGND VPWR VPWR sky130_fd_sc_hd__decap_3
XFILLER_35_689 VGND VGND VPWR VPWR sky130_fd_sc_hd__decap_3
XFILLER_62_475 VGND VGND VPWR VPWR sky130_fd_sc_hd__fill_1
X_6790_ _4853_/B _4849_/B _5004_/B _4851_/Y VGND VGND VPWR VPWR _6791_/B sky130_fd_sc_hd__a211o_2
X_5810_ _5897_/A _8235_/Q _6999_/A1 VGND VGND VPWR VPWR _5810_/X sky130_fd_sc_hd__o21a_2
XFILLER_15_380 VGND VGND VPWR VPWR sky130_fd_sc_hd__decap_3
XFILLER_50_626 VGND VGND VPWR VPWR sky130_fd_sc_hd__decap_3
X_5741_ _6354_/A VGND VGND VPWR VPWR _5741_/Y sky130_fd_sc_hd__inv_2
XFILLER_30_350 VGND VGND VPWR VPWR sky130_fd_sc_hd__decap_3
X_7411_ _8216_/Q _8280_/Q VGND VGND VPWR VPWR _7411_/X sky130_fd_sc_hd__and2_2
X_5672_ _6536_/A _6321_/B VGND VGND VPWR VPWR _5673_/B sky130_fd_sc_hd__nor2_2
XTAP_TAPCELL_ROW_20_518 VGND VPWR sky130_fd_sc_hd__tapvpwrvgnd_1
X_8391_ _8396_/CLK _8391_/D VGND VGND VPWR VPWR _8391_/Q sky130_fd_sc_hd__dfxtp_2
X_4623_ _4623_/A VGND VGND VPWR VPWR _8249_/D sky130_fd_sc_hd__buf_1
Xmax_cap210 _5507_/X VGND VGND VPWR VPWR _5508_/A sky130_fd_sc_hd__buf_6
X_7342_ _8277_/Q _7312_/Y _7341_/X VGND VGND VPWR VPWR _7343_/B sky130_fd_sc_hd__o21a_2
X_4554_ _7843_/A _8081_/Q VGND VGND VPWR VPWR _4555_/A sky130_fd_sc_hd__and2_2
Xmax_cap243 _8229_/Q VGND VGND VPWR VPWR _5528_/A sky130_fd_sc_hd__buf_12
Xmax_cap232 _5338_/X VGND VGND VPWR VPWR _6936_/A2 sky130_fd_sc_hd__buf_4
Xmax_cap221 _5665_/X VGND VGND VPWR VPWR _7640_/A1 sky130_fd_sc_hd__buf_6
X_7273_ _7193_/A _6132_/X _6135_/X _7272_/Y VGND VGND VPWR VPWR _7273_/X sky130_fd_sc_hd__a22o_2
XFILLER_104_617 VGND VGND VPWR VPWR sky130_fd_sc_hd__fill_1
XFILLER_104_628 VGND VGND VPWR VPWR sky130_fd_sc_hd__decap_3
XFILLER_116_477 VGND VGND VPWR VPWR sky130_fd_sc_hd__decap_3
XFILLER_116_499 VGND VGND VPWR VPWR sky130_fd_sc_hd__decap_3
Xmax_cap254 _5780_/S VGND VGND VPWR VPWR _7796_/A sky130_fd_sc_hd__buf_12
X_6224_ _6297_/A _6224_/B VGND VGND VPWR VPWR _6224_/X sky130_fd_sc_hd__or2_2
X_4485_ _4485_/A VGND VGND VPWR VPWR _8180_/D sky130_fd_sc_hd__buf_1
XFILLER_103_149 VGND VGND VPWR VPWR sky130_fd_sc_hd__decap_3
XFILLER_106_26 VGND VGND VPWR VPWR sky130_fd_sc_hd__fill_2
XFILLER_58_704 VGND VGND VPWR VPWR sky130_fd_sc_hd__decap_3
XFILLER_58_726 VGND VGND VPWR VPWR sky130_fd_sc_hd__decap_3
XFILLER_85_501 VGND VGND VPWR VPWR sky130_fd_sc_hd__decap_3
X_6155_ _8180_/Q _6149_/X _6154_/X VGND VGND VPWR VPWR _6155_/Y sky130_fd_sc_hd__o21ai_2
XFILLER_111_182 VGND VGND VPWR VPWR sky130_fd_sc_hd__decap_3
XFILLER_112_683 VGND VGND VPWR VPWR sky130_fd_sc_hd__decap_3
XFILLER_57_225 VGND VGND VPWR VPWR sky130_fd_sc_hd__decap_3
XFILLER_97_372 VGND VGND VPWR VPWR sky130_fd_sc_hd__decap_3
X_6086_ _6086_/A _6086_/B VGND VGND VPWR VPWR _6086_/Y sky130_fd_sc_hd__nor2_2
X_5106_ _7631_/C _5700_/B VGND VGND VPWR VPWR _5290_/A sky130_fd_sc_hd__nor2_2
XFILLER_57_269 VGND VGND VPWR VPWR sky130_fd_sc_hd__decap_3
XFILLER_85_545 VGND VGND VPWR VPWR sky130_fd_sc_hd__decap_3
X_5037_ _5037_/A _5037_/B VGND VGND VPWR VPWR _5037_/Y sky130_fd_sc_hd__nor2_2
XFILLER_38_450 VGND VGND VPWR VPWR sky130_fd_sc_hd__decap_3
XFILLER_72_206 VGND VGND VPWR VPWR sky130_fd_sc_hd__decap_3
XFILLER_73_729 VGND VGND VPWR VPWR sky130_fd_sc_hd__decap_3
XFILLER_85_589 VGND VGND VPWR VPWR sky130_fd_sc_hd__decap_3
XTAP_TAPCELL_ROW_28_629 VGND VPWR sky130_fd_sc_hd__tapvpwrvgnd_1
XTAP_TAPCELL_ROW_28_618 VGND VPWR sky130_fd_sc_hd__tapvpwrvgnd_1
XFILLER_25_100 VGND VGND VPWR VPWR sky130_fd_sc_hd__fill_1
XFILLER_26_645 VGND VGND VPWR VPWR sky130_fd_sc_hd__decap_3
XFILLER_53_420 VGND VGND VPWR VPWR sky130_fd_sc_hd__decap_3
XFILLER_82_29 VGND VGND VPWR VPWR sky130_fd_sc_hd__decap_3
XTAP_TAPCELL_ROW_0_243 VGND VPWR sky130_fd_sc_hd__tapvpwrvgnd_1
XTAP_TAPCELL_ROW_0_254 VGND VPWR sky130_fd_sc_hd__tapvpwrvgnd_1
XFILLER_25_155 VGND VGND VPWR VPWR sky130_fd_sc_hd__decap_3
XFILLER_53_464 VGND VGND VPWR VPWR sky130_fd_sc_hd__decap_3
XTAP_TAPCELL_ROW_0_265 VGND VPWR sky130_fd_sc_hd__tapvpwrvgnd_1
XFILLER_13_328 VGND VGND VPWR VPWR sky130_fd_sc_hd__decap_3
XFILLER_15_34 VGND VGND VPWR VPWR sky130_fd_sc_hd__decap_3
XFILLER_25_199 VGND VGND VPWR VPWR sky130_fd_sc_hd__decap_3
XFILLER_80_283 VGND VGND VPWR VPWR sky130_fd_sc_hd__decap_3
X_6988_ _8202_/Q _6988_/B _8203_/Q VGND VGND VPWR VPWR _6988_/X sky130_fd_sc_hd__or3_4
XFILLER_40_147 VGND VGND VPWR VPWR sky130_fd_sc_hd__decap_3
X_5939_ _7767_/B _5701_/A _5938_/X _8288_/Q VGND VGND VPWR VPWR _5939_/X sky130_fd_sc_hd__o22a_2
XFILLER_31_11 VGND VGND VPWR VPWR sky130_fd_sc_hd__decap_3
XFILLER_5_505 VGND VGND VPWR VPWR sky130_fd_sc_hd__decap_3
X_7609_ _7613_/B _7840_/B _7610_/B VGND VGND VPWR VPWR _7609_/Y sky130_fd_sc_hd__a21oi_2
XFILLER_119_271 VGND VGND VPWR VPWR sky130_fd_sc_hd__decap_3
XFILLER_107_455 VGND VGND VPWR VPWR sky130_fd_sc_hd__fill_1
XFILLER_31_88 VGND VGND VPWR VPWR sky130_fd_sc_hd__fill_1
XFILLER_103_3 VGND VGND VPWR VPWR sky130_fd_sc_hd__decap_3
XTAP_TAPCELL_ROW_112_1720 VGND VPWR sky130_fd_sc_hd__tapvpwrvgnd_1
XFILLER_1_722 VGND VGND VPWR VPWR sky130_fd_sc_hd__decap_3
XFILLER_110_609 VGND VGND VPWR VPWR sky130_fd_sc_hd__decap_3
XFILLER_88_361 VGND VGND VPWR VPWR sky130_fd_sc_hd__decap_3
Xinput100 operand_b[37] VGND VGND VPWR VPWR _4378_/B sky130_fd_sc_hd__clkdlybuf4s25_1
Xinput111 operand_b[47] VGND VGND VPWR VPWR _4398_/B sky130_fd_sc_hd__clkdlybuf4s25_1
XTAP_TAPCELL_ROW_8_365 VGND VPWR sky130_fd_sc_hd__tapvpwrvgnd_1
XFILLER_0_265 VGND VGND VPWR VPWR sky130_fd_sc_hd__decap_3
XFILLER_102_171 VGND VGND VPWR VPWR sky130_fd_sc_hd__decap_3
XFILLER_103_694 VGND VGND VPWR VPWR sky130_fd_sc_hd__fill_2
Xinput133 operand_b[9] VGND VGND VPWR VPWR _4322_/B sky130_fd_sc_hd__clkdlybuf4s25_1
Xinput122 operand_b[57] VGND VGND VPWR VPWR _4418_/B sky130_fd_sc_hd__clkdlybuf4s25_1
XFILLER_0_298 VGND VGND VPWR VPWR sky130_fd_sc_hd__fill_2
XFILLER_36_409 VGND VGND VPWR VPWR sky130_fd_sc_hd__decap_3
XFILLER_48_236 VGND VGND VPWR VPWR sky130_fd_sc_hd__decap_3
XFILLER_76_545 VGND VGND VPWR VPWR sky130_fd_sc_hd__decap_3
XFILLER_76_567 VGND VGND VPWR VPWR sky130_fd_sc_hd__decap_3
XFILLER_29_461 VGND VGND VPWR VPWR sky130_fd_sc_hd__decap_3
XFILLER_56_52 VGND VGND VPWR VPWR sky130_fd_sc_hd__decap_3
XFILLER_63_217 VGND VGND VPWR VPWR sky130_fd_sc_hd__decap_3
XFILLER_63_228 VGND VGND VPWR VPWR sky130_fd_sc_hd__decap_3
XFILLER_76_589 VGND VGND VPWR VPWR sky130_fd_sc_hd__decap_3
XFILLER_17_645 VGND VGND VPWR VPWR sky130_fd_sc_hd__decap_3
XFILLER_56_85 VGND VGND VPWR VPWR sky130_fd_sc_hd__decap_3
XFILLER_16_144 VGND VGND VPWR VPWR sky130_fd_sc_hd__decap_3
XFILLER_32_604 VGND VGND VPWR VPWR sky130_fd_sc_hd__decap_3
XFILLER_44_442 VGND VGND VPWR VPWR sky130_fd_sc_hd__fill_2
XFILLER_44_475 VGND VGND VPWR VPWR sky130_fd_sc_hd__fill_1
XFILLER_71_250 VGND VGND VPWR VPWR sky130_fd_sc_hd__decap_3
XTAP_TAPCELL_ROW_55_971 VGND VPWR sky130_fd_sc_hd__tapvpwrvgnd_1
XFILLER_112_80 VGND VGND VPWR VPWR sky130_fd_sc_hd__fill_1
XFILLER_16_177 VGND VGND VPWR VPWR sky130_fd_sc_hd__decap_3
XFILLER_32_648 VGND VGND VPWR VPWR sky130_fd_sc_hd__decap_3
XFILLER_31_158 VGND VGND VPWR VPWR sky130_fd_sc_hd__decap_3
XFILLER_12_350 VGND VGND VPWR VPWR sky130_fd_sc_hd__decap_3
XFILLER_31_169 VGND VGND VPWR VPWR sky130_fd_sc_hd__decap_3
XFILLER_12_394 VGND VGND VPWR VPWR sky130_fd_sc_hd__fill_2
XFILLER_8_332 VGND VGND VPWR VPWR sky130_fd_sc_hd__fill_1
XFILLER_68_6 VGND VGND VPWR VPWR sky130_fd_sc_hd__fill_2
XFILLER_8_365 VGND VGND VPWR VPWR sky130_fd_sc_hd__decap_3
XTAP_TAPCELL_ROW_74_1225 VGND VPWR sky130_fd_sc_hd__tapvpwrvgnd_1
XFILLER_113_436 VGND VGND VPWR VPWR sky130_fd_sc_hd__decap_3
XFILLER_4_582 VGND VGND VPWR VPWR sky130_fd_sc_hd__fill_2
XFILLER_98_114 VGND VGND VPWR VPWR sky130_fd_sc_hd__fill_1
XFILLER_98_136 VGND VGND VPWR VPWR sky130_fd_sc_hd__decap_3
XFILLER_98_147 VGND VGND VPWR VPWR sky130_fd_sc_hd__decap_3
X_4270_ _7898_/B _4270_/B VGND VGND VPWR VPWR _4271_/A sky130_fd_sc_hd__and2_2
XFILLER_113_469 VGND VGND VPWR VPWR sky130_fd_sc_hd__fill_2
XFILLER_86_309 VGND VGND VPWR VPWR sky130_fd_sc_hd__decap_3
XFILLER_97_70 VGND VGND VPWR VPWR sky130_fd_sc_hd__decap_3
XFILLER_79_372 VGND VGND VPWR VPWR sky130_fd_sc_hd__decap_3
XFILLER_39_258 VGND VGND VPWR VPWR sky130_fd_sc_hd__decap_3
Xsplit263 _6024_/A VGND VGND VPWR VPWR _7767_/B sky130_fd_sc_hd__buf_4
XFILLER_27_409 VGND VGND VPWR VPWR sky130_fd_sc_hd__decap_3
XFILLER_54_206 VGND VGND VPWR VPWR sky130_fd_sc_hd__decap_3
XFILLER_55_729 VGND VGND VPWR VPWR sky130_fd_sc_hd__decap_3
XFILLER_67_589 VGND VGND VPWR VPWR sky130_fd_sc_hd__decap_3
X_7960_ _8387_/CLK _7960_/D VGND VGND VPWR VPWR _7960_/Q sky130_fd_sc_hd__dfxtp_2
X_7891_ _7891_/A VGND VGND VPWR VPWR _8382_/D sky130_fd_sc_hd__buf_1
X_6911_ _8264_/Q _6885_/B _6903_/S VGND VGND VPWR VPWR _6911_/X sky130_fd_sc_hd__a21o_2
XFILLER_23_604 VGND VGND VPWR VPWR sky130_fd_sc_hd__fill_2
XFILLER_23_615 VGND VGND VPWR VPWR sky130_fd_sc_hd__fill_1
X_6842_ _7182_/B _6828_/Y _6836_/X _6841_/X VGND VGND VPWR VPWR _6842_/X sky130_fd_sc_hd__a211o_2
XTAP_TAPCELL_ROW_85_1365 VGND VPWR sky130_fd_sc_hd__tapvpwrvgnd_1
XFILLER_22_103 VGND VGND VPWR VPWR sky130_fd_sc_hd__decap_3
XFILLER_23_626 VGND VGND VPWR VPWR sky130_fd_sc_hd__decap_3
XFILLER_62_283 VGND VGND VPWR VPWR sky130_fd_sc_hd__decap_3
XFILLER_90_592 VGND VGND VPWR VPWR sky130_fd_sc_hd__decap_3
XFILLER_50_445 VGND VGND VPWR VPWR sky130_fd_sc_hd__decap_3
X_6773_ _7067_/A _6853_/B VGND VGND VPWR VPWR _6773_/X sky130_fd_sc_hd__or2_2
X_3985_ _3985_/A VGND VGND VPWR VPWR _7941_/D sky130_fd_sc_hd__buf_1
XFILLER_10_309 VGND VGND VPWR VPWR sky130_fd_sc_hd__decap_3
X_5724_ _8169_/Q _8233_/Q VGND VGND VPWR VPWR _5724_/X sky130_fd_sc_hd__or2_4
XTAP_TAPCELL_ROW_33_687 VGND VPWR sky130_fd_sc_hd__tapvpwrvgnd_1
X_5655_ _8230_/Q _5651_/Y _5656_/C _5656_/D _5654_/X VGND VGND VPWR VPWR _5655_/X
+ sky130_fd_sc_hd__a41o_2
X_8374_ _8384_/CLK _8374_/D VGND VGND VPWR VPWR _8374_/Q sky130_fd_sc_hd__dfxtp_2
X_4606_ _7898_/B _8107_/Q VGND VGND VPWR VPWR _4607_/A sky130_fd_sc_hd__and2_2
XFILLER_7_90 VGND VGND VPWR VPWR sky130_fd_sc_hd__fill_1
XPHY_EDGE_ROW_107_Left_227 VGND VGND VPWR VPWR sky130_fd_sc_hd__decap_3
X_7325_ _8277_/Q _5296_/A _5492_/Y _7319_/A _7453_/A VGND VGND VPWR VPWR _7325_/X
+ sky130_fd_sc_hd__a221o_2
X_5586_ _6763_/A _6686_/A VGND VGND VPWR VPWR _5587_/A sky130_fd_sc_hd__nor2_2
XFILLER_104_403 VGND VGND VPWR VPWR sky130_fd_sc_hd__decap_3
XFILLER_117_36 VGND VGND VPWR VPWR sky130_fd_sc_hd__decap_3
X_4537_ _4537_/A VGND VGND VPWR VPWR _8206_/D sky130_fd_sc_hd__buf_1
XFILLER_104_436 VGND VGND VPWR VPWR sky130_fd_sc_hd__fill_2
XFILLER_89_125 VGND VGND VPWR VPWR sky130_fd_sc_hd__decap_3
X_7256_ _7254_/Y _7255_/X _7640_/A1 VGND VGND VPWR VPWR _7256_/X sky130_fd_sc_hd__o21a_2
X_4468_ _7898_/B _8038_/Q VGND VGND VPWR VPWR _4469_/A sky130_fd_sc_hd__and2_2
XFILLER_89_158 VGND VGND VPWR VPWR sky130_fd_sc_hd__decap_3
XFILLER_89_169 VGND VGND VPWR VPWR sky130_fd_sc_hd__decap_3
X_7187_ _7619_/A _7195_/A _7186_/X _5600_/A _4781_/A VGND VGND VPWR VPWR _7187_/X
+ sky130_fd_sc_hd__o32a_2
X_6207_ _7298_/S0 _6206_/X _6009_/Y VGND VGND VPWR VPWR _6207_/X sky130_fd_sc_hd__a21bo_2
XFILLER_112_480 VGND VGND VPWR VPWR sky130_fd_sc_hd__decap_3
XFILLER_58_523 VGND VGND VPWR VPWR sky130_fd_sc_hd__decap_3
XFILLER_98_692 VGND VGND VPWR VPWR sky130_fd_sc_hd__decap_3
X_6138_ _5037_/B _6138_/B _6138_/C VGND VGND VPWR VPWR _6138_/X sky130_fd_sc_hd__and3b_2
X_4399_ _4399_/A VGND VGND VPWR VPWR _8137_/D sky130_fd_sc_hd__buf_1
XTAP_TAPCELL_ROW_5_324 VGND VPWR sky130_fd_sc_hd__tapvpwrvgnd_1
XFILLER_100_631 VGND VGND VPWR VPWR sky130_fd_sc_hd__decap_3
XFILLER_85_320 VGND VGND VPWR VPWR sky130_fd_sc_hd__fill_2
XFILLER_85_331 VGND VGND VPWR VPWR sky130_fd_sc_hd__decap_3
XFILLER_45_217 VGND VGND VPWR VPWR sky130_fd_sc_hd__decap_3
XFILLER_58_578 VGND VGND VPWR VPWR sky130_fd_sc_hd__decap_3
XFILLER_58_589 VGND VGND VPWR VPWR sky130_fd_sc_hd__decap_3
XFILLER_85_386 VGND VGND VPWR VPWR sky130_fd_sc_hd__decap_3
XFILLER_93_17 VGND VGND VPWR VPWR sky130_fd_sc_hd__decap_3
XPHY_EDGE_ROW_116_Left_236 VGND VGND VPWR VPWR sky130_fd_sc_hd__decap_3
X_6069_ _6067_/Y _6068_/X _7135_/B VGND VGND VPWR VPWR _6072_/A sky130_fd_sc_hd__a21o_2
XFILLER_26_11 VGND VGND VPWR VPWR sky130_fd_sc_hd__decap_3
XFILLER_73_559 VGND VGND VPWR VPWR sky130_fd_sc_hd__fill_1
XFILLER_14_604 VGND VGND VPWR VPWR sky130_fd_sc_hd__decap_3
XFILLER_26_442 VGND VGND VPWR VPWR sky130_fd_sc_hd__decap_3
XFILLER_60_209 VGND VGND VPWR VPWR sky130_fd_sc_hd__decap_3
XFILLER_14_648 VGND VGND VPWR VPWR sky130_fd_sc_hd__fill_1
XFILLER_26_88 VGND VGND VPWR VPWR sky130_fd_sc_hd__decap_3
XFILLER_81_570 VGND VGND VPWR VPWR sky130_fd_sc_hd__decap_3
XTAP_TAPCELL_ROW_52_930 VGND VPWR sky130_fd_sc_hd__tapvpwrvgnd_1
XFILLER_13_158 VGND VGND VPWR VPWR sky130_fd_sc_hd__decap_3
XFILLER_41_445 VGND VGND VPWR VPWR sky130_fd_sc_hd__decap_3
XFILLER_53_294 VGND VGND VPWR VPWR sky130_fd_sc_hd__decap_3
XTAP_TAPCELL_ROW_52_941 VGND VPWR sky130_fd_sc_hd__tapvpwrvgnd_1
XFILLER_13_169 VGND VGND VPWR VPWR sky130_fd_sc_hd__decap_3
XFILLER_41_489 VGND VGND VPWR VPWR sky130_fd_sc_hd__fill_1
XFILLER_42_32 VGND VGND VPWR VPWR sky130_fd_sc_hd__decap_3
XFILLER_21_191 VGND VGND VPWR VPWR sky130_fd_sc_hd__decap_3
Xrebuffer440 _6968_/Y VGND VGND VPWR VPWR _6994_/A2 sky130_fd_sc_hd__buf_2
XFILLER_5_346 VGND VGND VPWR VPWR sky130_fd_sc_hd__fill_2
Xrebuffer451 _8189_/Q VGND VGND VPWR VPWR _6596_/A1 sky130_fd_sc_hd__buf_2
XFILLER_107_241 VGND VGND VPWR VPWR sky130_fd_sc_hd__decap_3
XFILLER_5_368 VGND VGND VPWR VPWR sky130_fd_sc_hd__decap_3
XFILLER_107_274 VGND VGND VPWR VPWR sky130_fd_sc_hd__decap_3
XFILLER_110_406 VGND VGND VPWR VPWR sky130_fd_sc_hd__decap_3
XFILLER_3_15 VGND VGND VPWR VPWR sky130_fd_sc_hd__decap_3
XFILLER_68_309 VGND VGND VPWR VPWR sky130_fd_sc_hd__decap_3
XFILLER_96_618 VGND VGND VPWR VPWR sky130_fd_sc_hd__decap_3
XFILLER_110_439 VGND VGND VPWR VPWR sky130_fd_sc_hd__decap_3
XFILLER_76_342 VGND VGND VPWR VPWR sky130_fd_sc_hd__decap_3
XFILLER_88_180 VGND VGND VPWR VPWR sky130_fd_sc_hd__decap_3
XFILLER_37_729 VGND VGND VPWR VPWR sky130_fd_sc_hd__decap_3
XFILLER_64_515 VGND VGND VPWR VPWR sky130_fd_sc_hd__decap_3
XFILLER_76_386 VGND VGND VPWR VPWR sky130_fd_sc_hd__decap_3
XFILLER_91_312 VGND VGND VPWR VPWR sky130_fd_sc_hd__decap_3
XFILLER_17_431 VGND VGND VPWR VPWR sky130_fd_sc_hd__decap_3
XFILLER_29_291 VGND VGND VPWR VPWR sky130_fd_sc_hd__decap_3
XFILLER_64_548 VGND VGND VPWR VPWR sky130_fd_sc_hd__decap_3
XFILLER_17_464 VGND VGND VPWR VPWR sky130_fd_sc_hd__decap_3
XFILLER_83_50 VGND VGND VPWR VPWR sky130_fd_sc_hd__decap_3
XFILLER_91_378 VGND VGND VPWR VPWR sky130_fd_sc_hd__decap_3
XFILLER_83_72 VGND VGND VPWR VPWR sky130_fd_sc_hd__decap_3
XFILLER_20_607 VGND VGND VPWR VPWR sky130_fd_sc_hd__decap_3
XFILLER_13_670 VGND VGND VPWR VPWR sky130_fd_sc_hd__fill_2
XTAP_TAPCELL_ROW_80_1295 VGND VPWR sky130_fd_sc_hd__tapvpwrvgnd_1
XTAP_TAPCELL_ROW_30_646 VGND VPWR sky130_fd_sc_hd__tapvpwrvgnd_1
XFILLER_9_696 VGND VGND VPWR VPWR sky130_fd_sc_hd__decap_3
X_5440_ _6421_/S _5364_/Y _5439_/X _5854_/B VGND VGND VPWR VPWR _5440_/X sky130_fd_sc_hd__a31o_2
XTAP_TAPCELL_ROW_10_392 VGND VPWR sky130_fd_sc_hd__tapvpwrvgnd_1
X_5371_ _6130_/A _5371_/B VGND VGND VPWR VPWR _5371_/Y sky130_fd_sc_hd__nand2_2
XFILLER_99_423 VGND VGND VPWR VPWR sky130_fd_sc_hd__decap_3
XFILLER_99_434 VGND VGND VPWR VPWR sky130_fd_sc_hd__decap_3
X_8090_ _8224_/CLK _8090_/D VGND VGND VPWR VPWR _8090_/Q sky130_fd_sc_hd__dfxtp_2
X_7110_ _8206_/Q _7101_/X _7103_/Y _6624_/A _7109_/X VGND VGND VPWR VPWR _7110_/X
+ sky130_fd_sc_hd__a221o_2
X_4322_ _7898_/B _4322_/B VGND VGND VPWR VPWR _4323_/A sky130_fd_sc_hd__and2_2
XFILLER_4_390 VGND VGND VPWR VPWR sky130_fd_sc_hd__decap_3
XFILLER_99_478 VGND VGND VPWR VPWR sky130_fd_sc_hd__decap_3
X_7041_ _5528_/A _5919_/Y _7040_/Y _5915_/X VGND VGND VPWR VPWR _7041_/X sky130_fd_sc_hd__a22o_2
X_4253_ _4253_/A VGND VGND VPWR VPWR _8064_/D sky130_fd_sc_hd__buf_1
XFILLER_67_331 VGND VGND VPWR VPWR sky130_fd_sc_hd__decap_3
XFILLER_95_651 VGND VGND VPWR VPWR sky130_fd_sc_hd__decap_3
X_4184_ _7898_/B _4184_/B VGND VGND VPWR VPWR _4185_/A sky130_fd_sc_hd__and2_2
XFILLER_27_206 VGND VGND VPWR VPWR sky130_fd_sc_hd__decap_3
XFILLER_55_526 VGND VGND VPWR VPWR sky130_fd_sc_hd__decap_3
XFILLER_67_364 VGND VGND VPWR VPWR sky130_fd_sc_hd__decap_3
XFILLER_82_301 VGND VGND VPWR VPWR sky130_fd_sc_hd__decap_3
XFILLER_94_150 VGND VGND VPWR VPWR sky130_fd_sc_hd__fill_2
XFILLER_95_673 VGND VGND VPWR VPWR sky130_fd_sc_hd__decap_3
XFILLER_103_16 VGND VGND VPWR VPWR sky130_fd_sc_hd__decap_3
XFILLER_27_228 VGND VGND VPWR VPWR sky130_fd_sc_hd__decap_3
XFILLER_82_312 VGND VGND VPWR VPWR sky130_fd_sc_hd__decap_3
XFILLER_94_183 VGND VGND VPWR VPWR sky130_fd_sc_hd__decap_3
X_7943_ _8352_/CLK _7943_/D VGND VGND VPWR VPWR _7943_/Q sky130_fd_sc_hd__dfxtp_2
XFILLER_42_209 VGND VGND VPWR VPWR sky130_fd_sc_hd__decap_3
XTAP_TAPCELL_ROW_38_757 VGND VPWR sky130_fd_sc_hd__tapvpwrvgnd_1
XFILLER_35_272 VGND VGND VPWR VPWR sky130_fd_sc_hd__decap_3
XFILLER_51_710 VGND VGND VPWR VPWR sky130_fd_sc_hd__fill_1
XFILLER_51_732 VGND VGND VPWR VPWR sky130_fd_sc_hd__fill_1
XFILLER_70_529 VGND VGND VPWR VPWR sky130_fd_sc_hd__decap_3
XFILLER_82_389 VGND VGND VPWR VPWR sky130_fd_sc_hd__decap_3
X_7874_ _8307_/Q _7930_/B VGND VGND VPWR VPWR _7875_/A sky130_fd_sc_hd__and2_2
XFILLER_23_445 VGND VGND VPWR VPWR sky130_fd_sc_hd__decap_3
XFILLER_50_231 VGND VGND VPWR VPWR sky130_fd_sc_hd__decap_3
X_6825_ _6825_/A _6825_/B _6825_/C _6825_/D VGND VGND VPWR VPWR _6826_/A sky130_fd_sc_hd__or4_4
XTAP_TAPCELL_ROW_18_492 VGND VPWR sky130_fd_sc_hd__tapvpwrvgnd_1
XFILLER_50_253 VGND VGND VPWR VPWR sky130_fd_sc_hd__decap_3
X_6756_ _6717_/X _6718_/X _5614_/X _6944_/A _8195_/Q _8196_/Q VGND VGND VPWR VPWR
+ _6757_/B sky130_fd_sc_hd__mux4_2
X_3968_ _8337_/Q _7930_/B VGND VGND VPWR VPWR _3969_/A sky130_fd_sc_hd__and2_2
X_5707_ _8231_/Q _5664_/X _7809_/A1 VGND VGND VPWR VPWR _5707_/X sky130_fd_sc_hd__a21o_2
XFILLER_109_517 VGND VGND VPWR VPWR sky130_fd_sc_hd__decap_3
X_6687_ _6687_/A VGND VGND VPWR VPWR _6687_/X sky130_fd_sc_hd__buf_1
XTAP_TAPCELL_ROW_98_1534 VGND VPWR sky130_fd_sc_hd__tapvpwrvgnd_1
XFILLER_12_79 VGND VGND VPWR VPWR sky130_fd_sc_hd__decap_3
X_5638_ _5266_/X _5246_/X _5247_/X _5248_/X _7783_/A _5684_/S VGND VGND VPWR VPWR
+ _5638_/X sky130_fd_sc_hd__mux4_2
XFILLER_117_550 VGND VGND VPWR VPWR sky130_fd_sc_hd__fill_1
XFILLER_117_561 VGND VGND VPWR VPWR sky130_fd_sc_hd__decap_3
X_8357_ _8401_/CLK _8357_/D VGND VGND VPWR VPWR _8357_/Q sky130_fd_sc_hd__dfxtp_2
X_5569_ _5380_/X _5353_/X _5596_/S VGND VGND VPWR VPWR _5569_/X sky130_fd_sc_hd__mux2_2
XFILLER_104_200 VGND VGND VPWR VPWR sky130_fd_sc_hd__decap_3
X_7308_ _7308_/A _8213_/Q VGND VGND VPWR VPWR _7425_/C sky130_fd_sc_hd__or2_4
XFILLER_104_233 VGND VGND VPWR VPWR sky130_fd_sc_hd__decap_3
XFILLER_78_607 VGND VGND VPWR VPWR sky130_fd_sc_hd__fill_1
X_8288_ clkload6/A _8288_/D VGND VGND VPWR VPWR _8288_/Q sky130_fd_sc_hd__dfxtp_4
XFILLER_104_277 VGND VGND VPWR VPWR sky130_fd_sc_hd__fill_1
XFILLER_77_128 VGND VGND VPWR VPWR sky130_fd_sc_hd__decap_3
X_7239_ _8210_/Q _8209_/Q _7796_/A VGND VGND VPWR VPWR _7239_/X sky130_fd_sc_hd__mux2_2
XFILLER_86_651 VGND VGND VPWR VPWR sky130_fd_sc_hd__decap_3
XFILLER_19_729 VGND VGND VPWR VPWR sky130_fd_sc_hd__decap_3
XFILLER_37_21 VGND VGND VPWR VPWR sky130_fd_sc_hd__decap_3
XFILLER_85_161 VGND VGND VPWR VPWR sky130_fd_sc_hd__decap_3
XFILLER_18_228 VGND VGND VPWR VPWR sky130_fd_sc_hd__fill_1
XFILLER_37_54 VGND VGND VPWR VPWR sky130_fd_sc_hd__fill_2
XFILLER_58_386 VGND VGND VPWR VPWR sky130_fd_sc_hd__decap_3
XFILLER_73_312 VGND VGND VPWR VPWR sky130_fd_sc_hd__decap_3
XTAP_TAPCELL_ROW_107_1652 VGND VPWR sky130_fd_sc_hd__tapvpwrvgnd_1
XFILLER_73_389 VGND VGND VPWR VPWR sky130_fd_sc_hd__decap_3
XFILLER_26_283 VGND VGND VPWR VPWR sky130_fd_sc_hd__decap_3
XFILLER_41_231 VGND VGND VPWR VPWR sky130_fd_sc_hd__fill_1
XFILLER_54_592 VGND VGND VPWR VPWR sky130_fd_sc_hd__fill_2
XFILLER_41_253 VGND VGND VPWR VPWR sky130_fd_sc_hd__decap_3
XFILLER_53_75 VGND VGND VPWR VPWR sky130_fd_sc_hd__decap_3
XFILLER_10_662 VGND VGND VPWR VPWR sky130_fd_sc_hd__fill_2
XFILLER_10_684 VGND VGND VPWR VPWR sky130_fd_sc_hd__fill_2
XFILLER_10_695 VGND VGND VPWR VPWR sky130_fd_sc_hd__decap_3
XFILLER_5_143 VGND VGND VPWR VPWR sky130_fd_sc_hd__decap_3
XFILLER_5_154 VGND VGND VPWR VPWR sky130_fd_sc_hd__decap_3
Xrebuffer292 _7129_/C VGND VGND VPWR VPWR _7070_/B sky130_fd_sc_hd__buf_2
XTAP_TAPCELL_ROW_58_1017 VGND VPWR sky130_fd_sc_hd__tapvpwrvgnd_1
XFILLER_5_176 VGND VGND VPWR VPWR sky130_fd_sc_hd__decap_3
XTAP_TAPCELL_ROW_118_1792 VGND VPWR sky130_fd_sc_hd__tapvpwrvgnd_1
XFILLER_110_203 VGND VGND VPWR VPWR sky130_fd_sc_hd__decap_3
XFILLER_68_106 VGND VGND VPWR VPWR sky130_fd_sc_hd__decap_3
XFILLER_78_83 VGND VGND VPWR VPWR sky130_fd_sc_hd__fill_1
XFILLER_78_94 VGND VGND VPWR VPWR sky130_fd_sc_hd__decap_3
XFILLER_1_382 VGND VGND VPWR VPWR sky130_fd_sc_hd__decap_3
XFILLER_1_393 VGND VGND VPWR VPWR sky130_fd_sc_hd__fill_2
XFILLER_96_448 VGND VGND VPWR VPWR sky130_fd_sc_hd__decap_3
XFILLER_49_364 VGND VGND VPWR VPWR sky130_fd_sc_hd__decap_3
XFILLER_76_150 VGND VGND VPWR VPWR sky130_fd_sc_hd__decap_3
XFILLER_83_109 VGND VGND VPWR VPWR sky130_fd_sc_hd__decap_3
XFILLER_64_312 VGND VGND VPWR VPWR sky130_fd_sc_hd__decap_3
XFILLER_24_209 VGND VGND VPWR VPWR sky130_fd_sc_hd__decap_3
XFILLER_64_345 VGND VGND VPWR VPWR sky130_fd_sc_hd__decap_3
XFILLER_91_131 VGND VGND VPWR VPWR sky130_fd_sc_hd__decap_3
XFILLER_91_153 VGND VGND VPWR VPWR sky130_fd_sc_hd__decap_3
XFILLER_92_665 VGND VGND VPWR VPWR sky130_fd_sc_hd__fill_1
XTAP_TAPCELL_ROW_69_1157 VGND VPWR sky130_fd_sc_hd__tapvpwrvgnd_1
XFILLER_17_272 VGND VGND VPWR VPWR sky130_fd_sc_hd__decap_3
XFILLER_45_570 VGND VGND VPWR VPWR sky130_fd_sc_hd__decap_3
XFILLER_92_698 VGND VGND VPWR VPWR sky130_fd_sc_hd__fill_2
X_4940_ _5867_/A _5867_/B _5867_/C _5868_/A VGND VGND VPWR VPWR _4941_/B sky130_fd_sc_hd__or4_2
XTAP_TAPCELL_ROW_35_716 VGND VPWR sky130_fd_sc_hd__tapvpwrvgnd_1
XFILLER_33_732 VGND VGND VPWR VPWR sky130_fd_sc_hd__fill_1
X_4871_ _8184_/Q _8248_/Q VGND VGND VPWR VPWR _4873_/A sky130_fd_sc_hd__or2b_2
XTAP_TAPCELL_ROW_82_1324 VGND VPWR sky130_fd_sc_hd__tapvpwrvgnd_1
XFILLER_32_264 VGND VGND VPWR VPWR sky130_fd_sc_hd__decap_3
XTAP_TAPCELL_ROW_15_451 VGND VPWR sky130_fd_sc_hd__tapvpwrvgnd_1
X_7590_ _7590_/A VGND VGND VPWR VPWR _7590_/Y sky130_fd_sc_hd__inv_2
X_6610_ _6610_/A _6610_/B VGND VGND VPWR VPWR _6610_/Y sky130_fd_sc_hd__xnor2_2
XFILLER_20_448 VGND VGND VPWR VPWR sky130_fd_sc_hd__fill_2
X_6541_ _8190_/Q _8254_/Q _6086_/A VGND VGND VPWR VPWR _6541_/Y sky130_fd_sc_hd__a21oi_2
X_6472_ _8187_/Q _8251_/Q VGND VGND VPWR VPWR _6472_/X sky130_fd_sc_hd__or2b_2
X_8211_ _8228_/CLK _8211_/D VGND VGND VPWR VPWR _8211_/Q sky130_fd_sc_hd__dfxtp_2
Xoutput201 _7966_/Q VGND VGND VPWR VPWR result[8] sky130_fd_sc_hd__clkdlybuf4s25_1
X_5423_ _7562_/A _5412_/B _7560_/A VGND VGND VPWR VPWR _5423_/X sky130_fd_sc_hd__a21o_2
X_8142_ _8280_/CLK _8142_/D VGND VGND VPWR VPWR _8142_/Q sky130_fd_sc_hd__dfxtp_2
X_5354_ _5153_/X _5148_/X _5384_/S VGND VGND VPWR VPWR _5354_/X sky130_fd_sc_hd__mux2_2
XFILLER_114_531 VGND VGND VPWR VPWR sky130_fd_sc_hd__fill_1
XFILLER_99_242 VGND VGND VPWR VPWR sky130_fd_sc_hd__decap_3
X_4305_ _4305_/A VGND VGND VPWR VPWR _8090_/D sky130_fd_sc_hd__buf_1
XTAP_TAPCELL_ROW_93_1464 VGND VPWR sky130_fd_sc_hd__tapvpwrvgnd_1
XFILLER_114_575 VGND VGND VPWR VPWR sky130_fd_sc_hd__fill_2
XFILLER_99_275 VGND VGND VPWR VPWR sky130_fd_sc_hd__fill_1
X_8073_ _8207_/CLK _8073_/D VGND VGND VPWR VPWR _8073_/Q sky130_fd_sc_hd__dfxtp_2
X_5285_ _5585_/A _5279_/X _5281_/X _5283_/X _5284_/X VGND VGND VPWR VPWR _5285_/X
+ sky130_fd_sc_hd__a32o_2
XFILLER_101_225 VGND VGND VPWR VPWR sky130_fd_sc_hd__decap_3
XFILLER_114_15 VGND VGND VPWR VPWR sky130_fd_sc_hd__decap_3
XFILLER_4_91 VGND VGND VPWR VPWR sky130_fd_sc_hd__decap_3
XFILLER_59_139 VGND VGND VPWR VPWR sky130_fd_sc_hd__decap_3
X_7024_ _7024_/A _7024_/B _7024_/C _7023_/X VGND VGND VPWR VPWR _7024_/X sky130_fd_sc_hd__or4b_4
X_4236_ _7898_/B _4236_/B VGND VGND VPWR VPWR _4237_/A sky130_fd_sc_hd__and2_2
XFILLER_101_258 VGND VGND VPWR VPWR sky130_fd_sc_hd__decap_3
XFILLER_28_504 VGND VGND VPWR VPWR sky130_fd_sc_hd__decap_3
XFILLER_83_610 VGND VGND VPWR VPWR sky130_fd_sc_hd__fill_1
X_4167_ _4167_/A VGND VGND VPWR VPWR _8021_/D sky130_fd_sc_hd__buf_1
XFILLER_55_334 VGND VGND VPWR VPWR sky130_fd_sc_hd__fill_2
XFILLER_67_183 VGND VGND VPWR VPWR sky130_fd_sc_hd__decap_3
XFILLER_67_194 VGND VGND VPWR VPWR sky130_fd_sc_hd__decap_3
XFILLER_82_120 VGND VGND VPWR VPWR sky130_fd_sc_hd__fill_1
XFILLER_83_643 VGND VGND VPWR VPWR sky130_fd_sc_hd__decap_3
XFILLER_82_153 VGND VGND VPWR VPWR sky130_fd_sc_hd__decap_3
XFILLER_83_676 VGND VGND VPWR VPWR sky130_fd_sc_hd__fill_1
X_4098_ _7930_/B _8390_/Q VGND VGND VPWR VPWR _4099_/A sky130_fd_sc_hd__and2_2
XFILLER_70_315 VGND VGND VPWR VPWR sky130_fd_sc_hd__decap_3
X_7926_ _8333_/Q _7930_/B VGND VGND VPWR VPWR _7927_/A sky130_fd_sc_hd__and2_2
XFILLER_23_231 VGND VGND VPWR VPWR sky130_fd_sc_hd__fill_1
XFILLER_36_592 VGND VGND VPWR VPWR sky130_fd_sc_hd__decap_3
XFILLER_82_197 VGND VGND VPWR VPWR sky130_fd_sc_hd__decap_3
X_7857_ _7857_/A VGND VGND VPWR VPWR _8365_/D sky130_fd_sc_hd__buf_1
XFILLER_23_253 VGND VGND VPWR VPWR sky130_fd_sc_hd__decap_3
XFILLER_90_29 VGND VGND VPWR VPWR sky130_fd_sc_hd__decap_3
X_6808_ _8261_/Q _6807_/B _8197_/Q VGND VGND VPWR VPWR _6848_/D sky130_fd_sc_hd__o21ai_2
XTAP_TAPCELL_ROW_102_1582 VGND VPWR sky130_fd_sc_hd__tapvpwrvgnd_1
X_7788_ _7796_/A _8194_/Q _7747_/A _7670_/A VGND VGND VPWR VPWR _7788_/Y sky130_fd_sc_hd__a211oi_2
XFILLER_7_419 VGND VGND VPWR VPWR sky130_fd_sc_hd__decap_3
X_6739_ _6874_/D _6739_/B VGND VGND VPWR VPWR _6739_/Y sky130_fd_sc_hd__xnor2_2
XFILLER_23_89 VGND VGND VPWR VPWR sky130_fd_sc_hd__decap_3
XFILLER_99_38 VGND VGND VPWR VPWR sky130_fd_sc_hd__decap_3
XFILLER_105_542 VGND VGND VPWR VPWR sky130_fd_sc_hd__decap_3
XFILLER_2_124 VGND VGND VPWR VPWR sky130_fd_sc_hd__decap_3
XFILLER_105_564 VGND VGND VPWR VPWR sky130_fd_sc_hd__decap_3
XFILLER_105_586 VGND VGND VPWR VPWR sky130_fd_sc_hd__decap_3
XFILLER_78_404 VGND VGND VPWR VPWR sky130_fd_sc_hd__decap_3
XFILLER_48_20 VGND VGND VPWR VPWR sky130_fd_sc_hd__decap_3
XFILLER_78_448 VGND VGND VPWR VPWR sky130_fd_sc_hd__decap_3
XFILLER_59_662 VGND VGND VPWR VPWR sky130_fd_sc_hd__decap_3
XFILLER_59_673 VGND VGND VPWR VPWR sky130_fd_sc_hd__decap_3
XFILLER_100_280 VGND VGND VPWR VPWR sky130_fd_sc_hd__decap_3
XFILLER_46_312 VGND VGND VPWR VPWR sky130_fd_sc_hd__decap_3
XFILLER_74_643 VGND VGND VPWR VPWR sky130_fd_sc_hd__fill_1
XFILLER_0_27 VGND VGND VPWR VPWR sky130_fd_sc_hd__fill_1
XFILLER_0_38 VGND VGND VPWR VPWR sky130_fd_sc_hd__decap_3
XFILLER_73_131 VGND VGND VPWR VPWR sky130_fd_sc_hd__decap_3
XFILLER_74_654 VGND VGND VPWR VPWR sky130_fd_sc_hd__decap_3
XFILLER_27_570 VGND VGND VPWR VPWR sky130_fd_sc_hd__decap_3
XFILLER_61_304 VGND VGND VPWR VPWR sky130_fd_sc_hd__decap_3
XFILLER_64_41 VGND VGND VPWR VPWR sky130_fd_sc_hd__decap_3
XFILLER_73_164 VGND VGND VPWR VPWR sky130_fd_sc_hd__decap_3
XFILLER_14_231 VGND VGND VPWR VPWR sky130_fd_sc_hd__decap_3
XFILLER_15_732 VGND VGND VPWR VPWR sky130_fd_sc_hd__fill_1
XFILLER_42_540 VGND VGND VPWR VPWR sky130_fd_sc_hd__decap_3
XFILLER_61_337 VGND VGND VPWR VPWR sky130_fd_sc_hd__decap_3
XFILLER_64_85 VGND VGND VPWR VPWR sky130_fd_sc_hd__decap_3
XFILLER_14_253 VGND VGND VPWR VPWR sky130_fd_sc_hd__decap_3
XTAP_TAPCELL_ROW_12_410 VGND VPWR sky130_fd_sc_hd__tapvpwrvgnd_1
XTAP_TAPCELL_ROW_64_1087 VGND VPWR sky130_fd_sc_hd__tapvpwrvgnd_1
XFILLER_80_73 VGND VGND VPWR VPWR sky130_fd_sc_hd__fill_2
XTAP_TAPCELL_ROW_12_421 VGND VPWR sky130_fd_sc_hd__tapvpwrvgnd_1
XFILLER_10_470 VGND VGND VPWR VPWR sky130_fd_sc_hd__decap_3
XTAP_TAPCELL_ROW_40_785 VGND VPWR sky130_fd_sc_hd__tapvpwrvgnd_1
XTAP_TAPCELL_ROW_40_774 VGND VPWR sky130_fd_sc_hd__tapvpwrvgnd_1
XFILLER_115_306 VGND VGND VPWR VPWR sky130_fd_sc_hd__decap_3
XFILLER_89_93 VGND VGND VPWR VPWR sky130_fd_sc_hd__decap_3
XFILLER_69_415 VGND VGND VPWR VPWR sky130_fd_sc_hd__decap_3
XFILLER_96_212 VGND VGND VPWR VPWR sky130_fd_sc_hd__decap_3
XFILLER_96_245 VGND VGND VPWR VPWR sky130_fd_sc_hd__decap_3
X_5070_ _4973_/Y _4985_/Y _4996_/Y _4997_/Y _5069_/Y VGND VGND VPWR VPWR _5071_/A
+ sky130_fd_sc_hd__a221o_2
XFILLER_29_3 VGND VGND VPWR VPWR sky130_fd_sc_hd__decap_3
XFILLER_49_150 VGND VGND VPWR VPWR sky130_fd_sc_hd__decap_3
XFILLER_56_109 VGND VGND VPWR VPWR sky130_fd_sc_hd__decap_3
XFILLER_96_256 VGND VGND VPWR VPWR sky130_fd_sc_hd__decap_3
X_4021_ _8356_/Q _4719_/A _4021_/C _4021_/D VGND VGND VPWR VPWR _4032_/B sky130_fd_sc_hd__or4_2
XFILLER_37_312 VGND VGND VPWR VPWR sky130_fd_sc_hd__decap_3
XFILLER_49_172 VGND VGND VPWR VPWR sky130_fd_sc_hd__decap_3
XFILLER_77_492 VGND VGND VPWR VPWR sky130_fd_sc_hd__decap_3
XFILLER_37_345 VGND VGND VPWR VPWR sky130_fd_sc_hd__decap_3
XFILLER_64_131 VGND VGND VPWR VPWR sky130_fd_sc_hd__decap_3
XFILLER_65_676 VGND VGND VPWR VPWR sky130_fd_sc_hd__fill_2
XFILLER_25_529 VGND VGND VPWR VPWR sky130_fd_sc_hd__decap_3
XFILLER_52_315 VGND VGND VPWR VPWR sky130_fd_sc_hd__decap_3
XFILLER_64_153 VGND VGND VPWR VPWR sky130_fd_sc_hd__decap_3
X_5972_ _8239_/Q _5337_/X _6936_/A2 VGND VGND VPWR VPWR _5972_/Y sky130_fd_sc_hd__o21ai_2
XTAP_TAPCELL_ROW_48_885 VGND VPWR sky130_fd_sc_hd__tapvpwrvgnd_1
XFILLER_18_592 VGND VGND VPWR VPWR sky130_fd_sc_hd__decap_3
XFILLER_52_359 VGND VGND VPWR VPWR sky130_fd_sc_hd__decap_3
XFILLER_64_197 VGND VGND VPWR VPWR sky130_fd_sc_hd__decap_3
XFILLER_80_657 VGND VGND VPWR VPWR sky130_fd_sc_hd__decap_3
X_7711_ _8215_/Q _7672_/X _7681_/X VGND VGND VPWR VPWR _7711_/Y sky130_fd_sc_hd__o21ai_2
X_4923_ _8239_/Q _6024_/B VGND VGND VPWR VPWR _4923_/X sky130_fd_sc_hd__or2b_2
XFILLER_20_212 VGND VGND VPWR VPWR sky130_fd_sc_hd__decap_3
X_7642_ _7631_/D _7641_/X _7640_/Y VGND VGND VPWR VPWR _7642_/X sky130_fd_sc_hd__a21o_2
X_4854_ _6610_/A _6792_/B _6675_/B _6731_/A VGND VGND VPWR VPWR _4854_/X sky130_fd_sc_hd__and4_2
XFILLER_20_245 VGND VGND VPWR VPWR sky130_fd_sc_hd__decap_3
XFILLER_20_256 VGND VGND VPWR VPWR sky130_fd_sc_hd__decap_3
X_7573_ _7573_/A _7573_/B _7575_/C _7573_/D VGND VGND VPWR VPWR _7579_/A sky130_fd_sc_hd__or4_4
X_4785_ _7233_/S _8274_/Q VGND VGND VPWR VPWR _4786_/B sky130_fd_sc_hd__nand2_2
XFILLER_119_645 VGND VGND VPWR VPWR sky130_fd_sc_hd__decap_3
XFILLER_20_278 VGND VGND VPWR VPWR sky130_fd_sc_hd__decap_3
X_6524_ _6483_/A _6483_/B _8253_/Q VGND VGND VPWR VPWR _6527_/B sky130_fd_sc_hd__a21o_2
XFILLER_118_144 VGND VGND VPWR VPWR sky130_fd_sc_hd__fill_1
XFILLER_9_290 VGND VGND VPWR VPWR sky130_fd_sc_hd__fill_1
X_6455_ _5460_/X _5466_/X _5465_/X _5472_/A _6620_/A _6818_/S VGND VGND VPWR VPWR
+ _6455_/X sky130_fd_sc_hd__mux4_2
X_6386_ _5528_/A _6385_/X _5124_/A VGND VGND VPWR VPWR _6386_/Y sky130_fd_sc_hd__o21ai_2
X_5406_ _8290_/Q _5404_/X _6130_/C _5276_/Y VGND VGND VPWR VPWR _5406_/X sky130_fd_sc_hd__a22o_2
XFILLER_0_628 VGND VGND VPWR VPWR sky130_fd_sc_hd__fill_1
XFILLER_102_501 VGND VGND VPWR VPWR sky130_fd_sc_hd__decap_3
XFILLER_88_724 VGND VGND VPWR VPWR sky130_fd_sc_hd__decap_3
X_8125_ _8397_/CLK _8125_/D VGND VGND VPWR VPWR _8125_/Q sky130_fd_sc_hd__dfxtp_2
X_5337_ _5337_/A VGND VGND VPWR VPWR _5337_/X sky130_fd_sc_hd__buf_1
XFILLER_87_223 VGND VGND VPWR VPWR sky130_fd_sc_hd__fill_1
XFILLER_87_234 VGND VGND VPWR VPWR sky130_fd_sc_hd__fill_2
X_8056_ clkload4/A _8056_/D VGND VGND VPWR VPWR _8056_/Q sky130_fd_sc_hd__dfxtp_2
X_5268_ _6536_/A VGND VGND VPWR VPWR _5268_/X sky130_fd_sc_hd__clkbuf_1
XFILLER_102_567 VGND VGND VPWR VPWR sky130_fd_sc_hd__decap_3
XFILLER_102_578 VGND VGND VPWR VPWR sky130_fd_sc_hd__decap_3
XFILLER_85_29 VGND VGND VPWR VPWR sky130_fd_sc_hd__fill_2
X_7007_ _7007_/A VGND VGND VPWR VPWR _7010_/C sky130_fd_sc_hd__inv_2
X_4219_ _4219_/A VGND VGND VPWR VPWR _8047_/D sky130_fd_sc_hd__buf_1
XFILLER_28_312 VGND VGND VPWR VPWR sky130_fd_sc_hd__decap_3
XFILLER_56_610 VGND VGND VPWR VPWR sky130_fd_sc_hd__decap_3
XFILLER_68_492 VGND VGND VPWR VPWR sky130_fd_sc_hd__decap_3
XFILLER_75_429 VGND VGND VPWR VPWR sky130_fd_sc_hd__decap_3
X_5199_ _5464_/A VGND VGND VPWR VPWR _6721_/A sky130_fd_sc_hd__buf_1
XFILLER_28_356 VGND VGND VPWR VPWR sky130_fd_sc_hd__decap_3
XFILLER_55_131 VGND VGND VPWR VPWR sky130_fd_sc_hd__fill_2
XFILLER_56_654 VGND VGND VPWR VPWR sky130_fd_sc_hd__decap_3
XFILLER_55_164 VGND VGND VPWR VPWR sky130_fd_sc_hd__decap_3
XFILLER_71_635 VGND VGND VPWR VPWR sky130_fd_sc_hd__decap_3
XFILLER_83_473 VGND VGND VPWR VPWR sky130_fd_sc_hd__decap_3
XFILLER_43_337 VGND VGND VPWR VPWR sky130_fd_sc_hd__decap_3
XFILLER_55_186 VGND VGND VPWR VPWR sky130_fd_sc_hd__decap_3
XFILLER_70_123 VGND VGND VPWR VPWR sky130_fd_sc_hd__decap_3
XTAP_TAPCELL_ROW_104_1611 VGND VPWR sky130_fd_sc_hd__tapvpwrvgnd_1
X_7909_ _7909_/A VGND VGND VPWR VPWR _8391_/D sky130_fd_sc_hd__buf_1
XFILLER_34_55 VGND VGND VPWR VPWR sky130_fd_sc_hd__fill_1
XFILLER_71_679 VGND VGND VPWR VPWR sky130_fd_sc_hd__decap_3
XFILLER_12_724 VGND VGND VPWR VPWR sky130_fd_sc_hd__decap_3
XFILLER_24_584 VGND VGND VPWR VPWR sky130_fd_sc_hd__decap_3
XFILLER_24_595 VGND VGND VPWR VPWR sky130_fd_sc_hd__decap_3
XFILLER_34_88 VGND VGND VPWR VPWR sky130_fd_sc_hd__fill_2
XFILLER_70_189 VGND VGND VPWR VPWR sky130_fd_sc_hd__decap_3
XFILLER_11_234 VGND VGND VPWR VPWR sky130_fd_sc_hd__decap_3
XFILLER_8_728 VGND VGND VPWR VPWR sky130_fd_sc_hd__decap_3
XFILLER_109_100 VGND VGND VPWR VPWR sky130_fd_sc_hd__fill_2
XFILLER_109_111 VGND VGND VPWR VPWR sky130_fd_sc_hd__fill_1
XFILLER_11_267 VGND VGND VPWR VPWR sky130_fd_sc_hd__decap_3
XFILLER_50_32 VGND VGND VPWR VPWR sky130_fd_sc_hd__decap_3
XFILLER_109_199 VGND VGND VPWR VPWR sky130_fd_sc_hd__decap_3
XFILLER_3_433 VGND VGND VPWR VPWR sky130_fd_sc_hd__decap_3
XTAP_TAPCELL_ROW_115_1751 VGND VPWR sky130_fd_sc_hd__tapvpwrvgnd_1
XFILLER_112_309 VGND VGND VPWR VPWR sky130_fd_sc_hd__fill_1
XFILLER_3_455 VGND VGND VPWR VPWR sky130_fd_sc_hd__decap_3
XFILLER_59_52 VGND VGND VPWR VPWR sky130_fd_sc_hd__decap_3
XFILLER_78_245 VGND VGND VPWR VPWR sky130_fd_sc_hd__decap_3
XFILLER_38_109 VGND VGND VPWR VPWR sky130_fd_sc_hd__decap_3
XFILLER_59_96 VGND VGND VPWR VPWR sky130_fd_sc_hd__decap_3
XFILLER_78_256 VGND VGND VPWR VPWR sky130_fd_sc_hd__decap_3
XFILLER_115_80 VGND VGND VPWR VPWR sky130_fd_sc_hd__decap_3
XFILLER_19_301 VGND VGND VPWR VPWR sky130_fd_sc_hd__decap_3
XFILLER_75_40 VGND VGND VPWR VPWR sky130_fd_sc_hd__decap_3
XFILLER_93_215 VGND VGND VPWR VPWR sky130_fd_sc_hd__decap_3
XFILLER_93_237 VGND VGND VPWR VPWR sky130_fd_sc_hd__decap_3
XFILLER_74_451 VGND VGND VPWR VPWR sky130_fd_sc_hd__decap_3
XFILLER_19_389 VGND VGND VPWR VPWR sky130_fd_sc_hd__decap_3
XFILLER_34_315 VGND VGND VPWR VPWR sky130_fd_sc_hd__decap_3
XFILLER_46_153 VGND VGND VPWR VPWR sky130_fd_sc_hd__decap_3
XFILLER_75_84 VGND VGND VPWR VPWR sky130_fd_sc_hd__decap_3
XTAP_TAPCELL_ROW_66_1116 VGND VPWR sky130_fd_sc_hd__tapvpwrvgnd_1
XFILLER_46_197 VGND VGND VPWR VPWR sky130_fd_sc_hd__decap_3
XTAP_TAPCELL_ROW_45_844 VGND VPWR sky130_fd_sc_hd__tapvpwrvgnd_1
XFILLER_61_178 VGND VGND VPWR VPWR sky130_fd_sc_hd__fill_1
XFILLER_62_679 VGND VGND VPWR VPWR sky130_fd_sc_hd__decap_3
XFILLER_91_83 VGND VGND VPWR VPWR sky130_fd_sc_hd__decap_3
XFILLER_30_554 VGND VGND VPWR VPWR sky130_fd_sc_hd__decap_3
XTAP_TAPCELL_ROW_25_590 VGND VPWR sky130_fd_sc_hd__tapvpwrvgnd_1
X_4570_ _7898_/B _8089_/Q VGND VGND VPWR VPWR _4571_/A sky130_fd_sc_hd__and2_2
XFILLER_116_604 VGND VGND VPWR VPWR sky130_fd_sc_hd__decap_3
XFILLER_115_103 VGND VGND VPWR VPWR sky130_fd_sc_hd__decap_3
XFILLER_116_648 VGND VGND VPWR VPWR sky130_fd_sc_hd__decap_3
XTAP_TAPCELL_ROW_77_1256 VGND VPWR sky130_fd_sc_hd__tapvpwrvgnd_1
XFILLER_115_125 VGND VGND VPWR VPWR sky130_fd_sc_hd__fill_2
XFILLER_6_293 VGND VGND VPWR VPWR sky130_fd_sc_hd__decap_3
X_6240_ _6239_/X _6165_/X _6104_/X _6012_/X _7812_/A _7670_/A VGND VGND VPWR VPWR
+ _6240_/X sky130_fd_sc_hd__mux4_2
XFILLER_115_169 VGND VGND VPWR VPWR sky130_fd_sc_hd__fill_2
X_6171_ _6109_/A _6170_/X _5124_/A VGND VGND VPWR VPWR _6171_/Y sky130_fd_sc_hd__o21ai_2
XTAP_TAPCELL_ROW_90_1434 VGND VPWR sky130_fd_sc_hd__tapvpwrvgnd_1
XTAP_TAPCELL_ROW_90_1423 VGND VPWR sky130_fd_sc_hd__tapvpwrvgnd_1
XFILLER_69_223 VGND VGND VPWR VPWR sky130_fd_sc_hd__fill_1
XFILLER_97_543 VGND VGND VPWR VPWR sky130_fd_sc_hd__decap_3
X_5122_ _5785_/A VGND VGND VPWR VPWR _5857_/A sky130_fd_sc_hd__clkbuf_2
XFILLER_57_418 VGND VGND VPWR VPWR sky130_fd_sc_hd__decap_3
XFILLER_85_705 VGND VGND VPWR VPWR sky130_fd_sc_hd__decap_3
XFILLER_97_576 VGND VGND VPWR VPWR sky130_fd_sc_hd__decap_3
XFILLER_111_375 VGND VGND VPWR VPWR sky130_fd_sc_hd__decap_3
XFILLER_84_215 VGND VGND VPWR VPWR sky130_fd_sc_hd__decap_3
X_5053_ _8254_/Q _5053_/B VGND VGND VPWR VPWR _5054_/B sky130_fd_sc_hd__nor2_2
XFILLER_84_259 VGND VGND VPWR VPWR sky130_fd_sc_hd__decap_3
X_4004_ _8355_/Q _7930_/B VGND VGND VPWR VPWR _4005_/A sky130_fd_sc_hd__and2_2
XFILLER_53_613 VGND VGND VPWR VPWR sky130_fd_sc_hd__decap_3
XFILLER_65_484 VGND VGND VPWR VPWR sky130_fd_sc_hd__decap_3
XFILLER_25_337 VGND VGND VPWR VPWR sky130_fd_sc_hd__decap_3
XFILLER_52_112 VGND VGND VPWR VPWR sky130_fd_sc_hd__decap_3
XFILLER_53_635 VGND VGND VPWR VPWR sky130_fd_sc_hd__decap_3
XFILLER_80_421 VGND VGND VPWR VPWR sky130_fd_sc_hd__decap_3
XFILLER_53_668 VGND VGND VPWR VPWR sky130_fd_sc_hd__decap_3
XFILLER_53_679 VGND VGND VPWR VPWR sky130_fd_sc_hd__fill_2
X_5955_ _7825_/A _5949_/X _5954_/X VGND VGND VPWR VPWR _5955_/Y sky130_fd_sc_hd__o21ai_2
XFILLER_33_370 VGND VGND VPWR VPWR sky130_fd_sc_hd__decap_3
XFILLER_40_318 VGND VGND VPWR VPWR sky130_fd_sc_hd__decap_3
X_5886_ _5886_/A _5886_/B VGND VGND VPWR VPWR _5925_/C sky130_fd_sc_hd__nor2_2
X_4906_ _8241_/Q _8177_/Q VGND VGND VPWR VPWR _5037_/B sky130_fd_sc_hd__and2b_2
X_7625_ _7193_/A _7624_/X _7626_/A VGND VGND VPWR VPWR _7625_/X sky130_fd_sc_hd__o21a_2
X_4837_ _8196_/Q _8260_/Q VGND VGND VPWR VPWR _4838_/B sky130_fd_sc_hd__and2b_2
X_7556_ _7038_/X _7555_/X _6782_/X _7321_/X _6070_/A _6507_/S VGND VGND VPWR VPWR
+ _7556_/X sky130_fd_sc_hd__mux4_2
Xrebuffer836 _7488_/X VGND VGND VPWR VPWR _7573_/A sky130_fd_sc_hd__buf_2
X_4768_ _8215_/Q _4769_/B VGND VGND VPWR VPWR _7372_/A sky130_fd_sc_hd__or2_2
XFILLER_107_615 VGND VGND VPWR VPWR sky130_fd_sc_hd__fill_1
XFILLER_119_475 VGND VGND VPWR VPWR sky130_fd_sc_hd__fill_1
XFILLER_119_486 VGND VGND VPWR VPWR sky130_fd_sc_hd__decap_3
X_7487_ _8217_/Q _8281_/Q _8282_/Q VGND VGND VPWR VPWR _7488_/C sky130_fd_sc_hd__o21a_2
X_6507_ _6506_/X _6200_/X _6507_/S VGND VGND VPWR VPWR _6508_/B sky130_fd_sc_hd__mux2_2
X_4699_ _4699_/A VGND VGND VPWR VPWR _8287_/D sky130_fd_sc_hd__buf_1
XFILLER_106_147 VGND VGND VPWR VPWR sky130_fd_sc_hd__decap_3
XFILLER_107_648 VGND VGND VPWR VPWR sky130_fd_sc_hd__decap_3
X_6438_ _8250_/Q _6411_/B _8186_/Q VGND VGND VPWR VPWR _6438_/X sky130_fd_sc_hd__a21o_2
X_8108_ _8379_/CLK _8108_/D VGND VGND VPWR VPWR _8108_/Q sky130_fd_sc_hd__dfxtp_2
X_6369_ _8186_/Q _6717_/A _6431_/C _6368_/Y VGND VGND VPWR VPWR _6369_/X sky130_fd_sc_hd__o31a_2
XFILLER_0_458 VGND VGND VPWR VPWR sky130_fd_sc_hd__decap_3
XFILLER_0_469 VGND VGND VPWR VPWR sky130_fd_sc_hd__decap_3
XFILLER_102_353 VGND VGND VPWR VPWR sky130_fd_sc_hd__decap_3
XFILLER_29_33 VGND VGND VPWR VPWR sky130_fd_sc_hd__decap_3
XFILLER_48_418 VGND VGND VPWR VPWR sky130_fd_sc_hd__fill_2
XFILLER_88_554 VGND VGND VPWR VPWR sky130_fd_sc_hd__decap_3
XFILLER_102_386 VGND VGND VPWR VPWR sky130_fd_sc_hd__decap_3
XFILLER_75_237 VGND VGND VPWR VPWR sky130_fd_sc_hd__fill_2
XFILLER_88_587 VGND VGND VPWR VPWR sky130_fd_sc_hd__fill_1
XTAP_TAPCELL_ROW_110_1692 VGND VPWR sky130_fd_sc_hd__tapvpwrvgnd_1
X_8039_ clkload9/A _8039_/D VGND VGND VPWR VPWR _8039_/Q sky130_fd_sc_hd__dfxtp_2
XFILLER_29_665 VGND VGND VPWR VPWR sky130_fd_sc_hd__decap_3
XFILLER_29_99 VGND VGND VPWR VPWR sky130_fd_sc_hd__decap_3
XFILLER_16_315 VGND VGND VPWR VPWR sky130_fd_sc_hd__decap_3
XFILLER_28_164 VGND VGND VPWR VPWR sky130_fd_sc_hd__decap_3
XFILLER_29_676 VGND VGND VPWR VPWR sky130_fd_sc_hd__decap_3
XFILLER_29_687 VGND VGND VPWR VPWR sky130_fd_sc_hd__decap_3
XFILLER_56_473 VGND VGND VPWR VPWR sky130_fd_sc_hd__decap_3
XFILLER_90_218 VGND VGND VPWR VPWR sky130_fd_sc_hd__decap_3
XTAP_TAPCELL_ROW_3_296 VGND VPWR sky130_fd_sc_hd__tapvpwrvgnd_1
XFILLER_16_348 VGND VGND VPWR VPWR sky130_fd_sc_hd__decap_3
XFILLER_28_197 VGND VGND VPWR VPWR sky130_fd_sc_hd__decap_3
XFILLER_45_32 VGND VGND VPWR VPWR sky130_fd_sc_hd__decap_3
XFILLER_45_54 VGND VGND VPWR VPWR sky130_fd_sc_hd__fill_2
XFILLER_71_443 VGND VGND VPWR VPWR sky130_fd_sc_hd__decap_3
XFILLER_83_292 VGND VGND VPWR VPWR sky130_fd_sc_hd__fill_1
XFILLER_43_156 VGND VGND VPWR VPWR sky130_fd_sc_hd__decap_3
XTAP_TAPCELL_ROW_42_803 VGND VPWR sky130_fd_sc_hd__tapvpwrvgnd_1
XFILLER_101_60 VGND VGND VPWR VPWR sky130_fd_sc_hd__decap_3
XFILLER_12_510 VGND VGND VPWR VPWR sky130_fd_sc_hd__decap_3
XFILLER_24_392 VGND VGND VPWR VPWR sky130_fd_sc_hd__fill_2
XFILLER_61_42 VGND VGND VPWR VPWR sky130_fd_sc_hd__fill_1
XTAP_TAPCELL_ROW_61_1057 VGND VPWR sky130_fd_sc_hd__tapvpwrvgnd_1
XTAP_TAPCELL_ROW_61_1046 VGND VPWR sky130_fd_sc_hd__tapvpwrvgnd_1
XFILLER_12_565 VGND VGND VPWR VPWR sky130_fd_sc_hd__decap_3
XFILLER_61_75 VGND VGND VPWR VPWR sky130_fd_sc_hd__decap_3
XFILLER_8_525 VGND VGND VPWR VPWR sky130_fd_sc_hd__decap_3
XFILLER_8_536 VGND VGND VPWR VPWR sky130_fd_sc_hd__decap_3
XANTENNA_8 _4017_/A VGND VGND VPWR VPWR sky130_fd_sc_hd__diode_2
XFILLER_113_607 VGND VGND VPWR VPWR sky130_fd_sc_hd__fill_2
XFILLER_10_90 VGND VGND VPWR VPWR sky130_fd_sc_hd__decap_3
XFILLER_112_128 VGND VGND VPWR VPWR sky130_fd_sc_hd__decap_3
XFILLER_79_532 VGND VGND VPWR VPWR sky130_fd_sc_hd__fill_1
XFILLER_39_429 VGND VGND VPWR VPWR sky130_fd_sc_hd__decap_3
XFILLER_66_215 VGND VGND VPWR VPWR sky130_fd_sc_hd__decap_3
XFILLER_86_83 VGND VGND VPWR VPWR sky130_fd_sc_hd__fill_1
XTAP_TAPCELL_ROW_72_1197 VGND VPWR sky130_fd_sc_hd__tapvpwrvgnd_1
XFILLER_19_131 VGND VGND VPWR VPWR sky130_fd_sc_hd__decap_3
XFILLER_66_248 VGND VGND VPWR VPWR sky130_fd_sc_hd__decap_3
XFILLER_66_259 VGND VGND VPWR VPWR sky130_fd_sc_hd__decap_3
XFILLER_86_94 VGND VGND VPWR VPWR sky130_fd_sc_hd__decap_3
XFILLER_94_579 VGND VGND VPWR VPWR sky130_fd_sc_hd__decap_3
XFILLER_19_164 VGND VGND VPWR VPWR sky130_fd_sc_hd__decap_3
XFILLER_35_624 VGND VGND VPWR VPWR sky130_fd_sc_hd__decap_3
XFILLER_81_218 VGND VGND VPWR VPWR sky130_fd_sc_hd__decap_3
XFILLER_19_175 VGND VGND VPWR VPWR sky130_fd_sc_hd__decap_3
XFILLER_34_112 VGND VGND VPWR VPWR sky130_fd_sc_hd__decap_3
XFILLER_62_421 VGND VGND VPWR VPWR sky130_fd_sc_hd__decap_3
XFILLER_22_307 VGND VGND VPWR VPWR sky130_fd_sc_hd__fill_1
XFILLER_35_679 VGND VGND VPWR VPWR sky130_fd_sc_hd__decap_3
XFILLER_50_605 VGND VGND VPWR VPWR sky130_fd_sc_hd__decap_3
XFILLER_62_454 VGND VGND VPWR VPWR sky130_fd_sc_hd__decap_3
XFILLER_22_318 VGND VGND VPWR VPWR sky130_fd_sc_hd__decap_3
X_5740_ _5740_/A VGND VGND VPWR VPWR _5740_/Y sky130_fd_sc_hd__inv_2
XFILLER_30_362 VGND VGND VPWR VPWR sky130_fd_sc_hd__fill_2
X_7410_ _8216_/Q _8280_/Q VGND VGND VPWR VPWR _7490_/D sky130_fd_sc_hd__or2_2
X_5671_ _5671_/A _5671_/B VGND VGND VPWR VPWR _5671_/Y sky130_fd_sc_hd__nand2_2
XTAP_TAPCELL_ROW_20_519 VGND VPWR sky130_fd_sc_hd__tapvpwrvgnd_1
XFILLER_30_384 VGND VGND VPWR VPWR sky130_fd_sc_hd__decap_3
X_8390_ _8390_/CLK _8390_/D VGND VGND VPWR VPWR _8390_/Q sky130_fd_sc_hd__dfxtp_2
X_4622_ _7898_/B _8115_/Q VGND VGND VPWR VPWR _4623_/A sky130_fd_sc_hd__and2_2
Xmax_cap211 _5270_/X VGND VGND VPWR VPWR _5671_/A sky130_fd_sc_hd__buf_4
X_7341_ _8277_/Q _7312_/Y _8213_/Q VGND VGND VPWR VPWR _7341_/X sky130_fd_sc_hd__a21bo_2
X_4553_ _4553_/A VGND VGND VPWR VPWR _8214_/D sky130_fd_sc_hd__buf_1
XFILLER_116_456 VGND VGND VPWR VPWR sky130_fd_sc_hd__decap_3
XFILLER_7_591 VGND VGND VPWR VPWR sky130_fd_sc_hd__decap_3
Xmax_cap244 _8229_/Q VGND VGND VPWR VPWR _7193_/A sky130_fd_sc_hd__buf_12
Xmax_cap233 _5332_/X VGND VGND VPWR VPWR _6121_/B sky130_fd_sc_hd__buf_6
Xmax_cap222 _5462_/X VGND VGND VPWR VPWR _7298_/S0 sky130_fd_sc_hd__buf_6
X_7272_ _7193_/A _7271_/X _6529_/A VGND VGND VPWR VPWR _7272_/Y sky130_fd_sc_hd__o21ai_2
X_4484_ _7898_/B _8046_/Q VGND VGND VPWR VPWR _4485_/A sky130_fd_sc_hd__and2_2
XFILLER_104_607 VGND VGND VPWR VPWR sky130_fd_sc_hd__decap_3
X_6223_ _6297_/A _6224_/B VGND VGND VPWR VPWR _6223_/Y sky130_fd_sc_hd__nand2_2
XFILLER_103_128 VGND VGND VPWR VPWR sky130_fd_sc_hd__decap_3
XFILLER_112_651 VGND VGND VPWR VPWR sky130_fd_sc_hd__decap_3
X_6154_ _6148_/X _6656_/A _6152_/X _6192_/A VGND VGND VPWR VPWR _6154_/X sky130_fd_sc_hd__a211o_2
XFILLER_111_150 VGND VGND VPWR VPWR sky130_fd_sc_hd__fill_1
XFILLER_112_695 VGND VGND VPWR VPWR sky130_fd_sc_hd__decap_3
XFILLER_57_204 VGND VGND VPWR VPWR sky130_fd_sc_hd__decap_3
XFILLER_97_384 VGND VGND VPWR VPWR sky130_fd_sc_hd__fill_1
X_6085_ _8178_/Q _8242_/Q VGND VGND VPWR VPWR _6086_/B sky130_fd_sc_hd__and2_2
X_5105_ _5528_/A _5832_/A VGND VGND VPWR VPWR _5488_/B sky130_fd_sc_hd__nor2_2
XFILLER_57_237 VGND VGND VPWR VPWR sky130_fd_sc_hd__fill_2
XFILLER_57_248 VGND VGND VPWR VPWR sky130_fd_sc_hd__decap_3
X_5036_ _4970_/A _5021_/X _5030_/X _4941_/A _5035_/X VGND VGND VPWR VPWR _5036_/X
+ sky130_fd_sc_hd__o221a_2
XFILLER_26_602 VGND VGND VPWR VPWR sky130_fd_sc_hd__decap_3
XFILLER_38_462 VGND VGND VPWR VPWR sky130_fd_sc_hd__decap_3
XFILLER_72_218 VGND VGND VPWR VPWR sky130_fd_sc_hd__decap_3
XTAP_TAPCELL_ROW_28_619 VGND VPWR sky130_fd_sc_hd__tapvpwrvgnd_1
XFILLER_26_635 VGND VGND VPWR VPWR sky130_fd_sc_hd__fill_2
XFILLER_26_657 VGND VGND VPWR VPWR sky130_fd_sc_hd__decap_3
XFILLER_53_432 VGND VGND VPWR VPWR sky130_fd_sc_hd__decap_3
XFILLER_65_281 VGND VGND VPWR VPWR sky130_fd_sc_hd__decap_3
XTAP_TAPCELL_ROW_0_244 VGND VPWR sky130_fd_sc_hd__tapvpwrvgnd_1
XFILLER_53_476 VGND VGND VPWR VPWR sky130_fd_sc_hd__decap_3
XTAP_TAPCELL_ROW_0_255 VGND VPWR sky130_fd_sc_hd__tapvpwrvgnd_1
X_6987_ _8203_/Q _6974_/X _6982_/Y _6986_/X VGND VGND VPWR VPWR _6987_/X sky130_fd_sc_hd__a211o_2
XFILLER_25_178 VGND VGND VPWR VPWR sky130_fd_sc_hd__decap_3
XFILLER_40_126 VGND VGND VPWR VPWR sky130_fd_sc_hd__decap_3
XFILLER_41_649 VGND VGND VPWR VPWR sky130_fd_sc_hd__decap_3
XFILLER_53_498 VGND VGND VPWR VPWR sky130_fd_sc_hd__decap_3
XFILLER_80_262 VGND VGND VPWR VPWR sky130_fd_sc_hd__decap_3
X_5938_ _6767_/A _5965_/A _5937_/Y _8290_/Q VGND VGND VPWR VPWR _5938_/X sky130_fd_sc_hd__o2bb2a_2
XFILLER_15_68 VGND VGND VPWR VPWR sky130_fd_sc_hd__decap_3
XFILLER_80_295 VGND VGND VPWR VPWR sky130_fd_sc_hd__decap_3
XFILLER_21_340 VGND VGND VPWR VPWR sky130_fd_sc_hd__decap_3
X_5869_ _8166_/Q _8230_/Q _5624_/X VGND VGND VPWR VPWR _5869_/X sky130_fd_sc_hd__a21o_2
X_7608_ _8220_/Q _8221_/Q _7608_/C VGND VGND VPWR VPWR _7608_/X sky130_fd_sc_hd__or3_4
XFILLER_119_261 VGND VGND VPWR VPWR sky130_fd_sc_hd__fill_1
XFILLER_31_67 VGND VGND VPWR VPWR sky130_fd_sc_hd__decap_3
X_7539_ _5563_/X _7522_/X _7526_/X _7531_/Y _7538_/X VGND VGND VPWR VPWR _7539_/X
+ sky130_fd_sc_hd__a2111o_2
XFILLER_107_467 VGND VGND VPWR VPWR sky130_fd_sc_hd__decap_3
XTAP_TAPCELL_ROW_112_1710 VGND VPWR sky130_fd_sc_hd__tapvpwrvgnd_1
XTAP_TAPCELL_ROW_112_1721 VGND VPWR sky130_fd_sc_hd__tapvpwrvgnd_1
XFILLER_0_222 VGND VGND VPWR VPWR sky130_fd_sc_hd__fill_2
XFILLER_88_340 VGND VGND VPWR VPWR sky130_fd_sc_hd__decap_3
Xinput101 operand_b[38] VGND VGND VPWR VPWR _4380_/B sky130_fd_sc_hd__clkdlybuf4s25_1
XTAP_TAPCELL_ROW_8_366 VGND VPWR sky130_fd_sc_hd__tapvpwrvgnd_1
XFILLER_0_277 VGND VGND VPWR VPWR sky130_fd_sc_hd__decap_3
XFILLER_102_150 VGND VGND VPWR VPWR sky130_fd_sc_hd__decap_3
XFILLER_103_673 VGND VGND VPWR VPWR sky130_fd_sc_hd__fill_2
XFILLER_48_215 VGND VGND VPWR VPWR sky130_fd_sc_hd__decap_3
Xinput112 operand_b[48] VGND VGND VPWR VPWR _4400_/B sky130_fd_sc_hd__clkdlybuf4s25_1
Xinput134 rst_n VGND VGND VPWR VPWR _7843_/A sky130_fd_sc_hd__buf_8
Xinput123 operand_b[58] VGND VGND VPWR VPWR _4420_/B sky130_fd_sc_hd__clkdlybuf4s25_1
XFILLER_102_183 VGND VGND VPWR VPWR sky130_fd_sc_hd__decap_3
XFILLER_48_248 VGND VGND VPWR VPWR sky130_fd_sc_hd__decap_3
XFILLER_48_259 VGND VGND VPWR VPWR sky130_fd_sc_hd__decap_3
XFILLER_56_20 VGND VGND VPWR VPWR sky130_fd_sc_hd__fill_1
XFILLER_76_557 VGND VGND VPWR VPWR sky130_fd_sc_hd__decap_3
XFILLER_29_473 VGND VGND VPWR VPWR sky130_fd_sc_hd__decap_3
XFILLER_56_64 VGND VGND VPWR VPWR sky130_fd_sc_hd__decap_3
XFILLER_91_505 VGND VGND VPWR VPWR sky130_fd_sc_hd__decap_3
XFILLER_29_495 VGND VGND VPWR VPWR sky130_fd_sc_hd__decap_3
XFILLER_44_410 VGND VGND VPWR VPWR sky130_fd_sc_hd__decap_3
XFILLER_44_421 VGND VGND VPWR VPWR sky130_fd_sc_hd__decap_3
XFILLER_56_270 VGND VGND VPWR VPWR sky130_fd_sc_hd__decap_3
XFILLER_56_97 VGND VGND VPWR VPWR sky130_fd_sc_hd__decap_3
XFILLER_16_156 VGND VGND VPWR VPWR sky130_fd_sc_hd__decap_3
XFILLER_44_454 VGND VGND VPWR VPWR sky130_fd_sc_hd__decap_3
XPHY_EDGE_ROW_113_Right_113 VGND VGND VPWR VPWR sky130_fd_sc_hd__decap_3
XFILLER_16_189 VGND VGND VPWR VPWR sky130_fd_sc_hd__decap_3
XFILLER_31_104 VGND VGND VPWR VPWR sky130_fd_sc_hd__decap_3
XFILLER_32_627 VGND VGND VPWR VPWR sky130_fd_sc_hd__decap_3
XFILLER_44_498 VGND VGND VPWR VPWR sky130_fd_sc_hd__decap_3
XFILLER_71_262 VGND VGND VPWR VPWR sky130_fd_sc_hd__decap_3
XTAP_TAPCELL_ROW_55_972 VGND VPWR sky130_fd_sc_hd__tapvpwrvgnd_1
XFILLER_31_126 VGND VGND VPWR VPWR sky130_fd_sc_hd__fill_2
XFILLER_72_85 VGND VGND VPWR VPWR sky130_fd_sc_hd__decap_3
XFILLER_12_362 VGND VGND VPWR VPWR sky130_fd_sc_hd__fill_2
XFILLER_40_671 VGND VGND VPWR VPWR sky130_fd_sc_hd__decap_3
XFILLER_40_693 VGND VGND VPWR VPWR sky130_fd_sc_hd__decap_3
XFILLER_8_399 VGND VGND VPWR VPWR sky130_fd_sc_hd__decap_3
XFILLER_113_404 VGND VGND VPWR VPWR sky130_fd_sc_hd__fill_2
XFILLER_4_550 VGND VGND VPWR VPWR sky130_fd_sc_hd__decap_3
XTAP_TAPCELL_ROW_74_1226 VGND VPWR sky130_fd_sc_hd__tapvpwrvgnd_1
XTAP_TAPCELL_ROW_74_1215 VGND VPWR sky130_fd_sc_hd__tapvpwrvgnd_1
XFILLER_79_340 VGND VGND VPWR VPWR sky130_fd_sc_hd__fill_1
XFILLER_79_351 VGND VGND VPWR VPWR sky130_fd_sc_hd__decap_3
XFILLER_97_82 VGND VGND VPWR VPWR sky130_fd_sc_hd__fill_2
XFILLER_98_159 VGND VGND VPWR VPWR sky130_fd_sc_hd__decap_3
XFILLER_67_524 VGND VGND VPWR VPWR sky130_fd_sc_hd__decap_3
XFILLER_67_568 VGND VGND VPWR VPWR sky130_fd_sc_hd__decap_3
XFILLER_94_332 VGND VGND VPWR VPWR sky130_fd_sc_hd__decap_3
Xsplit264 _6024_/B VGND VGND VPWR VPWR _6022_/B sky130_fd_sc_hd__buf_4
Xsplit275 _5491_/C VGND VGND VPWR VPWR _5411_/B sky130_fd_sc_hd__buf_4
XFILLER_54_218 VGND VGND VPWR VPWR sky130_fd_sc_hd__fill_1
XFILLER_55_719 VGND VGND VPWR VPWR sky130_fd_sc_hd__fill_1
XFILLER_82_516 VGND VGND VPWR VPWR sky130_fd_sc_hd__decap_3
XFILLER_94_365 VGND VGND VPWR VPWR sky130_fd_sc_hd__decap_3
XFILLER_35_432 VGND VGND VPWR VPWR sky130_fd_sc_hd__decap_3
XFILLER_47_281 VGND VGND VPWR VPWR sky130_fd_sc_hd__decap_3
XFILLER_82_538 VGND VGND VPWR VPWR sky130_fd_sc_hd__decap_3
XFILLER_94_398 VGND VGND VPWR VPWR sky130_fd_sc_hd__decap_3
X_7890_ _8315_/Q _7898_/B VGND VGND VPWR VPWR _7891_/A sky130_fd_sc_hd__and2_2
X_6910_ _6910_/A _6910_/B _6910_/C VGND VGND VPWR VPWR _6910_/X sky130_fd_sc_hd__and3_2
X_6841_ _6856_/A2 _6840_/X _6148_/X VGND VGND VPWR VPWR _6841_/X sky130_fd_sc_hd__o21a_2
XTAP_TAPCELL_ROW_85_1366 VGND VPWR sky130_fd_sc_hd__tapvpwrvgnd_1
XFILLER_22_115 VGND VGND VPWR VPWR sky130_fd_sc_hd__decap_3
XFILLER_35_476 VGND VGND VPWR VPWR sky130_fd_sc_hd__decap_3
XFILLER_50_424 VGND VGND VPWR VPWR sky130_fd_sc_hd__decap_3
XFILLER_62_262 VGND VGND VPWR VPWR sky130_fd_sc_hd__decap_3
XFILLER_90_571 VGND VGND VPWR VPWR sky130_fd_sc_hd__fill_1
XFILLER_22_148 VGND VGND VPWR VPWR sky130_fd_sc_hd__decap_3
XFILLER_62_295 VGND VGND VPWR VPWR sky130_fd_sc_hd__decap_3
X_6772_ _8195_/Q _8196_/Q VGND VGND VPWR VPWR _6853_/B sky130_fd_sc_hd__nand2_2
X_3984_ _8345_/Q _7930_/B VGND VGND VPWR VPWR _3985_/A sky130_fd_sc_hd__and2_2
X_5723_ _6999_/A1 _5720_/X _5722_/X VGND VGND VPWR VPWR _5723_/X sky130_fd_sc_hd__a21o_2
XTAP_TAPCELL_ROW_33_688 VGND VPWR sky130_fd_sc_hd__tapvpwrvgnd_1
X_5654_ _5528_/A _5584_/A _8230_/Q _5598_/D VGND VGND VPWR VPWR _5654_/X sky130_fd_sc_hd__a31o_2
X_8373_ _8382_/CLK _8373_/D VGND VGND VPWR VPWR _8373_/Q sky130_fd_sc_hd__dfxtp_2
X_4605_ _4605_/A VGND VGND VPWR VPWR _8240_/D sky130_fd_sc_hd__buf_1
XFILLER_116_220 VGND VGND VPWR VPWR sky130_fd_sc_hd__fill_1
XFILLER_117_732 VGND VGND VPWR VPWR sky130_fd_sc_hd__fill_1
X_7324_ _7193_/A _6203_/Y _6207_/X _7323_/X VGND VGND VPWR VPWR _7324_/X sky130_fd_sc_hd__o2bb2a_2
X_5585_ _5585_/A _5690_/C VGND VGND VPWR VPWR _5585_/Y sky130_fd_sc_hd__nand2_2
XFILLER_116_253 VGND VGND VPWR VPWR sky130_fd_sc_hd__decap_3
XFILLER_117_15 VGND VGND VPWR VPWR sky130_fd_sc_hd__decap_3
XFILLER_2_509 VGND VGND VPWR VPWR sky130_fd_sc_hd__decap_3
X_4536_ _7898_/B _8072_/Q VGND VGND VPWR VPWR _4537_/A sky130_fd_sc_hd__and2_2
XFILLER_116_286 VGND VGND VPWR VPWR sky130_fd_sc_hd__fill_1
XFILLER_117_48 VGND VGND VPWR VPWR sky130_fd_sc_hd__decap_3
XFILLER_89_137 VGND VGND VPWR VPWR sky130_fd_sc_hd__decap_3
X_7255_ _7255_/A _7255_/B _7255_/C VGND VGND VPWR VPWR _7255_/X sky130_fd_sc_hd__and3_2
X_4467_ _4467_/A VGND VGND VPWR VPWR _8171_/D sky130_fd_sc_hd__buf_1
X_7186_ _8273_/Q _5398_/A _5338_/A VGND VGND VPWR VPWR _7186_/X sky130_fd_sc_hd__o21a_2
X_6206_ _5477_/A _5518_/X _5516_/X _6070_/B VGND VGND VPWR VPWR _6206_/X sky130_fd_sc_hd__a22o_2
X_4398_ _7930_/B _4398_/B VGND VGND VPWR VPWR _4399_/A sky130_fd_sc_hd__and2_2
XFILLER_112_470 VGND VGND VPWR VPWR sky130_fd_sc_hd__decap_3
XFILLER_98_671 VGND VGND VPWR VPWR sky130_fd_sc_hd__decap_3
X_6137_ _4907_/A _6138_/B _4909_/Y VGND VGND VPWR VPWR _6140_/A sky130_fd_sc_hd__a21oi_2
XTAP_TAPCELL_ROW_5_325 VGND VPWR sky130_fd_sc_hd__tapvpwrvgnd_1
XFILLER_100_654 VGND VGND VPWR VPWR sky130_fd_sc_hd__decap_3
XFILLER_112_492 VGND VGND VPWR VPWR sky130_fd_sc_hd__decap_3
XFILLER_58_546 VGND VGND VPWR VPWR sky130_fd_sc_hd__decap_3
XFILLER_85_343 VGND VGND VPWR VPWR sky130_fd_sc_hd__decap_3
XFILLER_97_181 VGND VGND VPWR VPWR sky130_fd_sc_hd__decap_3
XFILLER_100_687 VGND VGND VPWR VPWR sky130_fd_sc_hd__decap_3
XFILLER_93_29 VGND VGND VPWR VPWR sky130_fd_sc_hd__fill_1
X_6068_ _6321_/B _6354_/A _5220_/Y _6277_/A VGND VGND VPWR VPWR _6068_/X sky130_fd_sc_hd__a211o_2
XFILLER_26_23 VGND VGND VPWR VPWR sky130_fd_sc_hd__decap_3
XFILLER_26_410 VGND VGND VPWR VPWR sky130_fd_sc_hd__decap_3
XFILLER_26_421 VGND VGND VPWR VPWR sky130_fd_sc_hd__decap_3
XFILLER_38_270 VGND VGND VPWR VPWR sky130_fd_sc_hd__fill_1
XFILLER_73_538 VGND VGND VPWR VPWR sky130_fd_sc_hd__decap_3
X_5019_ _5598_/D _8230_/Q _5018_/X VGND VGND VPWR VPWR _5019_/X sky130_fd_sc_hd__a21o_2
XFILLER_53_240 VGND VGND VPWR VPWR sky130_fd_sc_hd__decap_3
XFILLER_26_67 VGND VGND VPWR VPWR sky130_fd_sc_hd__decap_3
XFILLER_41_402 VGND VGND VPWR VPWR sky130_fd_sc_hd__decap_3
XFILLER_41_424 VGND VGND VPWR VPWR sky130_fd_sc_hd__decap_3
XFILLER_81_593 VGND VGND VPWR VPWR sky130_fd_sc_hd__decap_3
XTAP_TAPCELL_ROW_52_931 VGND VPWR sky130_fd_sc_hd__tapvpwrvgnd_1
XFILLER_22_660 VGND VGND VPWR VPWR sky130_fd_sc_hd__decap_3
XFILLER_42_44 VGND VGND VPWR VPWR sky130_fd_sc_hd__decap_3
XFILLER_9_108 VGND VGND VPWR VPWR sky130_fd_sc_hd__fill_1
XFILLER_9_119 VGND VGND VPWR VPWR sky130_fd_sc_hd__decap_3
XFILLER_42_77 VGND VGND VPWR VPWR sky130_fd_sc_hd__decap_3
XFILLER_42_88 VGND VGND VPWR VPWR sky130_fd_sc_hd__decap_3
XFILLER_107_220 VGND VGND VPWR VPWR sky130_fd_sc_hd__decap_3
XFILLER_5_325 VGND VGND VPWR VPWR sky130_fd_sc_hd__decap_3
Xrebuffer452 _8189_/Q VGND VGND VPWR VPWR _4857_/B sky130_fd_sc_hd__buf_2
XFILLER_107_253 VGND VGND VPWR VPWR sky130_fd_sc_hd__decap_3
XFILLER_107_297 VGND VGND VPWR VPWR sky130_fd_sc_hd__decap_3
XFILLER_1_553 VGND VGND VPWR VPWR sky130_fd_sc_hd__decap_3
XFILLER_107_70 VGND VGND VPWR VPWR sky130_fd_sc_hd__decap_3
XFILLER_110_418 VGND VGND VPWR VPWR sky130_fd_sc_hd__fill_2
XFILLER_3_49 VGND VGND VPWR VPWR sky130_fd_sc_hd__decap_3
XFILLER_67_41 VGND VGND VPWR VPWR sky130_fd_sc_hd__decap_3
XFILLER_89_682 VGND VGND VPWR VPWR sky130_fd_sc_hd__fill_2
XFILLER_67_63 VGND VGND VPWR VPWR sky130_fd_sc_hd__decap_3
XFILLER_76_332 VGND VGND VPWR VPWR sky130_fd_sc_hd__decap_3
XFILLER_37_708 VGND VGND VPWR VPWR sky130_fd_sc_hd__fill_1
XFILLER_49_568 VGND VGND VPWR VPWR sky130_fd_sc_hd__decap_3
XFILLER_76_365 VGND VGND VPWR VPWR sky130_fd_sc_hd__decap_3
XFILLER_76_398 VGND VGND VPWR VPWR sky130_fd_sc_hd__decap_3
XFILLER_91_346 VGND VGND VPWR VPWR sky130_fd_sc_hd__decap_3
XFILLER_32_402 VGND VGND VPWR VPWR sky130_fd_sc_hd__decap_3
XFILLER_32_424 VGND VGND VPWR VPWR sky130_fd_sc_hd__decap_3
XFILLER_72_560 VGND VGND VPWR VPWR sky130_fd_sc_hd__decap_3
XFILLER_32_446 VGND VGND VPWR VPWR sky130_fd_sc_hd__decap_3
XFILLER_20_619 VGND VGND VPWR VPWR sky130_fd_sc_hd__decap_3
XFILLER_9_620 VGND VGND VPWR VPWR sky130_fd_sc_hd__decap_3
XFILLER_13_682 VGND VGND VPWR VPWR sky130_fd_sc_hd__decap_3
XFILLER_80_6 VGND VGND VPWR VPWR sky130_fd_sc_hd__decap_3
XTAP_TAPCELL_ROW_80_1296 VGND VPWR sky130_fd_sc_hd__tapvpwrvgnd_1
XTAP_TAPCELL_ROW_30_647 VGND VPWR sky130_fd_sc_hd__tapvpwrvgnd_1
XFILLER_118_529 VGND VGND VPWR VPWR sky130_fd_sc_hd__decap_3
XFILLER_8_141 VGND VGND VPWR VPWR sky130_fd_sc_hd__decap_3
XFILLER_8_185 VGND VGND VPWR VPWR sky130_fd_sc_hd__decap_3
XFILLER_59_3 VGND VGND VPWR VPWR sky130_fd_sc_hd__decap_3
XFILLER_99_402 VGND VGND VPWR VPWR sky130_fd_sc_hd__decap_3
XTAP_TAPCELL_ROW_10_393 VGND VPWR sky130_fd_sc_hd__tapvpwrvgnd_1
X_5370_ _6648_/A _5362_/X _5369_/X VGND VGND VPWR VPWR _5371_/B sky130_fd_sc_hd__o21bai_2
XFILLER_113_201 VGND VGND VPWR VPWR sky130_fd_sc_hd__decap_3
X_4321_ _4321_/A VGND VGND VPWR VPWR _8098_/D sky130_fd_sc_hd__buf_1
X_7040_ _8229_/Q _7039_/X _6011_/X VGND VGND VPWR VPWR _7040_/Y sky130_fd_sc_hd__o21ai_2
X_4252_ _7898_/B _4252_/B VGND VGND VPWR VPWR _4253_/A sky130_fd_sc_hd__and2_2
XFILLER_113_278 VGND VGND VPWR VPWR sky130_fd_sc_hd__fill_2
XFILLER_86_129 VGND VGND VPWR VPWR sky130_fd_sc_hd__decap_3
XFILLER_67_343 VGND VGND VPWR VPWR sky130_fd_sc_hd__decap_3
XFILLER_79_181 VGND VGND VPWR VPWR sky130_fd_sc_hd__decap_3
X_4183_ _4183_/A VGND VGND VPWR VPWR _8029_/D sky130_fd_sc_hd__buf_1
XFILLER_55_505 VGND VGND VPWR VPWR sky130_fd_sc_hd__decap_3
XFILLER_67_376 VGND VGND VPWR VPWR sky130_fd_sc_hd__decap_3
XFILLER_95_685 VGND VGND VPWR VPWR sky130_fd_sc_hd__decap_3
XFILLER_103_28 VGND VGND VPWR VPWR sky130_fd_sc_hd__fill_2
XFILLER_27_218 VGND VGND VPWR VPWR sky130_fd_sc_hd__decap_3
XFILLER_55_538 VGND VGND VPWR VPWR sky130_fd_sc_hd__decap_3
X_7942_ _8349_/CLK _7942_/D VGND VGND VPWR VPWR _7942_/Q sky130_fd_sc_hd__dfxtp_2
XTAP_TAPCELL_ROW_38_747 VGND VPWR sky130_fd_sc_hd__tapvpwrvgnd_1
XFILLER_82_368 VGND VGND VPWR VPWR sky130_fd_sc_hd__decap_3
XTAP_TAPCELL_ROW_38_758 VGND VPWR sky130_fd_sc_hd__tapvpwrvgnd_1
XFILLER_23_402 VGND VGND VPWR VPWR sky130_fd_sc_hd__decap_3
XFILLER_35_251 VGND VGND VPWR VPWR sky130_fd_sc_hd__decap_3
X_7873_ _7873_/A VGND VGND VPWR VPWR _8373_/D sky130_fd_sc_hd__buf_1
XFILLER_35_284 VGND VGND VPWR VPWR sky130_fd_sc_hd__decap_3
XFILLER_50_210 VGND VGND VPWR VPWR sky130_fd_sc_hd__decap_3
X_6824_ _6454_/A _6821_/X _6823_/X _6721_/A VGND VGND VPWR VPWR _6824_/X sky130_fd_sc_hd__a22o_2
XTAP_TAPCELL_ROW_18_493 VGND VPWR sky130_fd_sc_hd__tapvpwrvgnd_1
XFILLER_50_243 VGND VGND VPWR VPWR sky130_fd_sc_hd__fill_2
X_6755_ _8196_/Q _6716_/X _6754_/X VGND VGND VPWR VPWR _6757_/A sky130_fd_sc_hd__a21oi_2
X_3967_ _3967_/A VGND VGND VPWR VPWR _7932_/D sky130_fd_sc_hd__buf_1
XFILLER_50_287 VGND VGND VPWR VPWR sky130_fd_sc_hd__fill_1
XFILLER_50_298 VGND VGND VPWR VPWR sky130_fd_sc_hd__fill_2
X_5706_ _5585_/A _5699_/X _5705_/X _6769_/B VGND VGND VPWR VPWR _5706_/X sky130_fd_sc_hd__o22a_2
XFILLER_109_529 VGND VGND VPWR VPWR sky130_fd_sc_hd__decap_3
Xclkbuf_leaf_30_clk clkbuf_2_2__f_clk/X VGND VGND VPWR VPWR _8385_/CLK sky130_fd_sc_hd__clkbuf_8
X_6686_ _6686_/A _6686_/B _6686_/C VGND VGND VPWR VPWR _6686_/X sky130_fd_sc_hd__and3_2
XTAP_TAPCELL_ROW_98_1535 VGND VPWR sky130_fd_sc_hd__tapvpwrvgnd_1
X_5637_ _5392_/X _5448_/X _7555_/S VGND VGND VPWR VPWR _5637_/X sky130_fd_sc_hd__mux2_2
X_8356_ _8401_/CLK _8356_/D VGND VGND VPWR VPWR _8356_/Q sky130_fd_sc_hd__dfxtp_2
X_5568_ _5377_/X _5382_/X _5684_/S VGND VGND VPWR VPWR _5568_/X sky130_fd_sc_hd__mux2_2
XFILLER_104_212 VGND VGND VPWR VPWR sky130_fd_sc_hd__decap_3
XFILLER_2_306 VGND VGND VPWR VPWR sky130_fd_sc_hd__fill_2
XFILLER_2_317 VGND VGND VPWR VPWR sky130_fd_sc_hd__fill_1
XFILLER_2_328 VGND VGND VPWR VPWR sky130_fd_sc_hd__decap_3
X_8287_ _8287_/CLK _8287_/D VGND VGND VPWR VPWR _8287_/Q sky130_fd_sc_hd__dfxtp_2
X_7307_ _8213_/Q _7307_/B VGND VGND VPWR VPWR _7309_/A sky130_fd_sc_hd__nand2_2
X_4519_ _4519_/A VGND VGND VPWR VPWR _8197_/D sky130_fd_sc_hd__buf_1
XFILLER_104_245 VGND VGND VPWR VPWR sky130_fd_sc_hd__decap_3
XFILLER_104_256 VGND VGND VPWR VPWR sky130_fd_sc_hd__decap_3
X_7238_ _6650_/B _6107_/X _7193_/A VGND VGND VPWR VPWR _7238_/Y sky130_fd_sc_hd__o21ai_2
X_5499_ _5506_/A _6763_/B _5498_/X _8290_/Q VGND VGND VPWR VPWR _5499_/X sky130_fd_sc_hd__o22a_2
XFILLER_58_321 VGND VGND VPWR VPWR sky130_fd_sc_hd__decap_3
XFILLER_86_641 VGND VGND VPWR VPWR sky130_fd_sc_hd__decap_3
XFILLER_98_490 VGND VGND VPWR VPWR sky130_fd_sc_hd__decap_3
X_7169_ _7034_/Y _7168_/Y _7095_/B VGND VGND VPWR VPWR _7169_/Y sky130_fd_sc_hd__o21ai_2
XFILLER_100_440 VGND VGND VPWR VPWR sky130_fd_sc_hd__decap_3
XFILLER_100_462 VGND VGND VPWR VPWR sky130_fd_sc_hd__decap_3
XFILLER_58_354 VGND VGND VPWR VPWR sky130_fd_sc_hd__decap_3
XFILLER_85_151 VGND VGND VPWR VPWR sky130_fd_sc_hd__fill_2
XFILLER_86_663 VGND VGND VPWR VPWR sky130_fd_sc_hd__decap_3
XFILLER_37_44 VGND VGND VPWR VPWR sky130_fd_sc_hd__fill_1
XFILLER_58_398 VGND VGND VPWR VPWR sky130_fd_sc_hd__decap_3
XFILLER_61_508 VGND VGND VPWR VPWR sky130_fd_sc_hd__decap_3
XFILLER_73_368 VGND VGND VPWR VPWR sky130_fd_sc_hd__decap_3
XTAP_TAPCELL_ROW_107_1653 VGND VPWR sky130_fd_sc_hd__tapvpwrvgnd_1
XFILLER_26_251 VGND VGND VPWR VPWR sky130_fd_sc_hd__fill_1
XFILLER_26_262 VGND VGND VPWR VPWR sky130_fd_sc_hd__decap_3
XFILLER_14_424 VGND VGND VPWR VPWR sky130_fd_sc_hd__decap_3
XFILLER_14_468 VGND VGND VPWR VPWR sky130_fd_sc_hd__decap_3
XFILLER_53_87 VGND VGND VPWR VPWR sky130_fd_sc_hd__decap_3
XFILLER_10_641 VGND VGND VPWR VPWR sky130_fd_sc_hd__decap_3
XFILLER_6_601 VGND VGND VPWR VPWR sky130_fd_sc_hd__fill_2
Xclkbuf_leaf_21_clk clkload2/A VGND VGND VPWR VPWR _8400_/CLK sky130_fd_sc_hd__clkbuf_8
XFILLER_5_122 VGND VGND VPWR VPWR sky130_fd_sc_hd__fill_1
XFILLER_6_623 VGND VGND VPWR VPWR sky130_fd_sc_hd__decap_3
XFILLER_6_634 VGND VGND VPWR VPWR sky130_fd_sc_hd__decap_3
XFILLER_6_645 VGND VGND VPWR VPWR sky130_fd_sc_hd__decap_3
XTAP_TAPCELL_ROW_58_1007 VGND VPWR sky130_fd_sc_hd__tapvpwrvgnd_1
XFILLER_6_667 VGND VGND VPWR VPWR sky130_fd_sc_hd__decap_3
XTAP_TAPCELL_ROW_58_1018 VGND VPWR sky130_fd_sc_hd__tapvpwrvgnd_1
XFILLER_108_584 VGND VGND VPWR VPWR sky130_fd_sc_hd__decap_3
XFILLER_5_188 VGND VGND VPWR VPWR sky130_fd_sc_hd__fill_1
XFILLER_6_689 VGND VGND VPWR VPWR sky130_fd_sc_hd__decap_3
XTAP_TAPCELL_ROW_118_1793 VGND VPWR sky130_fd_sc_hd__tapvpwrvgnd_1
Xrebuffer293 _8170_/Q VGND VGND VPWR VPWR _5943_/B sky130_fd_sc_hd__buf_2
XFILLER_69_608 VGND VGND VPWR VPWR sky130_fd_sc_hd__decap_3
XFILLER_78_51 VGND VGND VPWR VPWR sky130_fd_sc_hd__decap_3
XFILLER_110_215 VGND VGND VPWR VPWR sky130_fd_sc_hd__decap_3
XFILLER_96_427 VGND VGND VPWR VPWR sky130_fd_sc_hd__decap_3
XFILLER_110_248 VGND VGND VPWR VPWR sky130_fd_sc_hd__decap_3
XFILLER_49_321 VGND VGND VPWR VPWR sky130_fd_sc_hd__decap_3
XFILLER_77_641 VGND VGND VPWR VPWR sky130_fd_sc_hd__decap_3
XFILLER_110_259 VGND VGND VPWR VPWR sky130_fd_sc_hd__decap_3
XFILLER_37_505 VGND VGND VPWR VPWR sky130_fd_sc_hd__decap_3
XFILLER_49_376 VGND VGND VPWR VPWR sky130_fd_sc_hd__decap_3
XFILLER_64_324 VGND VGND VPWR VPWR sky130_fd_sc_hd__decap_3
XFILLER_76_162 VGND VGND VPWR VPWR sky130_fd_sc_hd__decap_3
XFILLER_76_184 VGND VGND VPWR VPWR sky130_fd_sc_hd__decap_3
XFILLER_92_611 VGND VGND VPWR VPWR sky130_fd_sc_hd__decap_3
XFILLER_94_72 VGND VGND VPWR VPWR sky130_fd_sc_hd__decap_3
XFILLER_64_357 VGND VGND VPWR VPWR sky130_fd_sc_hd__decap_3
XFILLER_64_368 VGND VGND VPWR VPWR sky130_fd_sc_hd__decap_3
XFILLER_94_94 VGND VGND VPWR VPWR sky130_fd_sc_hd__decap_3
XTAP_TAPCELL_ROW_69_1158 VGND VPWR sky130_fd_sc_hd__tapvpwrvgnd_1
XFILLER_17_240 VGND VGND VPWR VPWR sky130_fd_sc_hd__decap_3
XFILLER_52_519 VGND VGND VPWR VPWR sky130_fd_sc_hd__decap_3
XFILLER_91_165 VGND VGND VPWR VPWR sky130_fd_sc_hd__decap_3
XFILLER_91_187 VGND VGND VPWR VPWR sky130_fd_sc_hd__decap_3
XTAP_TAPCELL_ROW_35_717 VGND VPWR sky130_fd_sc_hd__tapvpwrvgnd_1
XFILLER_17_284 VGND VGND VPWR VPWR sky130_fd_sc_hd__decap_3
X_4870_ _6592_/A _6592_/B _6792_/C _6592_/D VGND VGND VPWR VPWR _4888_/A sky130_fd_sc_hd__nand4_2
XTAP_TAPCELL_ROW_82_1325 VGND VPWR sky130_fd_sc_hd__tapvpwrvgnd_1
XFILLER_32_243 VGND VGND VPWR VPWR sky130_fd_sc_hd__decap_3
XFILLER_60_552 VGND VGND VPWR VPWR sky130_fd_sc_hd__decap_3
XTAP_TAPCELL_ROW_15_452 VGND VPWR sky130_fd_sc_hd__tapvpwrvgnd_1
XFILLER_20_416 VGND VGND VPWR VPWR sky130_fd_sc_hd__decap_3
XFILLER_20_427 VGND VGND VPWR VPWR sky130_fd_sc_hd__decap_3
XFILLER_32_287 VGND VGND VPWR VPWR sky130_fd_sc_hd__decap_3
XFILLER_60_585 VGND VGND VPWR VPWR sky130_fd_sc_hd__decap_3
X_6540_ _6533_/Y _6535_/Y _6539_/X VGND VGND VPWR VPWR _6555_/A sky130_fd_sc_hd__a21oi_2
XFILLER_13_490 VGND VGND VPWR VPWR sky130_fd_sc_hd__decap_3
XFILLER_9_461 VGND VGND VPWR VPWR sky130_fd_sc_hd__fill_2
Xclkbuf_leaf_12_clk clkload2/A VGND VGND VPWR VPWR _8349_/CLK sky130_fd_sc_hd__clkbuf_8
XFILLER_9_472 VGND VGND VPWR VPWR sky130_fd_sc_hd__fill_2
XFILLER_9_483 VGND VGND VPWR VPWR sky130_fd_sc_hd__decap_3
X_6471_ _6471_/A _6471_/B _6470_/X VGND VGND VPWR VPWR _6471_/X sky130_fd_sc_hd__or3b_4
X_8210_ _8229_/CLK _8210_/D VGND VGND VPWR VPWR _8210_/Q sky130_fd_sc_hd__dfxtp_2
X_5422_ _5422_/A VGND VGND VPWR VPWR _5422_/X sky130_fd_sc_hd__buf_1
X_8141_ _8280_/CLK _8141_/D VGND VGND VPWR VPWR _8141_/Q sky130_fd_sc_hd__dfxtp_2
Xoutput202 _7967_/Q VGND VGND VPWR VPWR result[9] sky130_fd_sc_hd__clkdlybuf4s25_1
X_5353_ _5149_/X _5145_/X _5384_/S VGND VGND VPWR VPWR _5353_/X sky130_fd_sc_hd__mux2_2
XFILLER_99_221 VGND VGND VPWR VPWR sky130_fd_sc_hd__decap_3
XFILLER_99_254 VGND VGND VPWR VPWR sky130_fd_sc_hd__decap_3
X_4304_ _7898_/B _4304_/B VGND VGND VPWR VPWR _4305_/A sky130_fd_sc_hd__and2_2
XTAP_TAPCELL_ROW_93_1465 VGND VPWR sky130_fd_sc_hd__tapvpwrvgnd_1
X_8072_ _8229_/CLK _8072_/D VGND VGND VPWR VPWR _8072_/Q sky130_fd_sc_hd__dfxtp_2
X_5284_ _5284_/A _5310_/B VGND VGND VPWR VPWR _5284_/X sky130_fd_sc_hd__or2_4
XFILLER_101_237 VGND VGND VPWR VPWR sky130_fd_sc_hd__decap_3
XFILLER_87_449 VGND VGND VPWR VPWR sky130_fd_sc_hd__decap_3
X_7023_ _8229_/Q _5863_/Y _7022_/Y _5857_/Y VGND VGND VPWR VPWR _7023_/X sky130_fd_sc_hd__a22o_2
X_4235_ _4235_/A VGND VGND VPWR VPWR _8055_/D sky130_fd_sc_hd__buf_1
XFILLER_114_27 VGND VGND VPWR VPWR sky130_fd_sc_hd__fill_1
XFILLER_114_38 VGND VGND VPWR VPWR sky130_fd_sc_hd__decap_3
X_4166_ _7843_/A _7953_/Q VGND VGND VPWR VPWR _4167_/A sky130_fd_sc_hd__and2_2
XFILLER_55_302 VGND VGND VPWR VPWR sky130_fd_sc_hd__decap_3
XFILLER_55_313 VGND VGND VPWR VPWR sky130_fd_sc_hd__decap_3
XFILLER_68_685 VGND VGND VPWR VPWR sky130_fd_sc_hd__decap_3
XFILLER_83_622 VGND VGND VPWR VPWR sky130_fd_sc_hd__decap_3
XFILLER_55_346 VGND VGND VPWR VPWR sky130_fd_sc_hd__decap_3
XFILLER_55_368 VGND VGND VPWR VPWR sky130_fd_sc_hd__decap_3
XFILLER_83_655 VGND VGND VPWR VPWR sky130_fd_sc_hd__decap_3
X_4097_ _4097_/A VGND VGND VPWR VPWR _7986_/D sky130_fd_sc_hd__buf_1
XFILLER_36_560 VGND VGND VPWR VPWR sky130_fd_sc_hd__decap_3
XFILLER_70_327 VGND VGND VPWR VPWR sky130_fd_sc_hd__decap_3
X_7925_ _7925_/A VGND VGND VPWR VPWR _8399_/D sky130_fd_sc_hd__buf_1
XFILLER_23_210 VGND VGND VPWR VPWR sky130_fd_sc_hd__decap_3
XFILLER_70_349 VGND VGND VPWR VPWR sky130_fd_sc_hd__fill_2
X_7856_ _8298_/Q _7930_/B VGND VGND VPWR VPWR _7857_/A sky130_fd_sc_hd__and2_2
X_6807_ _8261_/Q _6807_/B VGND VGND VPWR VPWR _6848_/C sky130_fd_sc_hd__nand2_2
XFILLER_23_287 VGND VGND VPWR VPWR sky130_fd_sc_hd__fill_2
XFILLER_23_46 VGND VGND VPWR VPWR sky130_fd_sc_hd__decap_3
XTAP_TAPCELL_ROW_102_1583 VGND VPWR sky130_fd_sc_hd__tapvpwrvgnd_1
X_7787_ _7787_/A _8194_/Q VGND VGND VPWR VPWR _7787_/Y sky130_fd_sc_hd__nand2_2
X_4999_ _8256_/Q _8192_/Q VGND VGND VPWR VPWR _6792_/A sky130_fd_sc_hd__or2b_2
XFILLER_109_304 VGND VGND VPWR VPWR sky130_fd_sc_hd__decap_3
X_6738_ _8259_/Q _6695_/B _6737_/X VGND VGND VPWR VPWR _6739_/B sky130_fd_sc_hd__o21ai_2
XFILLER_109_337 VGND VGND VPWR VPWR sky130_fd_sc_hd__decap_3
X_6669_ _6675_/B _6727_/C _6669_/C VGND VGND VPWR VPWR _6669_/X sky130_fd_sc_hd__and3_2
XFILLER_105_521 VGND VGND VPWR VPWR sky130_fd_sc_hd__decap_3
XFILLER_2_103 VGND VGND VPWR VPWR sky130_fd_sc_hd__decap_3
XFILLER_3_615 VGND VGND VPWR VPWR sky130_fd_sc_hd__fill_1
X_8339_ _8353_/CLK _8339_/D VGND VGND VPWR VPWR _8339_/Q sky130_fd_sc_hd__dfxtp_2
XFILLER_2_136 VGND VGND VPWR VPWR sky130_fd_sc_hd__fill_1
XFILLER_2_147 VGND VGND VPWR VPWR sky130_fd_sc_hd__decap_3
XFILLER_78_416 VGND VGND VPWR VPWR sky130_fd_sc_hd__decap_3
XFILLER_78_427 VGND VGND VPWR VPWR sky130_fd_sc_hd__decap_3
XFILLER_48_32 VGND VGND VPWR VPWR sky130_fd_sc_hd__decap_3
XFILLER_19_505 VGND VGND VPWR VPWR sky130_fd_sc_hd__decap_3
XFILLER_93_408 VGND VGND VPWR VPWR sky130_fd_sc_hd__decap_3
XFILLER_19_538 VGND VGND VPWR VPWR sky130_fd_sc_hd__decap_3
XFILLER_46_302 VGND VGND VPWR VPWR sky130_fd_sc_hd__decap_3
XFILLER_48_98 VGND VGND VPWR VPWR sky130_fd_sc_hd__fill_1
XFILLER_58_184 VGND VGND VPWR VPWR sky130_fd_sc_hd__decap_3
XFILLER_59_685 VGND VGND VPWR VPWR sky130_fd_sc_hd__decap_3
XFILLER_73_143 VGND VGND VPWR VPWR sky130_fd_sc_hd__decap_3
XFILLER_74_666 VGND VGND VPWR VPWR sky130_fd_sc_hd__decap_3
XFILLER_34_519 VGND VGND VPWR VPWR sky130_fd_sc_hd__decap_3
XFILLER_46_368 VGND VGND VPWR VPWR sky130_fd_sc_hd__fill_2
XFILLER_46_379 VGND VGND VPWR VPWR sky130_fd_sc_hd__decap_3
XFILLER_61_316 VGND VGND VPWR VPWR sky130_fd_sc_hd__decap_3
XFILLER_61_327 VGND VGND VPWR VPWR sky130_fd_sc_hd__decap_3
XFILLER_64_53 VGND VGND VPWR VPWR sky130_fd_sc_hd__fill_2
XFILLER_74_699 VGND VGND VPWR VPWR sky130_fd_sc_hd__fill_1
XFILLER_42_530 VGND VGND VPWR VPWR sky130_fd_sc_hd__fill_2
XFILLER_61_349 VGND VGND VPWR VPWR sky130_fd_sc_hd__decap_3
XFILLER_64_97 VGND VGND VPWR VPWR sky130_fd_sc_hd__fill_1
XFILLER_73_187 VGND VGND VPWR VPWR sky130_fd_sc_hd__decap_3
XFILLER_14_243 VGND VGND VPWR VPWR sky130_fd_sc_hd__fill_1
XFILLER_14_265 VGND VGND VPWR VPWR sky130_fd_sc_hd__decap_3
XFILLER_42_552 VGND VGND VPWR VPWR sky130_fd_sc_hd__decap_3
XFILLER_42_574 VGND VGND VPWR VPWR sky130_fd_sc_hd__decap_3
XFILLER_14_287 VGND VGND VPWR VPWR sky130_fd_sc_hd__decap_3
XFILLER_80_41 VGND VGND VPWR VPWR sky130_fd_sc_hd__decap_3
XTAP_TAPCELL_ROW_12_411 VGND VPWR sky130_fd_sc_hd__tapvpwrvgnd_1
XTAP_TAPCELL_ROW_64_1088 VGND VPWR sky130_fd_sc_hd__tapvpwrvgnd_1
XTAP_TAPCELL_ROW_40_775 VGND VPWR sky130_fd_sc_hd__tapvpwrvgnd_1
XFILLER_6_486 VGND VGND VPWR VPWR sky130_fd_sc_hd__decap_3
XFILLER_111_546 VGND VGND VPWR VPWR sky130_fd_sc_hd__decap_3
XFILLER_69_449 VGND VGND VPWR VPWR sky130_fd_sc_hd__decap_3
XFILLER_96_224 VGND VGND VPWR VPWR sky130_fd_sc_hd__decap_3
XFILLER_96_268 VGND VGND VPWR VPWR sky130_fd_sc_hd__fill_1
Xclkbuf_leaf_1_clk clkload0/A VGND VGND VPWR VPWR clkload4/A sky130_fd_sc_hd__clkbuf_8
X_4020_ _8320_/Q _8324_/Q _8326_/Q _8329_/Q VGND VGND VPWR VPWR _4021_/D sky130_fd_sc_hd__or4_2
XFILLER_37_324 VGND VGND VPWR VPWR sky130_fd_sc_hd__decap_3
XFILLER_49_162 VGND VGND VPWR VPWR sky130_fd_sc_hd__decap_3
XFILLER_49_184 VGND VGND VPWR VPWR sky130_fd_sc_hd__decap_3
XFILLER_77_471 VGND VGND VPWR VPWR sky130_fd_sc_hd__decap_3
XFILLER_65_655 VGND VGND VPWR VPWR sky130_fd_sc_hd__fill_1
XFILLER_92_430 VGND VGND VPWR VPWR sky130_fd_sc_hd__decap_3
XFILLER_37_379 VGND VGND VPWR VPWR sky130_fd_sc_hd__decap_3
X_5971_ _8239_/Q _5718_/X _5402_/X _5977_/A VGND VGND VPWR VPWR _5971_/X sky130_fd_sc_hd__a22o_2
XTAP_TAPCELL_ROW_48_886 VGND VPWR sky130_fd_sc_hd__tapvpwrvgnd_1
XFILLER_52_338 VGND VGND VPWR VPWR sky130_fd_sc_hd__decap_3
XFILLER_80_636 VGND VGND VPWR VPWR sky130_fd_sc_hd__decap_3
XFILLER_80_669 VGND VGND VPWR VPWR sky130_fd_sc_hd__decap_3
XFILLER_92_496 VGND VGND VPWR VPWR sky130_fd_sc_hd__decap_3
X_7710_ _8215_/Q _7663_/B _7660_/X VGND VGND VPWR VPWR _7710_/Y sky130_fd_sc_hd__o21ai_2
X_4922_ _6024_/B _8239_/Q VGND VGND VPWR VPWR _6039_/B sky130_fd_sc_hd__and2b_2
XFILLER_33_541 VGND VGND VPWR VPWR sky130_fd_sc_hd__decap_3
X_7641_ _7637_/Y _7638_/Y _5192_/A VGND VGND VPWR VPWR _7641_/X sky130_fd_sc_hd__a21o_2
XFILLER_100_29 VGND VGND VPWR VPWR sky130_fd_sc_hd__decap_3
XFILLER_20_224 VGND VGND VPWR VPWR sky130_fd_sc_hd__decap_3
XFILLER_33_585 VGND VGND VPWR VPWR sky130_fd_sc_hd__fill_1
X_4853_ _4851_/Y _4853_/B VGND VGND VPWR VPWR _6731_/A sky130_fd_sc_hd__and2b_2
X_7572_ _8284_/Q _7574_/B VGND VGND VPWR VPWR _7573_/D sky130_fd_sc_hd__or2_2
X_4784_ _8210_/Q VGND VGND VPWR VPWR _7233_/S sky130_fd_sc_hd__inv_2
X_6523_ _6592_/D _6523_/B VGND VGND VPWR VPWR _6523_/Y sky130_fd_sc_hd__nor2_2
XFILLER_119_679 VGND VGND VPWR VPWR sky130_fd_sc_hd__decap_3
X_6454_ _6454_/A _6454_/B VGND VGND VPWR VPWR _6454_/Y sky130_fd_sc_hd__nand2_2
X_5405_ _8163_/Q _5491_/C _5310_/A split/A _5286_/A _6199_/S1 VGND VGND VPWR VPWR
+ _6130_/C sky130_fd_sc_hd__mux4_2
X_6385_ _5358_/X _5381_/X _5362_/X _5355_/X _6708_/A _7745_/A VGND VGND VPWR VPWR
+ _6385_/X sky130_fd_sc_hd__mux4_2
XFILLER_87_202 VGND VGND VPWR VPWR sky130_fd_sc_hd__decap_3
XPHY_EDGE_ROW_10_Left_130 VGND VGND VPWR VPWR sky130_fd_sc_hd__decap_3
X_8124_ _8397_/CLK _8124_/D VGND VGND VPWR VPWR _8124_/Q sky130_fd_sc_hd__dfxtp_2
X_5336_ _5397_/A VGND VGND VPWR VPWR _5337_/A sky130_fd_sc_hd__buf_1
XFILLER_102_524 VGND VGND VPWR VPWR sky130_fd_sc_hd__fill_2
XFILLER_102_546 VGND VGND VPWR VPWR sky130_fd_sc_hd__decap_3
XFILLER_114_395 VGND VGND VPWR VPWR sky130_fd_sc_hd__decap_3
X_8055_ _8389_/CLK _8055_/D VGND VGND VPWR VPWR _8055_/Q sky130_fd_sc_hd__dfxtp_2
X_5267_ _5263_/X _5264_/X _5265_/X _5266_/X _7783_/A _5684_/S VGND VGND VPWR VPWR
+ _5267_/X sky130_fd_sc_hd__mux4_2
XFILLER_75_408 VGND VGND VPWR VPWR sky130_fd_sc_hd__decap_3
XFILLER_87_246 VGND VGND VPWR VPWR sky130_fd_sc_hd__decap_3
X_7006_ _8202_/Q _8203_/Q _7006_/C VGND VGND VPWR VPWR _7006_/X sky130_fd_sc_hd__and3_2
X_4218_ _7898_/B _4218_/B VGND VGND VPWR VPWR _4219_/A sky130_fd_sc_hd__and2_2
XFILLER_18_35 VGND VGND VPWR VPWR sky130_fd_sc_hd__decap_3
XFILLER_28_302 VGND VGND VPWR VPWR sky130_fd_sc_hd__decap_3
XFILLER_56_633 VGND VGND VPWR VPWR sky130_fd_sc_hd__decap_3
XFILLER_68_460 VGND VGND VPWR VPWR sky130_fd_sc_hd__decap_3
X_5198_ _5197_/B _5197_/C _5289_/A VGND VGND VPWR VPWR _5198_/Y sky130_fd_sc_hd__a21oi_2
X_4149_ _4149_/A VGND VGND VPWR VPWR _8012_/D sky130_fd_sc_hd__buf_1
XFILLER_18_79 VGND VGND VPWR VPWR sky130_fd_sc_hd__decap_3
XFILLER_28_368 VGND VGND VPWR VPWR sky130_fd_sc_hd__decap_3
XFILLER_43_316 VGND VGND VPWR VPWR sky130_fd_sc_hd__decap_3
XFILLER_55_154 VGND VGND VPWR VPWR sky130_fd_sc_hd__fill_2
XFILLER_56_688 VGND VGND VPWR VPWR sky130_fd_sc_hd__decap_3
XFILLER_71_625 VGND VGND VPWR VPWR sky130_fd_sc_hd__decap_3
XFILLER_83_485 VGND VGND VPWR VPWR sky130_fd_sc_hd__decap_3
XFILLER_24_530 VGND VGND VPWR VPWR sky130_fd_sc_hd__fill_2
XFILLER_43_349 VGND VGND VPWR VPWR sky130_fd_sc_hd__decap_3
XTAP_TAPCELL_ROW_104_1612 VGND VPWR sky130_fd_sc_hd__tapvpwrvgnd_1
X_7908_ _8324_/Q _7930_/B VGND VGND VPWR VPWR _7909_/A sky130_fd_sc_hd__and2_2
XFILLER_34_23 VGND VGND VPWR VPWR sky130_fd_sc_hd__decap_3
XFILLER_34_45 VGND VGND VPWR VPWR sky130_fd_sc_hd__decap_3
XFILLER_51_382 VGND VGND VPWR VPWR sky130_fd_sc_hd__decap_3
X_7839_ _8223_/Q _8287_/Q _5192_/A _7637_/Y _7838_/X VGND VGND VPWR VPWR _7839_/X
+ sky130_fd_sc_hd__o41a_4
XFILLER_11_246 VGND VGND VPWR VPWR sky130_fd_sc_hd__decap_3
XFILLER_51_393 VGND VGND VPWR VPWR sky130_fd_sc_hd__decap_3
XFILLER_8_707 VGND VGND VPWR VPWR sky130_fd_sc_hd__decap_3
XFILLER_50_11 VGND VGND VPWR VPWR sky130_fd_sc_hd__fill_2
XFILLER_50_22 VGND VGND VPWR VPWR sky130_fd_sc_hd__decap_3
XFILLER_7_206 VGND VGND VPWR VPWR sky130_fd_sc_hd__fill_1
Xclkload0 clkload0/A VGND VGND VPWR VPWR clkload0/Y sky130_fd_sc_hd__inv_8
XFILLER_109_134 VGND VGND VPWR VPWR sky130_fd_sc_hd__fill_2
XFILLER_50_44 VGND VGND VPWR VPWR sky130_fd_sc_hd__decap_3
XFILLER_109_178 VGND VGND VPWR VPWR sky130_fd_sc_hd__decap_3
XFILLER_3_412 VGND VGND VPWR VPWR sky130_fd_sc_hd__decap_3
XFILLER_50_88 VGND VGND VPWR VPWR sky130_fd_sc_hd__decap_3
XFILLER_3_445 VGND VGND VPWR VPWR sky130_fd_sc_hd__decap_3
XTAP_TAPCELL_ROW_115_1752 VGND VPWR sky130_fd_sc_hd__tapvpwrvgnd_1
XFILLER_105_340 VGND VGND VPWR VPWR sky130_fd_sc_hd__decap_3
XFILLER_105_362 VGND VGND VPWR VPWR sky130_fd_sc_hd__decap_3
XFILLER_3_467 VGND VGND VPWR VPWR sky130_fd_sc_hd__fill_2
XFILLER_59_31 VGND VGND VPWR VPWR sky130_fd_sc_hd__decap_3
XFILLER_105_384 VGND VGND VPWR VPWR sky130_fd_sc_hd__decap_3
XFILLER_78_224 VGND VGND VPWR VPWR sky130_fd_sc_hd__decap_3
XFILLER_78_268 VGND VGND VPWR VPWR sky130_fd_sc_hd__decap_3
XFILLER_19_313 VGND VGND VPWR VPWR sky130_fd_sc_hd__fill_2
XFILLER_47_600 VGND VGND VPWR VPWR sky130_fd_sc_hd__decap_3
XFILLER_19_335 VGND VGND VPWR VPWR sky130_fd_sc_hd__fill_1
XFILLER_19_346 VGND VGND VPWR VPWR sky130_fd_sc_hd__decap_3
XFILLER_46_110 VGND VGND VPWR VPWR sky130_fd_sc_hd__decap_3
XFILLER_74_430 VGND VGND VPWR VPWR sky130_fd_sc_hd__decap_3
XFILLER_75_52 VGND VGND VPWR VPWR sky130_fd_sc_hd__decap_3
XFILLER_19_379 VGND VGND VPWR VPWR sky130_fd_sc_hd__fill_1
XFILLER_34_305 VGND VGND VPWR VPWR sky130_fd_sc_hd__decap_3
XFILLER_46_165 VGND VGND VPWR VPWR sky130_fd_sc_hd__decap_3
XFILLER_75_96 VGND VGND VPWR VPWR sky130_fd_sc_hd__decap_3
XTAP_TAPCELL_ROW_66_1117 VGND VPWR sky130_fd_sc_hd__tapvpwrvgnd_1
XFILLER_34_327 VGND VGND VPWR VPWR sky130_fd_sc_hd__decap_3
XFILLER_61_102 VGND VGND VPWR VPWR sky130_fd_sc_hd__fill_1
XFILLER_61_113 VGND VGND VPWR VPWR sky130_fd_sc_hd__decap_3
XFILLER_62_658 VGND VGND VPWR VPWR sky130_fd_sc_hd__decap_3
XFILLER_74_496 VGND VGND VPWR VPWR sky130_fd_sc_hd__decap_3
XTAP_TAPCELL_ROW_45_845 VGND VPWR sky130_fd_sc_hd__tapvpwrvgnd_1
XFILLER_30_500 VGND VGND VPWR VPWR sky130_fd_sc_hd__fill_1
XFILLER_30_522 VGND VGND VPWR VPWR sky130_fd_sc_hd__decap_3
XFILLER_42_382 VGND VGND VPWR VPWR sky130_fd_sc_hd__decap_3
XFILLER_30_533 VGND VGND VPWR VPWR sky130_fd_sc_hd__decap_3
XTAP_TAPCELL_ROW_25_580 VGND VPWR sky130_fd_sc_hd__tapvpwrvgnd_1
XFILLER_6_250 VGND VGND VPWR VPWR sky130_fd_sc_hd__fill_2
XTAP_TAPCELL_ROW_77_1257 VGND VPWR sky130_fd_sc_hd__tapvpwrvgnd_1
XFILLER_69_202 VGND VGND VPWR VPWR sky130_fd_sc_hd__decap_3
XFILLER_97_511 VGND VGND VPWR VPWR sky130_fd_sc_hd__decap_3
X_6170_ _5458_/X _5465_/X _5460_/X _5466_/X _6130_/A _7745_/A VGND VGND VPWR VPWR
+ _6170_/X sky130_fd_sc_hd__mux4_2
XTAP_TAPCELL_ROW_90_1424 VGND VPWR sky130_fd_sc_hd__tapvpwrvgnd_1
XFILLER_111_321 VGND VGND VPWR VPWR sky130_fd_sc_hd__decap_3
XFILLER_97_522 VGND VGND VPWR VPWR sky130_fd_sc_hd__decap_3
X_5121_ _5121_/A VGND VGND VPWR VPWR _5785_/A sky130_fd_sc_hd__clkbuf_2
XTAP_TAPCELL_ROW_90_1435 VGND VPWR sky130_fd_sc_hd__tapvpwrvgnd_1
XFILLER_97_555 VGND VGND VPWR VPWR sky130_fd_sc_hd__decap_3
XFILLER_38_622 VGND VGND VPWR VPWR sky130_fd_sc_hd__decap_3
XFILLER_69_279 VGND VGND VPWR VPWR sky130_fd_sc_hd__fill_1
XFILLER_97_599 VGND VGND VPWR VPWR sky130_fd_sc_hd__decap_3
X_5052_ _5051_/Y _4864_/A _4858_/B VGND VGND VPWR VPWR _5053_/B sky130_fd_sc_hd__a21oi_2
XFILLER_65_441 VGND VGND VPWR VPWR sky130_fd_sc_hd__decap_3
XFILLER_77_290 VGND VGND VPWR VPWR sky130_fd_sc_hd__decap_3
XFILLER_84_238 VGND VGND VPWR VPWR sky130_fd_sc_hd__decap_3
X_4003_ _4003_/A VGND VGND VPWR VPWR _7950_/D sky130_fd_sc_hd__buf_1
XFILLER_37_165 VGND VGND VPWR VPWR sky130_fd_sc_hd__decap_3
XFILLER_38_688 VGND VGND VPWR VPWR sky130_fd_sc_hd__decap_3
XFILLER_65_463 VGND VGND VPWR VPWR sky130_fd_sc_hd__decap_3
XFILLER_111_17 VGND VGND VPWR VPWR sky130_fd_sc_hd__decap_3
XFILLER_25_349 VGND VGND VPWR VPWR sky130_fd_sc_hd__fill_1
XFILLER_52_124 VGND VGND VPWR VPWR sky130_fd_sc_hd__decap_3
XFILLER_53_647 VGND VGND VPWR VPWR sky130_fd_sc_hd__decap_3
XFILLER_65_496 VGND VGND VPWR VPWR sky130_fd_sc_hd__decap_3
XTAP_TAPCELL_ROW_88_1397 VGND VPWR sky130_fd_sc_hd__tapvpwrvgnd_1
XFILLER_52_157 VGND VGND VPWR VPWR sky130_fd_sc_hd__decap_3
XFILLER_80_455 VGND VGND VPWR VPWR sky130_fd_sc_hd__decap_3
XFILLER_80_477 VGND VGND VPWR VPWR sky130_fd_sc_hd__decap_3
X_5954_ _5477_/X _5952_/X _5953_/Y _6070_/B VGND VGND VPWR VPWR _5954_/X sky130_fd_sc_hd__a22o_2
XFILLER_21_511 VGND VGND VPWR VPWR sky130_fd_sc_hd__fill_1
XFILLER_33_382 VGND VGND VPWR VPWR sky130_fd_sc_hd__decap_3
X_5885_ _5029_/X _5883_/Y _5884_/X _4927_/A VGND VGND VPWR VPWR _5925_/B sky130_fd_sc_hd__a22o_2
X_4905_ _8177_/Q _8241_/Q VGND VGND VPWR VPWR _4907_/A sky130_fd_sc_hd__and2b_2
XFILLER_21_533 VGND VGND VPWR VPWR sky130_fd_sc_hd__decap_3
XFILLER_21_555 VGND VGND VPWR VPWR sky130_fd_sc_hd__decap_3
XFILLER_33_393 VGND VGND VPWR VPWR sky130_fd_sc_hd__decap_3
X_7624_ _7113_/X _7623_/X _6866_/X _7389_/X _5100_/A _6353_/B VGND VGND VPWR VPWR
+ _7624_/X sky130_fd_sc_hd__mux4_2
X_4836_ _8260_/Q _8196_/Q VGND VGND VPWR VPWR _5004_/B sky130_fd_sc_hd__nor2b_2
XFILLER_119_421 VGND VGND VPWR VPWR sky130_fd_sc_hd__decap_3
XFILLER_21_577 VGND VGND VPWR VPWR sky130_fd_sc_hd__decap_3
X_7555_ _7554_/X _7448_/X _7555_/S VGND VGND VPWR VPWR _7555_/X sky130_fd_sc_hd__mux2_2
Xrebuffer826 _6838_/C VGND VGND VPWR VPWR _6149_/B1 sky130_fd_sc_hd__buf_2
X_6506_ _6505_/X _6346_/X _7670_/A VGND VGND VPWR VPWR _6506_/X sky130_fd_sc_hd__mux2_2
X_4767_ _8279_/Q VGND VGND VPWR VPWR _4769_/B sky130_fd_sc_hd__inv_2
XFILLER_112_9 VGND VGND VPWR VPWR sky130_fd_sc_hd__fill_2
XFILLER_119_498 VGND VGND VPWR VPWR sky130_fd_sc_hd__decap_3
XFILLER_20_25 VGND VGND VPWR VPWR sky130_fd_sc_hd__decap_3
X_7486_ _7280_/B _7398_/X _7402_/X _8280_/Q VGND VGND VPWR VPWR _7486_/Y sky130_fd_sc_hd__a211oi_2
X_4698_ _7843_/A _8153_/Q VGND VGND VPWR VPWR _4699_/A sky130_fd_sc_hd__and2_2
X_6437_ _6434_/Y _6436_/X _8187_/Q VGND VGND VPWR VPWR _6437_/X sky130_fd_sc_hd__mux2_2
XFILLER_106_159 VGND VGND VPWR VPWR sky130_fd_sc_hd__decap_3
XFILLER_20_69 VGND VGND VPWR VPWR sky130_fd_sc_hd__fill_1
X_6368_ _8186_/Q _6368_/B VGND VGND VPWR VPWR _6368_/Y sky130_fd_sc_hd__nand2_2
XFILLER_102_321 VGND VGND VPWR VPWR sky130_fd_sc_hd__decap_3
XFILLER_96_29 VGND VGND VPWR VPWR sky130_fd_sc_hd__decap_3
X_8107_ _8379_/CLK _8107_/D VGND VGND VPWR VPWR _8107_/Q sky130_fd_sc_hd__dfxtp_2
X_5319_ _5319_/A VGND VGND VPWR VPWR _5817_/A sky130_fd_sc_hd__buf_1
XFILLER_102_332 VGND VGND VPWR VPWR sky130_fd_sc_hd__decap_3
XFILLER_29_12 VGND VGND VPWR VPWR sky130_fd_sc_hd__fill_2
XFILLER_48_408 VGND VGND VPWR VPWR sky130_fd_sc_hd__decap_3
X_6299_ _6299_/A _6299_/B _6046_/A VGND VGND VPWR VPWR _6300_/B sky130_fd_sc_hd__or3b_2
XFILLER_102_365 VGND VGND VPWR VPWR sky130_fd_sc_hd__decap_3
XFILLER_29_67 VGND VGND VPWR VPWR sky130_fd_sc_hd__fill_2
XFILLER_75_216 VGND VGND VPWR VPWR sky130_fd_sc_hd__decap_3
XTAP_TAPCELL_ROW_110_1693 VGND VPWR sky130_fd_sc_hd__tapvpwrvgnd_1
X_8038_ clkload9/A _8038_/D VGND VGND VPWR VPWR _8038_/Q sky130_fd_sc_hd__dfxtp_2
XFILLER_102_398 VGND VGND VPWR VPWR sky130_fd_sc_hd__decap_3
XFILLER_28_121 VGND VGND VPWR VPWR sky130_fd_sc_hd__fill_1
XFILLER_56_430 VGND VGND VPWR VPWR sky130_fd_sc_hd__decap_3
XFILLER_68_290 VGND VGND VPWR VPWR sky130_fd_sc_hd__decap_3
XFILLER_44_614 VGND VGND VPWR VPWR sky130_fd_sc_hd__decap_3
XFILLER_29_699 VGND VGND VPWR VPWR sky130_fd_sc_hd__decap_3
XFILLER_43_113 VGND VGND VPWR VPWR sky130_fd_sc_hd__decap_3
XFILLER_56_496 VGND VGND VPWR VPWR sky130_fd_sc_hd__decap_3
XFILLER_71_411 VGND VGND VPWR VPWR sky130_fd_sc_hd__decap_3
XFILLER_71_422 VGND VGND VPWR VPWR sky130_fd_sc_hd__decap_3
XFILLER_83_271 VGND VGND VPWR VPWR sky130_fd_sc_hd__fill_1
XTAP_TAPCELL_ROW_3_297 VGND VPWR sky130_fd_sc_hd__tapvpwrvgnd_1
XFILLER_45_66 VGND VGND VPWR VPWR sky130_fd_sc_hd__decap_3
XFILLER_71_455 VGND VGND VPWR VPWR sky130_fd_sc_hd__decap_3
XTAP_TAPCELL_ROW_42_804 VGND VPWR sky130_fd_sc_hd__tapvpwrvgnd_1
XFILLER_101_50 VGND VGND VPWR VPWR sky130_fd_sc_hd__decap_3
XFILLER_24_371 VGND VGND VPWR VPWR sky130_fd_sc_hd__decap_3
XFILLER_71_488 VGND VGND VPWR VPWR sky130_fd_sc_hd__decap_3
XFILLER_101_72 VGND VGND VPWR VPWR sky130_fd_sc_hd__fill_1
XFILLER_12_533 VGND VGND VPWR VPWR sky130_fd_sc_hd__decap_3
XFILLER_51_190 VGND VGND VPWR VPWR sky130_fd_sc_hd__decap_3
XFILLER_61_21 VGND VGND VPWR VPWR sky130_fd_sc_hd__decap_3
XFILLER_8_504 VGND VGND VPWR VPWR sky130_fd_sc_hd__decap_3
XTAP_TAPCELL_ROW_61_1047 VGND VPWR sky130_fd_sc_hd__tapvpwrvgnd_1
XTAP_TAPCELL_ROW_61_1058 VGND VPWR sky130_fd_sc_hd__tapvpwrvgnd_1
XTAP_TAPCELL_ROW_22_550 VGND VPWR sky130_fd_sc_hd__tapvpwrvgnd_1
XFILLER_61_87 VGND VGND VPWR VPWR sky130_fd_sc_hd__decap_3
XFILLER_8_548 VGND VGND VPWR VPWR sky130_fd_sc_hd__decap_3
XANTENNA_9 _4017_/A VGND VGND VPWR VPWR sky130_fd_sc_hd__diode_2
XFILLER_3_253 VGND VGND VPWR VPWR sky130_fd_sc_hd__decap_3
XFILLER_106_682 VGND VGND VPWR VPWR sky130_fd_sc_hd__fill_1
XFILLER_105_181 VGND VGND VPWR VPWR sky130_fd_sc_hd__decap_3
XFILLER_39_408 VGND VGND VPWR VPWR sky130_fd_sc_hd__decap_3
XFILLER_94_525 VGND VGND VPWR VPWR sky130_fd_sc_hd__decap_3
XFILLER_94_536 VGND VGND VPWR VPWR sky130_fd_sc_hd__fill_1
XTAP_TAPCELL_ROW_72_1198 VGND VPWR sky130_fd_sc_hd__tapvpwrvgnd_1
XFILLER_47_441 VGND VGND VPWR VPWR sky130_fd_sc_hd__decap_3
XFILLER_19_143 VGND VGND VPWR VPWR sky130_fd_sc_hd__decap_3
XFILLER_47_452 VGND VGND VPWR VPWR sky130_fd_sc_hd__decap_3
XFILLER_62_400 VGND VGND VPWR VPWR sky130_fd_sc_hd__decap_3
XFILLER_19_198 VGND VGND VPWR VPWR sky130_fd_sc_hd__decap_3
XFILLER_35_636 VGND VGND VPWR VPWR sky130_fd_sc_hd__decap_3
XFILLER_62_433 VGND VGND VPWR VPWR sky130_fd_sc_hd__decap_3
XFILLER_74_271 VGND VGND VPWR VPWR sky130_fd_sc_hd__decap_3
XFILLER_90_731 VGND VGND VPWR VPWR sky130_fd_sc_hd__fill_2
XFILLER_62_466 VGND VGND VPWR VPWR sky130_fd_sc_hd__decap_3
XFILLER_15_371 VGND VGND VPWR VPWR sky130_fd_sc_hd__decap_3
XFILLER_34_168 VGND VGND VPWR VPWR sky130_fd_sc_hd__decap_3
XFILLER_50_617 VGND VGND VPWR VPWR sky130_fd_sc_hd__decap_3
XFILLER_62_477 VGND VGND VPWR VPWR sky130_fd_sc_hd__decap_3
XFILLER_15_393 VGND VGND VPWR VPWR sky130_fd_sc_hd__fill_2
X_5670_ _5158_/X _5136_/X _7745_/A VGND VGND VPWR VPWR _5671_/B sky130_fd_sc_hd__mux2_2
XFILLER_30_341 VGND VGND VPWR VPWR sky130_fd_sc_hd__decap_3
X_4621_ _4621_/A VGND VGND VPWR VPWR _8248_/D sky130_fd_sc_hd__buf_1
XFILLER_30_396 VGND VGND VPWR VPWR sky130_fd_sc_hd__decap_3
XFILLER_116_413 VGND VGND VPWR VPWR sky130_fd_sc_hd__decap_3
X_7340_ _7398_/D _7340_/B VGND VGND VPWR VPWR _7340_/X sky130_fd_sc_hd__xor2_2
X_4552_ _7843_/A _8080_/Q VGND VGND VPWR VPWR _4553_/A sky130_fd_sc_hd__and2_2
XFILLER_116_424 VGND VGND VPWR VPWR sky130_fd_sc_hd__decap_3
Xmax_cap234 _5278_/X VGND VGND VPWR VPWR _5585_/A sky130_fd_sc_hd__buf_4
Xmax_cap223 _5714_/A VGND VGND VPWR VPWR _6804_/A sky130_fd_sc_hd__buf_4
Xmax_cap212 _5242_/X VGND VGND VPWR VPWR _7747_/A sky130_fd_sc_hd__clkbuf_8
X_7271_ _6706_/X _7270_/X _6420_/X _6978_/X _6536_/A _6355_/A VGND VGND VPWR VPWR
+ _7271_/X sky130_fd_sc_hd__mux4_2
X_4483_ _4483_/A VGND VGND VPWR VPWR _8179_/D sky130_fd_sc_hd__buf_1
XFILLER_116_468 VGND VGND VPWR VPWR sky130_fd_sc_hd__decap_3
Xmax_cap245 _8228_/Q VGND VGND VPWR VPWR _6620_/A sky130_fd_sc_hd__buf_12
X_6222_ _8245_/Q _6210_/X _6221_/X VGND VGND VPWR VPWR _6222_/X sky130_fd_sc_hd__o21a_4
XFILLER_106_17 VGND VGND VPWR VPWR sky130_fd_sc_hd__decap_3
XFILLER_112_663 VGND VGND VPWR VPWR sky130_fd_sc_hd__decap_3
XFILLER_58_717 VGND VGND VPWR VPWR sky130_fd_sc_hd__decap_3
X_6153_ _8180_/Q VGND VGND VPWR VPWR _6192_/A sky130_fd_sc_hd__inv_2
XFILLER_57_216 VGND VGND VPWR VPWR sky130_fd_sc_hd__decap_3
XFILLER_85_514 VGND VGND VPWR VPWR sky130_fd_sc_hd__fill_2
X_6084_ _6084_/A _6084_/B VGND VGND VPWR VPWR _6084_/Y sky130_fd_sc_hd__xnor2_2
X_5104_ _6070_/A _7626_/A VGND VGND VPWR VPWR _5832_/A sky130_fd_sc_hd__nand2_2
XFILLER_85_536 VGND VGND VPWR VPWR sky130_fd_sc_hd__decap_3
X_5035_ _8239_/Q _5032_/X _5034_/X VGND VGND VPWR VPWR _5035_/X sky130_fd_sc_hd__a21o_2
XFILLER_26_614 VGND VGND VPWR VPWR sky130_fd_sc_hd__fill_1
XFILLER_38_441 VGND VGND VPWR VPWR sky130_fd_sc_hd__decap_3
XFILLER_53_411 VGND VGND VPWR VPWR sky130_fd_sc_hd__decap_3
XFILLER_65_293 VGND VGND VPWR VPWR sky130_fd_sc_hd__decap_3
XFILLER_93_591 VGND VGND VPWR VPWR sky130_fd_sc_hd__fill_1
XTAP_TAPCELL_ROW_0_245 VGND VPWR sky130_fd_sc_hd__tapvpwrvgnd_1
XFILLER_26_669 VGND VGND VPWR VPWR sky130_fd_sc_hd__fill_1
XFILLER_41_606 VGND VGND VPWR VPWR sky130_fd_sc_hd__fill_2
XFILLER_53_444 VGND VGND VPWR VPWR sky130_fd_sc_hd__decap_3
XFILLER_53_455 VGND VGND VPWR VPWR sky130_fd_sc_hd__decap_3
XTAP_TAPCELL_ROW_0_256 VGND VPWR sky130_fd_sc_hd__tapvpwrvgnd_1
X_6986_ _8267_/Q _5422_/X _6985_/X _8290_/Q _7453_/A VGND VGND VPWR VPWR _6986_/X
+ sky130_fd_sc_hd__a221o_2
XFILLER_13_308 VGND VGND VPWR VPWR sky130_fd_sc_hd__decap_3
XFILLER_40_116 VGND VGND VPWR VPWR sky130_fd_sc_hd__fill_1
XFILLER_41_639 VGND VGND VPWR VPWR sky130_fd_sc_hd__fill_1
XFILLER_80_274 VGND VGND VPWR VPWR sky130_fd_sc_hd__decap_3
X_5937_ _7767_/B _8238_/Q _6767_/A VGND VGND VPWR VPWR _5937_/Y sky130_fd_sc_hd__a21oi_2
XFILLER_21_352 VGND VGND VPWR VPWR sky130_fd_sc_hd__decap_3
X_7607_ _8221_/Q _7231_/A _7562_/B _7646_/A VGND VGND VPWR VPWR _7607_/X sky130_fd_sc_hd__a31o_2
X_5868_ _5868_/A _5868_/B _5868_/C VGND VGND VPWR VPWR _5868_/X sky130_fd_sc_hd__and3_4
XFILLER_21_396 VGND VGND VPWR VPWR sky130_fd_sc_hd__decap_3
X_5799_ _8234_/Q _5791_/Y _7776_/B VGND VGND VPWR VPWR _5799_/X sky130_fd_sc_hd__o21a_2
X_4819_ _8202_/Q _6967_/A VGND VGND VPWR VPWR _7151_/B sky130_fd_sc_hd__nand2_2
XFILLER_107_402 VGND VGND VPWR VPWR sky130_fd_sc_hd__decap_3
X_7538_ _7535_/X _7537_/X _8220_/Q VGND VGND VPWR VPWR _7538_/X sky130_fd_sc_hd__mux2_2
XFILLER_107_446 VGND VGND VPWR VPWR sky130_fd_sc_hd__fill_2
XFILLER_119_284 VGND VGND VPWR VPWR sky130_fd_sc_hd__decap_3
XFILLER_31_79 VGND VGND VPWR VPWR sky130_fd_sc_hd__decap_3
X_7469_ _7619_/A _7466_/X _7468_/X VGND VGND VPWR VPWR _7469_/X sky130_fd_sc_hd__a21o_2
XFILLER_107_479 VGND VGND VPWR VPWR sky130_fd_sc_hd__fill_1
XTAP_TAPCELL_ROW_112_1711 VGND VPWR sky130_fd_sc_hd__tapvpwrvgnd_1
XFILLER_0_201 VGND VGND VPWR VPWR sky130_fd_sc_hd__fill_2
XFILLER_115_490 VGND VGND VPWR VPWR sky130_fd_sc_hd__fill_1
Xinput102 operand_b[39] VGND VGND VPWR VPWR _4382_/B sky130_fd_sc_hd__clkdlybuf4s25_1
XTAP_TAPCELL_ROW_8_367 VGND VPWR sky130_fd_sc_hd__tapvpwrvgnd_1
XFILLER_0_256 VGND VGND VPWR VPWR sky130_fd_sc_hd__decap_3
XFILLER_102_162 VGND VGND VPWR VPWR sky130_fd_sc_hd__decap_3
XFILLER_76_503 VGND VGND VPWR VPWR sky130_fd_sc_hd__decap_3
XFILLER_76_525 VGND VGND VPWR VPWR sky130_fd_sc_hd__decap_3
XFILLER_88_374 VGND VGND VPWR VPWR sky130_fd_sc_hd__decap_3
XFILLER_88_385 VGND VGND VPWR VPWR sky130_fd_sc_hd__decap_3
Xinput113 operand_b[49] VGND VGND VPWR VPWR _4402_/B sky130_fd_sc_hd__clkdlybuf4s25_1
Xinput135 valid_in VGND VGND VPWR VPWR _4442_/B sky130_fd_sc_hd__clkdlybuf4s25_1
Xinput124 operand_b[59] VGND VGND VPWR VPWR _4422_/B sky130_fd_sc_hd__clkdlybuf4s25_1
XFILLER_102_195 VGND VGND VPWR VPWR sky130_fd_sc_hd__fill_1
XFILLER_48_227 VGND VGND VPWR VPWR sky130_fd_sc_hd__decap_3
XFILLER_76_536 VGND VGND VPWR VPWR sky130_fd_sc_hd__decap_3
XFILLER_29_441 VGND VGND VPWR VPWR sky130_fd_sc_hd__decap_3
XFILLER_56_43 VGND VGND VPWR VPWR sky130_fd_sc_hd__decap_3
XFILLER_91_528 VGND VGND VPWR VPWR sky130_fd_sc_hd__decap_3
XFILLER_56_282 VGND VGND VPWR VPWR sky130_fd_sc_hd__decap_3
XFILLER_56_76 VGND VGND VPWR VPWR sky130_fd_sc_hd__decap_3
XFILLER_16_124 VGND VGND VPWR VPWR sky130_fd_sc_hd__decap_3
XFILLER_44_433 VGND VGND VPWR VPWR sky130_fd_sc_hd__decap_3
XFILLER_44_466 VGND VGND VPWR VPWR sky130_fd_sc_hd__fill_1
XPHY_EDGE_ROW_19_Right_19 VGND VGND VPWR VPWR sky130_fd_sc_hd__decap_3
XFILLER_16_168 VGND VGND VPWR VPWR sky130_fd_sc_hd__decap_3
XFILLER_25_680 VGND VGND VPWR VPWR sky130_fd_sc_hd__decap_3
XFILLER_31_116 VGND VGND VPWR VPWR sky130_fd_sc_hd__fill_1
XFILLER_32_617 VGND VGND VPWR VPWR sky130_fd_sc_hd__fill_1
XFILLER_32_639 VGND VGND VPWR VPWR sky130_fd_sc_hd__decap_3
XFILLER_44_477 VGND VGND VPWR VPWR sky130_fd_sc_hd__decap_3
XFILLER_71_274 VGND VGND VPWR VPWR sky130_fd_sc_hd__decap_3
XTAP_TAPCELL_ROW_55_973 VGND VPWR sky130_fd_sc_hd__tapvpwrvgnd_1
XFILLER_31_149 VGND VGND VPWR VPWR sky130_fd_sc_hd__decap_3
XFILLER_71_296 VGND VGND VPWR VPWR sky130_fd_sc_hd__decap_3
XFILLER_12_374 VGND VGND VPWR VPWR sky130_fd_sc_hd__fill_2
XFILLER_12_385 VGND VGND VPWR VPWR sky130_fd_sc_hd__decap_3
XFILLER_8_323 VGND VGND VPWR VPWR sky130_fd_sc_hd__decap_3
XFILLER_99_606 VGND VGND VPWR VPWR sky130_fd_sc_hd__fill_2
XFILLER_99_617 VGND VGND VPWR VPWR sky130_fd_sc_hd__fill_1
XPHY_EDGE_ROW_28_Right_28 VGND VGND VPWR VPWR sky130_fd_sc_hd__decap_3
XTAP_TAPCELL_ROW_74_1227 VGND VPWR sky130_fd_sc_hd__tapvpwrvgnd_1
XTAP_TAPCELL_ROW_74_1216 VGND VPWR sky130_fd_sc_hd__tapvpwrvgnd_1
XFILLER_113_416 VGND VGND VPWR VPWR sky130_fd_sc_hd__decap_3
XFILLER_97_50 VGND VGND VPWR VPWR sky130_fd_sc_hd__decap_3
XFILLER_106_490 VGND VGND VPWR VPWR sky130_fd_sc_hd__decap_3
XFILLER_113_449 VGND VGND VPWR VPWR sky130_fd_sc_hd__decap_3
XFILLER_79_330 VGND VGND VPWR VPWR sky130_fd_sc_hd__decap_3
XFILLER_67_503 VGND VGND VPWR VPWR sky130_fd_sc_hd__fill_1
XFILLER_79_363 VGND VGND VPWR VPWR sky130_fd_sc_hd__decap_3
XFILLER_39_249 VGND VGND VPWR VPWR sky130_fd_sc_hd__decap_3
XFILLER_67_536 VGND VGND VPWR VPWR sky130_fd_sc_hd__decap_3
XFILLER_79_396 VGND VGND VPWR VPWR sky130_fd_sc_hd__decap_3
XFILLER_94_344 VGND VGND VPWR VPWR sky130_fd_sc_hd__fill_1
XFILLER_82_506 VGND VGND VPWR VPWR sky130_fd_sc_hd__decap_3
XFILLER_94_355 VGND VGND VPWR VPWR sky130_fd_sc_hd__fill_1
XFILLER_35_411 VGND VGND VPWR VPWR sky130_fd_sc_hd__decap_3
XPHY_EDGE_ROW_37_Right_37 VGND VGND VPWR VPWR sky130_fd_sc_hd__decap_3
XFILLER_35_444 VGND VGND VPWR VPWR sky130_fd_sc_hd__decap_3
X_6840_ _8198_/Q _6900_/C VGND VGND VPWR VPWR _6840_/X sky130_fd_sc_hd__and2_2
XFILLER_23_617 VGND VGND VPWR VPWR sky130_fd_sc_hd__decap_3
XFILLER_62_274 VGND VGND VPWR VPWR sky130_fd_sc_hd__decap_3
X_6771_ _8195_/Q _8196_/Q _6771_/C VGND VGND VPWR VPWR _6839_/B sky130_fd_sc_hd__or3_4
XTAP_TAPCELL_ROW_85_1367 VGND VPWR sky130_fd_sc_hd__tapvpwrvgnd_1
XFILLER_22_138 VGND VGND VPWR VPWR sky130_fd_sc_hd__fill_2
XFILLER_50_436 VGND VGND VPWR VPWR sky130_fd_sc_hd__decap_3
X_5722_ _6769_/A _7783_/B _5721_/Y _6121_/B _5027_/A VGND VGND VPWR VPWR _5722_/X
+ sky130_fd_sc_hd__a32o_2
X_3983_ _3983_/A VGND VGND VPWR VPWR _7940_/D sky130_fd_sc_hd__buf_1
XFILLER_31_683 VGND VGND VPWR VPWR sky130_fd_sc_hd__fill_1
X_5653_ _8164_/Q _4958_/A _5548_/A VGND VGND VPWR VPWR _5656_/D sky130_fd_sc_hd__a21oi_2
XTAP_TAPCELL_ROW_33_689 VGND VPWR sky130_fd_sc_hd__tapvpwrvgnd_1
XFILLER_30_193 VGND VGND VPWR VPWR sky130_fd_sc_hd__decap_3
XPHY_EDGE_ROW_46_Right_46 VGND VGND VPWR VPWR sky130_fd_sc_hd__decap_3
X_8372_ _8386_/CLK _8372_/D VGND VGND VPWR VPWR _8372_/Q sky130_fd_sc_hd__dfxtp_2
X_5584_ _5584_/A _5584_/B VGND VGND VPWR VPWR _5690_/C sky130_fd_sc_hd__nor2_2
X_4604_ _7898_/B _8106_/Q VGND VGND VPWR VPWR _4605_/A sky130_fd_sc_hd__and2_2
X_7323_ _7193_/A _7322_/X _7626_/A VGND VGND VPWR VPWR _7323_/X sky130_fd_sc_hd__o21a_2
X_4535_ _4535_/A VGND VGND VPWR VPWR _8205_/D sky130_fd_sc_hd__buf_1
XFILLER_117_27 VGND VGND VPWR VPWR sky130_fd_sc_hd__decap_3
XFILLER_104_427 VGND VGND VPWR VPWR sky130_fd_sc_hd__decap_3
XFILLER_116_265 VGND VGND VPWR VPWR sky130_fd_sc_hd__fill_1
X_7254_ _7255_/B _7254_/A2 _7255_/A VGND VGND VPWR VPWR _7254_/Y sky130_fd_sc_hd__a21oi_2
X_4466_ _7898_/B _8037_/Q VGND VGND VPWR VPWR _4467_/A sky130_fd_sc_hd__and2_2
X_7185_ _7221_/B _5093_/X _5600_/A _8209_/Q VGND VGND VPWR VPWR _7185_/X sky130_fd_sc_hd__o22a_2
X_6205_ _6109_/A _6204_/X _5186_/A VGND VGND VPWR VPWR _6205_/Y sky130_fd_sc_hd__o21ai_2
X_4397_ _4397_/A VGND VGND VPWR VPWR _8136_/D sky130_fd_sc_hd__buf_1
XFILLER_100_611 VGND VGND VPWR VPWR sky130_fd_sc_hd__decap_3
XFILLER_85_300 VGND VGND VPWR VPWR sky130_fd_sc_hd__fill_1
XFILLER_98_661 VGND VGND VPWR VPWR sky130_fd_sc_hd__decap_3
X_6136_ _6132_/X _6134_/Y _6135_/X _6109_/A VGND VGND VPWR VPWR _6136_/Y sky130_fd_sc_hd__a22oi_2
XTAP_TAPCELL_ROW_5_326 VGND VPWR sky130_fd_sc_hd__tapvpwrvgnd_1
XFILLER_100_622 VGND VGND VPWR VPWR sky130_fd_sc_hd__decap_3
XFILLER_58_536 VGND VGND VPWR VPWR sky130_fd_sc_hd__fill_1
XFILLER_58_558 VGND VGND VPWR VPWR sky130_fd_sc_hd__decap_3
XFILLER_97_193 VGND VGND VPWR VPWR sky130_fd_sc_hd__decap_3
XFILLER_100_666 VGND VGND VPWR VPWR sky130_fd_sc_hd__decap_3
XFILLER_58_569 VGND VGND VPWR VPWR sky130_fd_sc_hd__decap_3
XFILLER_85_366 VGND VGND VPWR VPWR sky130_fd_sc_hd__decap_3
XFILLER_85_377 VGND VGND VPWR VPWR sky130_fd_sc_hd__decap_3
XPHY_EDGE_ROW_55_Right_55 VGND VGND VPWR VPWR sky130_fd_sc_hd__decap_3
X_6067_ _6353_/A _8223_/Q VGND VGND VPWR VPWR _6067_/Y sky130_fd_sc_hd__nand2_2
XFILLER_85_399 VGND VGND VPWR VPWR sky130_fd_sc_hd__decap_3
X_5018_ _5598_/D _8230_/Q _5016_/Y _5528_/A _5017_/Y VGND VGND VPWR VPWR _5018_/X
+ sky130_fd_sc_hd__o221a_2
XFILLER_26_433 VGND VGND VPWR VPWR sky130_fd_sc_hd__decap_3
XFILLER_81_550 VGND VGND VPWR VPWR sky130_fd_sc_hd__decap_3
XFILLER_26_477 VGND VGND VPWR VPWR sky130_fd_sc_hd__decap_3
XFILLER_26_499 VGND VGND VPWR VPWR sky130_fd_sc_hd__decap_3
XFILLER_53_252 VGND VGND VPWR VPWR sky130_fd_sc_hd__decap_3
XFILLER_81_561 VGND VGND VPWR VPWR sky130_fd_sc_hd__decap_3
XFILLER_13_138 VGND VGND VPWR VPWR sky130_fd_sc_hd__decap_3
XFILLER_41_436 VGND VGND VPWR VPWR sky130_fd_sc_hd__decap_3
XFILLER_41_458 VGND VGND VPWR VPWR sky130_fd_sc_hd__decap_3
X_6969_ _8266_/Q _6963_/B _4817_/A VGND VGND VPWR VPWR _6969_/X sky130_fd_sc_hd__a21o_2
XTAP_TAPCELL_ROW_52_932 VGND VPWR sky130_fd_sc_hd__tapvpwrvgnd_1
XFILLER_42_23 VGND VGND VPWR VPWR sky130_fd_sc_hd__decap_3
XFILLER_21_160 VGND VGND VPWR VPWR sky130_fd_sc_hd__decap_3
XFILLER_22_672 VGND VGND VPWR VPWR sky130_fd_sc_hd__fill_1
XPHY_EDGE_ROW_64_Right_64 VGND VGND VPWR VPWR sky130_fd_sc_hd__decap_3
XFILLER_21_182 VGND VGND VPWR VPWR sky130_fd_sc_hd__decap_3
XFILLER_5_337 VGND VGND VPWR VPWR sky130_fd_sc_hd__decap_3
Xrebuffer453 _6549_/C VGND VGND VPWR VPWR _6712_/B sky130_fd_sc_hd__buf_2
Xrebuffer442 _6967_/B VGND VGND VPWR VPWR _6935_/B sky130_fd_sc_hd__buf_2
XPHY_EDGE_ROW_2_Left_122 VGND VGND VPWR VPWR sky130_fd_sc_hd__decap_3
XPHY_EDGE_ROW_39_Left_159 VGND VGND VPWR VPWR sky130_fd_sc_hd__decap_3
XFILLER_107_265 VGND VGND VPWR VPWR sky130_fd_sc_hd__decap_3
XFILLER_107_287 VGND VGND VPWR VPWR sky130_fd_sc_hd__fill_1
XFILLER_96_609 VGND VGND VPWR VPWR sky130_fd_sc_hd__decap_3
XFILLER_49_514 VGND VGND VPWR VPWR sky130_fd_sc_hd__decap_3
XFILLER_67_20 VGND VGND VPWR VPWR sky130_fd_sc_hd__decap_3
XFILLER_95_108 VGND VGND VPWR VPWR sky130_fd_sc_hd__decap_3
XFILLER_95_119 VGND VGND VPWR VPWR sky130_fd_sc_hd__fill_2
XFILLER_49_525 VGND VGND VPWR VPWR sky130_fd_sc_hd__decap_3
XFILLER_67_53 VGND VGND VPWR VPWR sky130_fd_sc_hd__decap_3
XFILLER_67_75 VGND VGND VPWR VPWR sky130_fd_sc_hd__decap_3
XFILLER_76_322 VGND VGND VPWR VPWR sky130_fd_sc_hd__decap_3
XFILLER_88_171 VGND VGND VPWR VPWR sky130_fd_sc_hd__decap_3
XPHY_EDGE_ROW_73_Right_73 VGND VGND VPWR VPWR sky130_fd_sc_hd__decap_3
XFILLER_76_355 VGND VGND VPWR VPWR sky130_fd_sc_hd__fill_1
XFILLER_91_303 VGND VGND VPWR VPWR sky130_fd_sc_hd__decap_3
XFILLER_29_271 VGND VGND VPWR VPWR sky130_fd_sc_hd__decap_3
XFILLER_57_591 VGND VGND VPWR VPWR sky130_fd_sc_hd__decap_3
XFILLER_64_539 VGND VGND VPWR VPWR sky130_fd_sc_hd__decap_3
XFILLER_17_455 VGND VGND VPWR VPWR sky130_fd_sc_hd__decap_3
XFILLER_83_41 VGND VGND VPWR VPWR sky130_fd_sc_hd__decap_3
XFILLER_91_369 VGND VGND VPWR VPWR sky130_fd_sc_hd__decap_3
XPHY_EDGE_ROW_48_Left_168 VGND VGND VPWR VPWR sky130_fd_sc_hd__decap_3
XFILLER_32_414 VGND VGND VPWR VPWR sky130_fd_sc_hd__decap_3
XFILLER_44_274 VGND VGND VPWR VPWR sky130_fd_sc_hd__decap_3
XFILLER_60_701 VGND VGND VPWR VPWR sky130_fd_sc_hd__decap_3
XFILLER_72_583 VGND VGND VPWR VPWR sky130_fd_sc_hd__fill_1
XFILLER_83_63 VGND VGND VPWR VPWR sky130_fd_sc_hd__decap_3
XFILLER_32_436 VGND VGND VPWR VPWR sky130_fd_sc_hd__fill_2
XFILLER_44_296 VGND VGND VPWR VPWR sky130_fd_sc_hd__decap_3
XFILLER_32_458 VGND VGND VPWR VPWR sky130_fd_sc_hd__decap_3
XFILLER_32_469 VGND VGND VPWR VPWR sky130_fd_sc_hd__decap_3
XPHY_EDGE_ROW_82_Right_82 VGND VGND VPWR VPWR sky130_fd_sc_hd__decap_3
XFILLER_12_171 VGND VGND VPWR VPWR sky130_fd_sc_hd__decap_3
XFILLER_40_480 VGND VGND VPWR VPWR sky130_fd_sc_hd__decap_3
XFILLER_9_632 VGND VGND VPWR VPWR sky130_fd_sc_hd__decap_3
XFILLER_73_6 VGND VGND VPWR VPWR sky130_fd_sc_hd__decap_3
XFILLER_8_153 VGND VGND VPWR VPWR sky130_fd_sc_hd__fill_1
XFILLER_9_654 VGND VGND VPWR VPWR sky130_fd_sc_hd__fill_1
XTAP_TAPCELL_ROW_80_1297 VGND VPWR sky130_fd_sc_hd__tapvpwrvgnd_1
XTAP_TAPCELL_ROW_30_648 VGND VPWR sky130_fd_sc_hd__tapvpwrvgnd_1
XFILLER_8_197 VGND VGND VPWR VPWR sky130_fd_sc_hd__decap_3
XPHY_EDGE_ROW_57_Left_177 VGND VGND VPWR VPWR sky130_fd_sc_hd__decap_3
XTAP_TAPCELL_ROW_10_383 VGND VPWR sky130_fd_sc_hd__tapvpwrvgnd_1
XTAP_TAPCELL_ROW_10_394 VGND VPWR sky130_fd_sc_hd__tapvpwrvgnd_1
XFILLER_114_714 VGND VGND VPWR VPWR sky130_fd_sc_hd__fill_2
XFILLER_99_414 VGND VGND VPWR VPWR sky130_fd_sc_hd__decap_3
X_4320_ _7898_/B _4320_/B VGND VGND VPWR VPWR _4321_/A sky130_fd_sc_hd__and2_2
X_4251_ _4251_/A VGND VGND VPWR VPWR _8063_/D sky130_fd_sc_hd__buf_1
XFILLER_101_419 VGND VGND VPWR VPWR sky130_fd_sc_hd__decap_3
XFILLER_113_257 VGND VGND VPWR VPWR sky130_fd_sc_hd__decap_3
XFILLER_79_160 VGND VGND VPWR VPWR sky130_fd_sc_hd__decap_3
XPHY_EDGE_ROW_91_Right_91 VGND VGND VPWR VPWR sky130_fd_sc_hd__decap_3
XFILLER_67_322 VGND VGND VPWR VPWR sky130_fd_sc_hd__decap_3
XFILLER_95_631 VGND VGND VPWR VPWR sky130_fd_sc_hd__decap_3
X_4182_ _7898_/B _4182_/B VGND VGND VPWR VPWR _4183_/A sky130_fd_sc_hd__and2_2
XFILLER_67_355 VGND VGND VPWR VPWR sky130_fd_sc_hd__decap_3
XFILLER_94_141 VGND VGND VPWR VPWR sky130_fd_sc_hd__decap_3
XFILLER_67_388 VGND VGND VPWR VPWR sky130_fd_sc_hd__decap_3
XFILLER_67_399 VGND VGND VPWR VPWR sky130_fd_sc_hd__decap_3
XPHY_EDGE_ROW_66_Left_186 VGND VGND VPWR VPWR sky130_fd_sc_hd__decap_3
X_7941_ _8355_/CLK _7941_/D VGND VGND VPWR VPWR _7941_/Q sky130_fd_sc_hd__dfxtp_2
XFILLER_35_230 VGND VGND VPWR VPWR sky130_fd_sc_hd__decap_3
X_7872_ _8306_/Q _7898_/B VGND VGND VPWR VPWR _7873_/A sky130_fd_sc_hd__and2_2
XTAP_TAPCELL_ROW_38_759 VGND VPWR sky130_fd_sc_hd__tapvpwrvgnd_1
XTAP_TAPCELL_ROW_38_748 VGND VPWR sky130_fd_sc_hd__tapvpwrvgnd_1
XFILLER_35_263 VGND VGND VPWR VPWR sky130_fd_sc_hd__decap_3
XFILLER_50_200 VGND VGND VPWR VPWR sky130_fd_sc_hd__fill_1
XFILLER_63_583 VGND VGND VPWR VPWR sky130_fd_sc_hd__decap_3
XFILLER_23_436 VGND VGND VPWR VPWR sky130_fd_sc_hd__decap_3
XFILLER_35_296 VGND VGND VPWR VPWR sky130_fd_sc_hd__decap_3
XFILLER_50_222 VGND VGND VPWR VPWR sky130_fd_sc_hd__decap_3
XFILLER_90_391 VGND VGND VPWR VPWR sky130_fd_sc_hd__decap_3
X_6823_ _5477_/X _5609_/B _6822_/X VGND VGND VPWR VPWR _6823_/X sky130_fd_sc_hd__a21o_2
XTAP_TAPCELL_ROW_18_494 VGND VPWR sky130_fd_sc_hd__tapvpwrvgnd_1
XFILLER_23_458 VGND VGND VPWR VPWR sky130_fd_sc_hd__fill_2
XFILLER_23_469 VGND VGND VPWR VPWR sky130_fd_sc_hd__decap_3
XFILLER_50_266 VGND VGND VPWR VPWR sky130_fd_sc_hd__fill_2
X_6754_ _8290_/Q _6751_/X _6753_/X _5627_/A _6687_/X VGND VGND VPWR VPWR _6754_/X
+ sky130_fd_sc_hd__a221o_2
X_3966_ _8336_/Q _7930_/B VGND VGND VPWR VPWR _3967_/A sky130_fd_sc_hd__and2_2
X_6685_ _8194_/Q _8258_/Q _6684_/X VGND VGND VPWR VPWR _6686_/C sky130_fd_sc_hd__a21o_2
X_5705_ _5702_/A _5701_/X _5704_/Y _6999_/A1 VGND VGND VPWR VPWR _5705_/X sky130_fd_sc_hd__o22a_2
XFILLER_109_508 VGND VGND VPWR VPWR sky130_fd_sc_hd__decap_3
XPHY_EDGE_ROW_75_Left_195 VGND VGND VPWR VPWR sky130_fd_sc_hd__decap_3
X_5636_ _5254_/X _5263_/X _5264_/X _5265_/X _7783_/A _5684_/S VGND VGND VPWR VPWR
+ _5636_/X sky130_fd_sc_hd__mux4_2
XTAP_TAPCELL_ROW_98_1536 VGND VPWR sky130_fd_sc_hd__tapvpwrvgnd_1
X_8355_ _8355_/CLK _8355_/D VGND VGND VPWR VPWR _8355_/Q sky130_fd_sc_hd__dfxtp_2
X_5567_ _5374_/X _5379_/X _7670_/A VGND VGND VPWR VPWR _5567_/X sky130_fd_sc_hd__mux2_2
X_8286_ _8287_/CLK _8286_/D VGND VGND VPWR VPWR _8286_/Q sky130_fd_sc_hd__dfxtp_2
X_7306_ _8212_/Q _7306_/B VGND VGND VPWR VPWR _7308_/A sky130_fd_sc_hd__or2_4
X_5498_ _7617_/A _5497_/Y _6763_/B VGND VGND VPWR VPWR _5498_/X sky130_fd_sc_hd__o21a_2
X_4518_ _7898_/B _8063_/Q VGND VGND VPWR VPWR _4519_/A sky130_fd_sc_hd__and2_2
XFILLER_104_224 VGND VGND VPWR VPWR sky130_fd_sc_hd__decap_3
X_7237_ _7631_/A _7234_/X _7236_/X VGND VGND VPWR VPWR _7237_/Y sky130_fd_sc_hd__o21ai_2
X_4449_ _4449_/A VGND VGND VPWR VPWR _8162_/D sky130_fd_sc_hd__buf_1
XFILLER_104_268 VGND VGND VPWR VPWR sky130_fd_sc_hd__decap_3
XFILLER_77_119 VGND VGND VPWR VPWR sky130_fd_sc_hd__decap_3
XFILLER_58_333 VGND VGND VPWR VPWR sky130_fd_sc_hd__decap_3
XFILLER_86_620 VGND VGND VPWR VPWR sky130_fd_sc_hd__decap_3
X_7168_ _8205_/Q _8269_/Q _6998_/X VGND VGND VPWR VPWR _7168_/Y sky130_fd_sc_hd__a21oi_2
XFILLER_100_430 VGND VGND VPWR VPWR sky130_fd_sc_hd__decap_3
XFILLER_112_290 VGND VGND VPWR VPWR sky130_fd_sc_hd__decap_3
XFILLER_19_709 VGND VGND VPWR VPWR sky130_fd_sc_hd__fill_2
X_7099_ _4806_/B _7051_/B _4806_/A VGND VGND VPWR VPWR _7100_/B sky130_fd_sc_hd__a21bo_2
X_6119_ _8243_/Q _5399_/X wire225/X VGND VGND VPWR VPWR _6119_/Y sky130_fd_sc_hd__o21ai_2
XFILLER_100_496 VGND VGND VPWR VPWR sky130_fd_sc_hd__decap_3
XFILLER_18_208 VGND VGND VPWR VPWR sky130_fd_sc_hd__decap_3
XFILLER_58_377 VGND VGND VPWR VPWR sky130_fd_sc_hd__decap_3
XFILLER_73_303 VGND VGND VPWR VPWR sky130_fd_sc_hd__fill_2
XFILLER_85_185 VGND VGND VPWR VPWR sky130_fd_sc_hd__decap_3
XFILLER_14_403 VGND VGND VPWR VPWR sky130_fd_sc_hd__fill_1
XFILLER_42_701 VGND VGND VPWR VPWR sky130_fd_sc_hd__fill_2
XFILLER_53_11 VGND VGND VPWR VPWR sky130_fd_sc_hd__fill_2
XFILLER_54_561 VGND VGND VPWR VPWR sky130_fd_sc_hd__decap_3
XTAP_TAPCELL_ROW_107_1654 VGND VPWR sky130_fd_sc_hd__tapvpwrvgnd_1
XFILLER_26_274 VGND VGND VPWR VPWR sky130_fd_sc_hd__decap_3
XFILLER_53_22 VGND VGND VPWR VPWR sky130_fd_sc_hd__decap_3
XFILLER_54_583 VGND VGND VPWR VPWR sky130_fd_sc_hd__decap_3
XFILLER_81_391 VGND VGND VPWR VPWR sky130_fd_sc_hd__fill_1
XFILLER_53_66 VGND VGND VPWR VPWR sky130_fd_sc_hd__decap_3
XFILLER_41_277 VGND VGND VPWR VPWR sky130_fd_sc_hd__decap_3
XFILLER_41_288 VGND VGND VPWR VPWR sky130_fd_sc_hd__decap_3
XFILLER_53_99 VGND VGND VPWR VPWR sky130_fd_sc_hd__decap_3
XFILLER_6_679 VGND VGND VPWR VPWR sky130_fd_sc_hd__fill_1
Xrebuffer283 _8169_/Q VGND VGND VPWR VPWR _5943_/A sky130_fd_sc_hd__buf_2
XTAP_TAPCELL_ROW_58_1019 VGND VPWR sky130_fd_sc_hd__tapvpwrvgnd_1
XTAP_TAPCELL_ROW_58_1008 VGND VPWR sky130_fd_sc_hd__tapvpwrvgnd_1
XTAP_TAPCELL_ROW_118_1794 VGND VPWR sky130_fd_sc_hd__tapvpwrvgnd_1
Xrebuffer294 rebuffer893/X VGND VGND VPWR VPWR _7383_/B sky130_fd_sc_hd__buf_6
XFILLER_78_85 VGND VGND VPWR VPWR sky130_fd_sc_hd__decap_3
XFILLER_96_417 VGND VGND VPWR VPWR sky130_fd_sc_hd__decap_3
XFILLER_77_620 VGND VGND VPWR VPWR sky130_fd_sc_hd__decap_3
XFILLER_89_491 VGND VGND VPWR VPWR sky130_fd_sc_hd__fill_2
XFILLER_96_439 VGND VGND VPWR VPWR sky130_fd_sc_hd__decap_3
XFILLER_49_355 VGND VGND VPWR VPWR sky130_fd_sc_hd__decap_3
XFILLER_76_141 VGND VGND VPWR VPWR sky130_fd_sc_hd__decap_3
XFILLER_77_653 VGND VGND VPWR VPWR sky130_fd_sc_hd__fill_1
XFILLER_37_528 VGND VGND VPWR VPWR sky130_fd_sc_hd__fill_2
XFILLER_64_303 VGND VGND VPWR VPWR sky130_fd_sc_hd__decap_3
XFILLER_92_623 VGND VGND VPWR VPWR sky130_fd_sc_hd__decap_3
XFILLER_64_336 VGND VGND VPWR VPWR sky130_fd_sc_hd__decap_3
XFILLER_91_122 VGND VGND VPWR VPWR sky130_fd_sc_hd__decap_3
XFILLER_92_645 VGND VGND VPWR VPWR sky130_fd_sc_hd__decap_3
XFILLER_92_656 VGND VGND VPWR VPWR sky130_fd_sc_hd__decap_3
XTAP_TAPCELL_ROW_69_1159 VGND VPWR sky130_fd_sc_hd__tapvpwrvgnd_1
XFILLER_17_263 VGND VGND VPWR VPWR sky130_fd_sc_hd__fill_1
XFILLER_45_550 VGND VGND VPWR VPWR sky130_fd_sc_hd__decap_3
XFILLER_45_561 VGND VGND VPWR VPWR sky130_fd_sc_hd__decap_3
XFILLER_92_689 VGND VGND VPWR VPWR sky130_fd_sc_hd__decap_3
XTAP_TAPCELL_ROW_35_718 VGND VPWR sky130_fd_sc_hd__tapvpwrvgnd_1
XFILLER_32_200 VGND VGND VPWR VPWR sky130_fd_sc_hd__decap_3
XFILLER_32_222 VGND VGND VPWR VPWR sky130_fd_sc_hd__decap_3
XFILLER_45_583 VGND VGND VPWR VPWR sky130_fd_sc_hd__fill_1
XFILLER_60_531 VGND VGND VPWR VPWR sky130_fd_sc_hd__fill_1
XFILLER_72_380 VGND VGND VPWR VPWR sky130_fd_sc_hd__decap_3
XFILLER_91_199 VGND VGND VPWR VPWR sky130_fd_sc_hd__fill_1
XTAP_TAPCELL_ROW_82_1326 VGND VPWR sky130_fd_sc_hd__tapvpwrvgnd_1
XTAP_TAPCELL_ROW_15_453 VGND VPWR sky130_fd_sc_hd__tapvpwrvgnd_1
X_6470_ _6099_/A _6717_/A _6434_/A _6434_/B _8187_/Q _4861_/A VGND VGND VPWR VPWR
+ _6470_/X sky130_fd_sc_hd__mux4_2
X_5421_ _7617_/A _7631_/C VGND VGND VPWR VPWR _5422_/A sky130_fd_sc_hd__nor2_2
XFILLER_99_200 VGND VGND VPWR VPWR sky130_fd_sc_hd__decap_3
X_8140_ _8280_/CLK _8140_/D VGND VGND VPWR VPWR _8140_/Q sky130_fd_sc_hd__dfxtp_2
Xoutput203 _8025_/Q VGND VGND VPWR VPWR valid_out sky130_fd_sc_hd__clkdlybuf4s25_1
X_5352_ _6589_/B2 _5316_/X _5329_/X _5351_/X VGND VGND VPWR VPWR _5352_/X sky130_fd_sc_hd__a211o_2
XFILLER_114_533 VGND VGND VPWR VPWR sky130_fd_sc_hd__decap_3
XFILLER_114_544 VGND VGND VPWR VPWR sky130_fd_sc_hd__decap_3
XFILLER_99_233 VGND VGND VPWR VPWR sky130_fd_sc_hd__decap_3
X_8071_ _8207_/CLK _8071_/D VGND VGND VPWR VPWR _8071_/Q sky130_fd_sc_hd__dfxtp_2
X_4303_ _4303_/A VGND VGND VPWR VPWR _8089_/D sky130_fd_sc_hd__buf_1
XTAP_TAPCELL_ROW_93_1466 VGND VPWR sky130_fd_sc_hd__tapvpwrvgnd_1
XFILLER_59_108 VGND VGND VPWR VPWR sky130_fd_sc_hd__decap_3
XFILLER_87_428 VGND VGND VPWR VPWR sky130_fd_sc_hd__fill_1
XFILLER_99_266 VGND VGND VPWR VPWR sky130_fd_sc_hd__decap_3
X_7022_ _8229_/Q _7021_/X _6011_/X VGND VGND VPWR VPWR _7022_/Y sky130_fd_sc_hd__o21ai_2
X_5283_ _7783_/A _6763_/B _6686_/B _7619_/A VGND VGND VPWR VPWR _5283_/X sky130_fd_sc_hd__a2bb2o_2
X_4234_ _7930_/B _4234_/B VGND VGND VPWR VPWR _4235_/A sky130_fd_sc_hd__and2_2
XFILLER_101_249 VGND VGND VPWR VPWR sky130_fd_sc_hd__decap_3
XFILLER_68_642 VGND VGND VPWR VPWR sky130_fd_sc_hd__fill_2
XFILLER_68_653 VGND VGND VPWR VPWR sky130_fd_sc_hd__decap_3
X_4165_ _4165_/A VGND VGND VPWR VPWR _8020_/D sky130_fd_sc_hd__buf_1
XFILLER_28_528 VGND VGND VPWR VPWR sky130_fd_sc_hd__decap_3
XFILLER_67_152 VGND VGND VPWR VPWR sky130_fd_sc_hd__decap_3
XFILLER_68_697 VGND VGND VPWR VPWR sky130_fd_sc_hd__decap_3
XFILLER_82_100 VGND VGND VPWR VPWR sky130_fd_sc_hd__fill_2
XFILLER_83_634 VGND VGND VPWR VPWR sky130_fd_sc_hd__decap_3
XFILLER_82_144 VGND VGND VPWR VPWR sky130_fd_sc_hd__decap_3
XFILLER_83_667 VGND VGND VPWR VPWR sky130_fd_sc_hd__decap_3
X_4096_ _7930_/B _8389_/Q VGND VGND VPWR VPWR _4097_/A sky130_fd_sc_hd__and2_2
X_7924_ _8332_/Q _7930_/B VGND VGND VPWR VPWR _7925_/A sky130_fd_sc_hd__and2_2
XFILLER_23_222 VGND VGND VPWR VPWR sky130_fd_sc_hd__fill_2
XFILLER_63_391 VGND VGND VPWR VPWR sky130_fd_sc_hd__fill_1
XFILLER_82_188 VGND VGND VPWR VPWR sky130_fd_sc_hd__decap_3
X_7855_ _7855_/A VGND VGND VPWR VPWR _8364_/D sky130_fd_sc_hd__buf_1
XFILLER_51_542 VGND VGND VPWR VPWR sky130_fd_sc_hd__fill_2
XFILLER_51_564 VGND VGND VPWR VPWR sky130_fd_sc_hd__decap_3
X_6806_ _7121_/A _6806_/B VGND VGND VPWR VPWR _8331_/D sky130_fd_sc_hd__nor2_2
XFILLER_23_266 VGND VGND VPWR VPWR sky130_fd_sc_hd__decap_3
XFILLER_51_586 VGND VGND VPWR VPWR sky130_fd_sc_hd__fill_2
XPHY_EDGE_ROW_83_Left_203 VGND VGND VPWR VPWR sky130_fd_sc_hd__decap_3
X_7786_ _7652_/Y _7757_/X _7766_/X _7785_/X VGND VGND VPWR VPWR _7786_/X sky130_fd_sc_hd__a31o_2
X_4998_ _4998_/A VGND VGND VPWR VPWR _4998_/Y sky130_fd_sc_hd__inv_2
XTAP_TAPCELL_ROW_102_1584 VGND VPWR sky130_fd_sc_hd__tapvpwrvgnd_1
X_6737_ _8259_/Q _6695_/B _4852_/A VGND VGND VPWR VPWR _6737_/X sky130_fd_sc_hd__a21o_2
XFILLER_99_29 VGND VGND VPWR VPWR sky130_fd_sc_hd__decap_3
X_6668_ _6727_/C _6669_/C _6675_/B VGND VGND VPWR VPWR _6668_/Y sky130_fd_sc_hd__a21oi_2
XFILLER_109_349 VGND VGND VPWR VPWR sky130_fd_sc_hd__decap_3
X_6599_ _6599_/A _6599_/B VGND VGND VPWR VPWR _6599_/X sky130_fd_sc_hd__or2_2
X_5619_ _7809_/A1 _5337_/X _5718_/A _8231_/Q VGND VGND VPWR VPWR _5619_/X sky130_fd_sc_hd__a2bb2o_2
XFILLER_105_500 VGND VGND VPWR VPWR sky130_fd_sc_hd__decap_3
XFILLER_117_371 VGND VGND VPWR VPWR sky130_fd_sc_hd__fill_1
X_8338_ _8398_/CLK _8338_/D VGND VGND VPWR VPWR _8338_/Q sky130_fd_sc_hd__dfxtp_2
XFILLER_117_393 VGND VGND VPWR VPWR sky130_fd_sc_hd__decap_3
XFILLER_2_115 VGND VGND VPWR VPWR sky130_fd_sc_hd__decap_3
XFILLER_105_577 VGND VGND VPWR VPWR sky130_fd_sc_hd__decap_3
XPHY_EDGE_ROW_92_Left_212 VGND VGND VPWR VPWR sky130_fd_sc_hd__decap_3
X_8269_ _8269_/CLK _8269_/D VGND VGND VPWR VPWR _8269_/Q sky130_fd_sc_hd__dfxtp_2
XFILLER_58_141 VGND VGND VPWR VPWR sky130_fd_sc_hd__decap_3
XFILLER_59_653 VGND VGND VPWR VPWR sky130_fd_sc_hd__decap_3
XFILLER_100_271 VGND VGND VPWR VPWR sky130_fd_sc_hd__decap_3
XFILLER_19_517 VGND VGND VPWR VPWR sky130_fd_sc_hd__decap_3
XFILLER_48_88 VGND VGND VPWR VPWR sky130_fd_sc_hd__fill_2
XFILLER_73_100 VGND VGND VPWR VPWR sky130_fd_sc_hd__decap_3
XFILLER_74_612 VGND VGND VPWR VPWR sky130_fd_sc_hd__decap_3
XFILLER_0_18 VGND VGND VPWR VPWR sky130_fd_sc_hd__decap_3
XFILLER_0_29 VGND VGND VPWR VPWR sky130_fd_sc_hd__decap_3
XFILLER_46_336 VGND VGND VPWR VPWR sky130_fd_sc_hd__decap_3
XFILLER_46_358 VGND VGND VPWR VPWR sky130_fd_sc_hd__decap_3
XFILLER_73_122 VGND VGND VPWR VPWR sky130_fd_sc_hd__decap_3
XFILLER_74_645 VGND VGND VPWR VPWR sky130_fd_sc_hd__decap_3
XFILLER_104_94 VGND VGND VPWR VPWR sky130_fd_sc_hd__decap_3
XFILLER_27_550 VGND VGND VPWR VPWR sky130_fd_sc_hd__decap_3
XFILLER_27_561 VGND VGND VPWR VPWR sky130_fd_sc_hd__decap_3
XFILLER_64_32 VGND VGND VPWR VPWR sky130_fd_sc_hd__decap_3
XFILLER_73_155 VGND VGND VPWR VPWR sky130_fd_sc_hd__decap_3
XFILLER_54_391 VGND VGND VPWR VPWR sky130_fd_sc_hd__decap_3
XFILLER_42_586 VGND VGND VPWR VPWR sky130_fd_sc_hd__fill_2
XTAP_TAPCELL_ROW_64_1089 VGND VPWR sky130_fd_sc_hd__tapvpwrvgnd_1
XFILLER_14_299 VGND VGND VPWR VPWR sky130_fd_sc_hd__decap_3
XTAP_TAPCELL_ROW_12_412 VGND VPWR sky130_fd_sc_hd__tapvpwrvgnd_1
XFILLER_6_410 VGND VGND VPWR VPWR sky130_fd_sc_hd__decap_3
XFILLER_80_97 VGND VGND VPWR VPWR sky130_fd_sc_hd__decap_3
XTAP_TAPCELL_ROW_40_776 VGND VPWR sky130_fd_sc_hd__tapvpwrvgnd_1
XFILLER_10_483 VGND VGND VPWR VPWR sky130_fd_sc_hd__decap_3
XFILLER_6_421 VGND VGND VPWR VPWR sky130_fd_sc_hd__decap_3
XPHY_EDGE_ROW_108_Right_108 VGND VGND VPWR VPWR sky130_fd_sc_hd__decap_3
XFILLER_108_393 VGND VGND VPWR VPWR sky130_fd_sc_hd__fill_1
XFILLER_111_503 VGND VGND VPWR VPWR sky130_fd_sc_hd__fill_1
XFILLER_69_406 VGND VGND VPWR VPWR sky130_fd_sc_hd__decap_3
XFILLER_96_203 VGND VGND VPWR VPWR sky130_fd_sc_hd__decap_3
XFILLER_111_525 VGND VGND VPWR VPWR sky130_fd_sc_hd__decap_3
XFILLER_111_536 VGND VGND VPWR VPWR sky130_fd_sc_hd__fill_1
XFILLER_36_6 VGND VGND VPWR VPWR sky130_fd_sc_hd__decap_3
XFILLER_96_236 VGND VGND VPWR VPWR sky130_fd_sc_hd__decap_3
XFILLER_111_558 VGND VGND VPWR VPWR sky130_fd_sc_hd__fill_2
XFILLER_84_409 VGND VGND VPWR VPWR sky130_fd_sc_hd__fill_2
XFILLER_77_461 VGND VGND VPWR VPWR sky130_fd_sc_hd__fill_2
XFILLER_77_483 VGND VGND VPWR VPWR sky130_fd_sc_hd__decap_3
XFILLER_49_196 VGND VGND VPWR VPWR sky130_fd_sc_hd__decap_3
XFILLER_65_667 VGND VGND VPWR VPWR sky130_fd_sc_hd__decap_3
XFILLER_52_306 VGND VGND VPWR VPWR sky130_fd_sc_hd__fill_2
XFILLER_92_464 VGND VGND VPWR VPWR sky130_fd_sc_hd__decap_3
XFILLER_92_475 VGND VGND VPWR VPWR sky130_fd_sc_hd__fill_1
X_5970_ _5965_/Y _5969_/X _7898_/B VGND VGND VPWR VPWR _8308_/D sky130_fd_sc_hd__o21a_2
XTAP_TAPCELL_ROW_48_887 VGND VPWR sky130_fd_sc_hd__tapvpwrvgnd_1
XFILLER_33_520 VGND VGND VPWR VPWR sky130_fd_sc_hd__decap_3
XFILLER_45_380 VGND VGND VPWR VPWR sky130_fd_sc_hd__decap_3
XFILLER_64_188 VGND VGND VPWR VPWR sky130_fd_sc_hd__decap_3
XFILLER_80_648 VGND VGND VPWR VPWR sky130_fd_sc_hd__decap_3
X_4921_ _4921_/A _5928_/A VGND VGND VPWR VPWR _5894_/A sky130_fd_sc_hd__nand2_2
XFILLER_60_350 VGND VGND VPWR VPWR sky130_fd_sc_hd__decap_3
X_7640_ _7640_/A1 _7640_/A2 _7638_/Y _7639_/Y VGND VGND VPWR VPWR _7640_/Y sky130_fd_sc_hd__a31oi_2
X_4852_ _4852_/A _8259_/Q VGND VGND VPWR VPWR _4853_/B sky130_fd_sc_hd__nand2_2
XFILLER_20_203 VGND VGND VPWR VPWR sky130_fd_sc_hd__decap_3
XFILLER_33_575 VGND VGND VPWR VPWR sky130_fd_sc_hd__decap_3
XFILLER_33_597 VGND VGND VPWR VPWR sky130_fd_sc_hd__decap_3
XFILLER_20_236 VGND VGND VPWR VPWR sky130_fd_sc_hd__decap_3
XFILLER_60_394 VGND VGND VPWR VPWR sky130_fd_sc_hd__decap_3
X_7571_ _8219_/Q _8283_/Q _8285_/Q _8221_/Q VGND VGND VPWR VPWR _7574_/B sky130_fd_sc_hd__a22o_2
X_4783_ _8210_/Q _4783_/B VGND VGND VPWR VPWR _4786_/A sky130_fd_sc_hd__nand2_2
XFILLER_119_614 VGND VGND VPWR VPWR sky130_fd_sc_hd__fill_2
XFILLER_119_636 VGND VGND VPWR VPWR sky130_fd_sc_hd__decap_3
X_6522_ _6592_/D _6523_/B VGND VGND VPWR VPWR _6522_/X sky130_fd_sc_hd__and2_2
XFILLER_109_17 VGND VGND VPWR VPWR sky130_fd_sc_hd__decap_3
XFILLER_119_669 VGND VGND VPWR VPWR sky130_fd_sc_hd__decap_3
XFILLER_9_281 VGND VGND VPWR VPWR sky130_fd_sc_hd__decap_3
X_6453_ _5861_/X _6452_/X _5487_/X _6166_/X _5182_/A _7745_/A VGND VGND VPWR VPWR
+ _6454_/B sky130_fd_sc_hd__mux4_2
XFILLER_109_39 VGND VGND VPWR VPWR sky130_fd_sc_hd__decap_3
X_5404_ _7631_/A _8163_/Q _5401_/Y _5403_/X VGND VGND VPWR VPWR _5404_/X sky130_fd_sc_hd__a31o_2
X_8123_ _8396_/CLK _8123_/D VGND VGND VPWR VPWR _8123_/Q sky130_fd_sc_hd__dfxtp_2
X_6384_ _6353_/A _5783_/X _6383_/Y _6650_/B VGND VGND VPWR VPWR _6384_/X sky130_fd_sc_hd__a211o_2
X_5335_ _5335_/A VGND VGND VPWR VPWR _5397_/A sky130_fd_sc_hd__buf_1
XFILLER_114_374 VGND VGND VPWR VPWR sky130_fd_sc_hd__decap_3
XFILLER_87_214 VGND VGND VPWR VPWR sky130_fd_sc_hd__decap_3
XFILLER_87_225 VGND VGND VPWR VPWR sky130_fd_sc_hd__decap_3
X_8054_ clkload4/A _8054_/D VGND VGND VPWR VPWR _8054_/Q sky130_fd_sc_hd__dfxtp_2
X_5266_ _6022_/B _6097_/A _7805_/A VGND VGND VPWR VPWR _5266_/X sky130_fd_sc_hd__mux2_2
XFILLER_102_558 VGND VGND VPWR VPWR sky130_fd_sc_hd__decap_3
XFILLER_87_269 VGND VGND VPWR VPWR sky130_fd_sc_hd__fill_2
X_7005_ _7195_/B _7005_/B VGND VGND VPWR VPWR _7005_/Y sky130_fd_sc_hd__nor2_2
X_4217_ _4217_/A VGND VGND VPWR VPWR _8046_/D sky130_fd_sc_hd__buf_1
XFILLER_55_100 VGND VGND VPWR VPWR sky130_fd_sc_hd__decap_3
XFILLER_68_483 VGND VGND VPWR VPWR sky130_fd_sc_hd__decap_3
X_5197_ _5289_/A _5197_/B _5197_/C VGND VGND VPWR VPWR _5197_/X sky130_fd_sc_hd__and3_2
XFILLER_110_580 VGND VGND VPWR VPWR sky130_fd_sc_hd__decap_3
XFILLER_28_325 VGND VGND VPWR VPWR sky130_fd_sc_hd__decap_3
XFILLER_55_122 VGND VGND VPWR VPWR sky130_fd_sc_hd__decap_3
XFILLER_56_645 VGND VGND VPWR VPWR sky130_fd_sc_hd__decap_3
XFILLER_95_291 VGND VGND VPWR VPWR sky130_fd_sc_hd__fill_1
X_4148_ _7930_/B _7944_/Q VGND VGND VPWR VPWR _4149_/A sky130_fd_sc_hd__and2_2
XFILLER_16_509 VGND VGND VPWR VPWR sky130_fd_sc_hd__decap_3
XFILLER_71_604 VGND VGND VPWR VPWR sky130_fd_sc_hd__decap_3
XFILLER_83_464 VGND VGND VPWR VPWR sky130_fd_sc_hd__decap_3
X_4079_ _4079_/A VGND VGND VPWR VPWR _7977_/D sky130_fd_sc_hd__buf_1
XFILLER_43_328 VGND VGND VPWR VPWR sky130_fd_sc_hd__decap_3
XFILLER_70_103 VGND VGND VPWR VPWR sky130_fd_sc_hd__fill_2
XFILLER_71_648 VGND VGND VPWR VPWR sky130_fd_sc_hd__fill_1
XFILLER_83_497 VGND VGND VPWR VPWR sky130_fd_sc_hd__decap_3
XTAP_TAPCELL_ROW_104_1613 VGND VPWR sky130_fd_sc_hd__tapvpwrvgnd_1
X_7907_ _7907_/A VGND VGND VPWR VPWR _8390_/D sky130_fd_sc_hd__buf_1
XFILLER_24_553 VGND VGND VPWR VPWR sky130_fd_sc_hd__decap_3
XFILLER_36_391 VGND VGND VPWR VPWR sky130_fd_sc_hd__decap_3
XFILLER_70_147 VGND VGND VPWR VPWR sky130_fd_sc_hd__decap_3
XFILLER_24_575 VGND VGND VPWR VPWR sky130_fd_sc_hd__decap_3
X_7838_ _8222_/Q _7838_/B _7838_/C _7637_/Y VGND VGND VPWR VPWR _7838_/X sky130_fd_sc_hd__or4b_4
XFILLER_11_225 VGND VGND VPWR VPWR sky130_fd_sc_hd__decap_3
XFILLER_8_719 VGND VGND VPWR VPWR sky130_fd_sc_hd__decap_3
X_7769_ _7670_/A _5121_/A _7767_/Y _7768_/Y VGND VGND VPWR VPWR _7769_/X sky130_fd_sc_hd__a31o_2
XFILLER_109_113 VGND VGND VPWR VPWR sky130_fd_sc_hd__decap_3
XFILLER_11_258 VGND VGND VPWR VPWR sky130_fd_sc_hd__decap_3
Xclkload1 clkload1/A VGND VGND VPWR VPWR clkload1/Y sky130_fd_sc_hd__clkinv_8
XFILLER_119_3 VGND VGND VPWR VPWR sky130_fd_sc_hd__decap_3
XFILLER_50_78 VGND VGND VPWR VPWR sky130_fd_sc_hd__decap_3
XFILLER_118_691 VGND VGND VPWR VPWR sky130_fd_sc_hd__decap_3
XFILLER_3_424 VGND VGND VPWR VPWR sky130_fd_sc_hd__decap_3
XTAP_TAPCELL_ROW_115_1753 VGND VPWR sky130_fd_sc_hd__tapvpwrvgnd_1
XFILLER_105_352 VGND VGND VPWR VPWR sky130_fd_sc_hd__fill_2
XFILLER_1_3 VGND VGND VPWR VPWR sky130_fd_sc_hd__decap_3
XFILLER_59_43 VGND VGND VPWR VPWR sky130_fd_sc_hd__decap_3
XFILLER_78_203 VGND VGND VPWR VPWR sky130_fd_sc_hd__decap_3
XFILLER_78_236 VGND VGND VPWR VPWR sky130_fd_sc_hd__decap_3
XFILLER_66_409 VGND VGND VPWR VPWR sky130_fd_sc_hd__decap_3
XFILLER_115_60 VGND VGND VPWR VPWR sky130_fd_sc_hd__decap_3
XFILLER_47_612 VGND VGND VPWR VPWR sky130_fd_sc_hd__decap_3
XFILLER_47_623 VGND VGND VPWR VPWR sky130_fd_sc_hd__decap_3
XFILLER_93_206 VGND VGND VPWR VPWR sky130_fd_sc_hd__decap_3
XFILLER_93_228 VGND VGND VPWR VPWR sky130_fd_sc_hd__decap_3
XFILLER_94_729 VGND VGND VPWR VPWR sky130_fd_sc_hd__decap_3
XFILLER_101_580 VGND VGND VPWR VPWR sky130_fd_sc_hd__decap_3
XFILLER_47_645 VGND VGND VPWR VPWR sky130_fd_sc_hd__decap_3
XFILLER_74_442 VGND VGND VPWR VPWR sky130_fd_sc_hd__decap_3
XFILLER_86_291 VGND VGND VPWR VPWR sky130_fd_sc_hd__decap_3
XFILLER_19_358 VGND VGND VPWR VPWR sky130_fd_sc_hd__fill_1
XFILLER_46_144 VGND VGND VPWR VPWR sky130_fd_sc_hd__decap_3
XFILLER_47_689 VGND VGND VPWR VPWR sky130_fd_sc_hd__fill_2
XFILLER_62_604 VGND VGND VPWR VPWR sky130_fd_sc_hd__decap_3
XFILLER_74_475 VGND VGND VPWR VPWR sky130_fd_sc_hd__fill_1
XFILLER_75_75 VGND VGND VPWR VPWR sky130_fd_sc_hd__decap_3
XTAP_TAPCELL_ROW_66_1118 VGND VPWR sky130_fd_sc_hd__tapvpwrvgnd_1
XFILLER_34_339 VGND VGND VPWR VPWR sky130_fd_sc_hd__decap_3
XFILLER_46_177 VGND VGND VPWR VPWR sky130_fd_sc_hd__decap_3
XFILLER_61_125 VGND VGND VPWR VPWR sky130_fd_sc_hd__fill_1
XFILLER_62_637 VGND VGND VPWR VPWR sky130_fd_sc_hd__fill_1
XTAP_TAPCELL_ROW_45_846 VGND VPWR sky130_fd_sc_hd__tapvpwrvgnd_1
XFILLER_27_391 VGND VGND VPWR VPWR sky130_fd_sc_hd__fill_1
XFILLER_61_147 VGND VGND VPWR VPWR sky130_fd_sc_hd__decap_3
XFILLER_61_169 VGND VGND VPWR VPWR sky130_fd_sc_hd__decap_3
XFILLER_91_41 VGND VGND VPWR VPWR sky130_fd_sc_hd__fill_1
XFILLER_15_564 VGND VGND VPWR VPWR sky130_fd_sc_hd__decap_3
XFILLER_91_52 VGND VGND VPWR VPWR sky130_fd_sc_hd__decap_3
XFILLER_91_74 VGND VGND VPWR VPWR sky130_fd_sc_hd__fill_2
XFILLER_42_394 VGND VGND VPWR VPWR sky130_fd_sc_hd__decap_3
XTAP_TAPCELL_ROW_25_581 VGND VPWR sky130_fd_sc_hd__tapvpwrvgnd_1
XFILLER_6_262 VGND VGND VPWR VPWR sky130_fd_sc_hd__decap_3
XFILLER_109_680 VGND VGND VPWR VPWR sky130_fd_sc_hd__decap_3
XFILLER_115_116 VGND VGND VPWR VPWR sky130_fd_sc_hd__decap_3
XTAP_TAPCELL_ROW_77_1258 VGND VPWR sky130_fd_sc_hd__tapvpwrvgnd_1
XTAP_TAPCELL_ROW_90_1425 VGND VPWR sky130_fd_sc_hd__tapvpwrvgnd_1
XFILLER_111_300 VGND VGND VPWR VPWR sky130_fd_sc_hd__decap_3
XFILLER_34_3 VGND VGND VPWR VPWR sky130_fd_sc_hd__fill_2
XFILLER_69_214 VGND VGND VPWR VPWR sky130_fd_sc_hd__decap_3
XFILLER_69_225 VGND VGND VPWR VPWR sky130_fd_sc_hd__decap_3
XFILLER_97_534 VGND VGND VPWR VPWR sky130_fd_sc_hd__fill_1
X_5120_ _7670_/B VGND VGND VPWR VPWR _5121_/A sky130_fd_sc_hd__clkbuf_2
XFILLER_111_333 VGND VGND VPWR VPWR sky130_fd_sc_hd__decap_3
XFILLER_57_409 VGND VGND VPWR VPWR sky130_fd_sc_hd__decap_3
X_5051_ _6561_/B VGND VGND VPWR VPWR _5051_/Y sky130_fd_sc_hd__inv_2
XFILLER_111_366 VGND VGND VPWR VPWR sky130_fd_sc_hd__decap_3
XFILLER_84_206 VGND VGND VPWR VPWR sky130_fd_sc_hd__decap_3
XFILLER_85_729 VGND VGND VPWR VPWR sky130_fd_sc_hd__decap_3
XFILLER_97_589 VGND VGND VPWR VPWR sky130_fd_sc_hd__decap_3
X_4002_ _8354_/Q _7930_/B VGND VGND VPWR VPWR _4003_/A sky130_fd_sc_hd__and2_2
XFILLER_38_645 VGND VGND VPWR VPWR sky130_fd_sc_hd__decap_3
XFILLER_65_420 VGND VGND VPWR VPWR sky130_fd_sc_hd__decap_3
XFILLER_25_306 VGND VGND VPWR VPWR sky130_fd_sc_hd__decap_3
XFILLER_65_475 VGND VGND VPWR VPWR sky130_fd_sc_hd__decap_3
XFILLER_92_261 VGND VGND VPWR VPWR sky130_fd_sc_hd__decap_3
XFILLER_111_29 VGND VGND VPWR VPWR sky130_fd_sc_hd__decap_3
XFILLER_18_380 VGND VGND VPWR VPWR sky130_fd_sc_hd__fill_2
XFILLER_37_199 VGND VGND VPWR VPWR sky130_fd_sc_hd__decap_3
XFILLER_52_103 VGND VGND VPWR VPWR sky130_fd_sc_hd__decap_3
XFILLER_53_626 VGND VGND VPWR VPWR sky130_fd_sc_hd__decap_3
XTAP_TAPCELL_ROW_88_1398 VGND VPWR sky130_fd_sc_hd__tapvpwrvgnd_1
XFILLER_52_136 VGND VGND VPWR VPWR sky130_fd_sc_hd__decap_3
XFILLER_80_467 VGND VGND VPWR VPWR sky130_fd_sc_hd__decap_3
X_5953_ _6321_/B _5574_/A _6353_/A VGND VGND VPWR VPWR _5953_/Y sky130_fd_sc_hd__o21ai_2
XFILLER_33_361 VGND VGND VPWR VPWR sky130_fd_sc_hd__decap_3
XFILLER_40_309 VGND VGND VPWR VPWR sky130_fd_sc_hd__decap_3
XFILLER_52_169 VGND VGND VPWR VPWR sky130_fd_sc_hd__fill_1
X_5884_ _8236_/Q _5884_/B VGND VGND VPWR VPWR _5884_/X sky130_fd_sc_hd__or2_2
X_4904_ _5037_/A _6039_/A VGND VGND VPWR VPWR _6007_/A sky130_fd_sc_hd__or2_2
XFILLER_60_180 VGND VGND VPWR VPWR sky130_fd_sc_hd__decap_3
X_7623_ _7622_/X _7503_/X _7623_/S VGND VGND VPWR VPWR _7623_/X sky130_fd_sc_hd__mux2_2
X_4835_ _6956_/C _7152_/A VGND VGND VPWR VPWR _6874_/C sky130_fd_sc_hd__nand2b_2
X_7554_ _8221_/Q _8220_/Q _8219_/Q _8218_/Q _7796_/A _7765_/A VGND VGND VPWR VPWR
+ _7554_/X sky130_fd_sc_hd__mux4_2
X_4766_ _4766_/A VGND VGND VPWR VPWR _7398_/B sky130_fd_sc_hd__buf_1
XFILLER_119_455 VGND VGND VPWR VPWR sky130_fd_sc_hd__decap_3
Xrebuffer827 _8161_/Q VGND VGND VPWR VPWR rebuffer827/X sky130_fd_sc_hd__buf_2
Xrebuffer838 _8167_/Q VGND VGND VPWR VPWR _5747_/A2 sky130_fd_sc_hd__buf_2
X_6505_ _6712_/B _8188_/Q _8187_/Q _8186_/Q _7796_/A _7812_/A VGND VGND VPWR VPWR
+ _6505_/X sky130_fd_sc_hd__mux4_2
XFILLER_107_606 VGND VGND VPWR VPWR sky130_fd_sc_hd__decap_3
XFILLER_119_477 VGND VGND VPWR VPWR sky130_fd_sc_hd__decap_3
X_7485_ _7606_/A1 _7460_/Y _7484_/X _7930_/B VGND VGND VPWR VPWR _8352_/D sky130_fd_sc_hd__o211a_4
X_4697_ _4697_/A VGND VGND VPWR VPWR _8286_/D sky130_fd_sc_hd__buf_1
XFILLER_106_138 VGND VGND VPWR VPWR sky130_fd_sc_hd__fill_2
XFILLER_107_639 VGND VGND VPWR VPWR sky130_fd_sc_hd__decap_3
X_6436_ _5407_/X _6550_/A _6435_/X VGND VGND VPWR VPWR _6436_/X sky130_fd_sc_hd__a21bo_2
X_6367_ _6339_/X _6358_/X _6366_/X _7930_/B VGND VGND VPWR VPWR _8319_/D sky130_fd_sc_hd__o31a_4
XFILLER_0_427 VGND VGND VPWR VPWR sky130_fd_sc_hd__decap_3
XFILLER_88_512 VGND VGND VPWR VPWR sky130_fd_sc_hd__decap_3
X_8106_ clkload5/A _8106_/D VGND VGND VPWR VPWR _8106_/Q sky130_fd_sc_hd__dfxtp_2
X_5318_ split/X _5318_/B VGND VGND VPWR VPWR _5318_/X sky130_fd_sc_hd__and2_2
XFILLER_0_449 VGND VGND VPWR VPWR sky130_fd_sc_hd__decap_3
XFILLER_102_344 VGND VGND VPWR VPWR sky130_fd_sc_hd__decap_3
XFILLER_76_707 VGND VGND VPWR VPWR sky130_fd_sc_hd__decap_3
XFILLER_88_545 VGND VGND VPWR VPWR sky130_fd_sc_hd__fill_1
X_6298_ _6024_/B _8239_/Q _6007_/A _6084_/A _6297_/X VGND VGND VPWR VPWR _6299_/A
+ sky130_fd_sc_hd__o2111ai_2
XFILLER_102_377 VGND VGND VPWR VPWR sky130_fd_sc_hd__decap_3
XFILLER_88_589 VGND VGND VPWR VPWR sky130_fd_sc_hd__decap_3
XTAP_TAPCELL_ROW_110_1683 VGND VPWR sky130_fd_sc_hd__tapvpwrvgnd_1
X_8037_ clkload9/A _8037_/D VGND VGND VPWR VPWR _8037_/Q sky130_fd_sc_hd__dfxtp_2
X_5249_ _8183_/Q _8184_/Q _5678_/S VGND VGND VPWR VPWR _5249_/X sky130_fd_sc_hd__mux2_2
XFILLER_28_100 VGND VGND VPWR VPWR sky130_fd_sc_hd__decap_3
XFILLER_29_656 VGND VGND VPWR VPWR sky130_fd_sc_hd__decap_3
XFILLER_75_228 VGND VGND VPWR VPWR sky130_fd_sc_hd__decap_3
XTAP_TAPCELL_ROW_110_1694 VGND VPWR sky130_fd_sc_hd__tapvpwrvgnd_1
XFILLER_16_306 VGND VGND VPWR VPWR sky130_fd_sc_hd__fill_2
XFILLER_56_442 VGND VGND VPWR VPWR sky130_fd_sc_hd__decap_3
XFILLER_83_250 VGND VGND VPWR VPWR sky130_fd_sc_hd__decap_3
XFILLER_16_339 VGND VGND VPWR VPWR sky130_fd_sc_hd__decap_3
XFILLER_28_188 VGND VGND VPWR VPWR sky130_fd_sc_hd__decap_3
XFILLER_44_626 VGND VGND VPWR VPWR sky130_fd_sc_hd__decap_3
XFILLER_44_648 VGND VGND VPWR VPWR sky130_fd_sc_hd__decap_3
XFILLER_56_486 VGND VGND VPWR VPWR sky130_fd_sc_hd__decap_3
XFILLER_71_434 VGND VGND VPWR VPWR sky130_fd_sc_hd__decap_3
XTAP_TAPCELL_ROW_3_298 VGND VPWR sky130_fd_sc_hd__tapvpwrvgnd_1
XFILLER_43_147 VGND VGND VPWR VPWR sky130_fd_sc_hd__decap_3
XFILLER_24_350 VGND VGND VPWR VPWR sky130_fd_sc_hd__decap_3
XFILLER_31_309 VGND VGND VPWR VPWR sky130_fd_sc_hd__decap_3
XFILLER_43_169 VGND VGND VPWR VPWR sky130_fd_sc_hd__decap_3
XTAP_TAPCELL_ROW_42_805 VGND VPWR sky130_fd_sc_hd__tapvpwrvgnd_1
XFILLER_12_545 VGND VGND VPWR VPWR sky130_fd_sc_hd__fill_1
XFILLER_61_11 VGND VGND VPWR VPWR sky130_fd_sc_hd__fill_1
XFILLER_61_33 VGND VGND VPWR VPWR sky130_fd_sc_hd__decap_3
XTAP_TAPCELL_ROW_61_1048 VGND VPWR sky130_fd_sc_hd__tapvpwrvgnd_1
XFILLER_12_556 VGND VGND VPWR VPWR sky130_fd_sc_hd__decap_3
XFILLER_12_589 VGND VGND VPWR VPWR sky130_fd_sc_hd__decap_3
XFILLER_61_55 VGND VGND VPWR VPWR sky130_fd_sc_hd__fill_1
XTAP_TAPCELL_ROW_22_551 VGND VPWR sky130_fd_sc_hd__tapvpwrvgnd_1
XTAP_TAPCELL_ROW_22_540 VGND VPWR sky130_fd_sc_hd__tapvpwrvgnd_1
XFILLER_61_99 VGND VGND VPWR VPWR sky130_fd_sc_hd__decap_3
XFILLER_3_221 VGND VGND VPWR VPWR sky130_fd_sc_hd__decap_3
XFILLER_79_501 VGND VGND VPWR VPWR sky130_fd_sc_hd__decap_3
XFILLER_98_309 VGND VGND VPWR VPWR sky130_fd_sc_hd__fill_2
XFILLER_105_160 VGND VGND VPWR VPWR sky130_fd_sc_hd__decap_3
XFILLER_3_287 VGND VGND VPWR VPWR sky130_fd_sc_hd__decap_3
XFILLER_79_523 VGND VGND VPWR VPWR sky130_fd_sc_hd__decap_3
XFILLER_105_193 VGND VGND VPWR VPWR sky130_fd_sc_hd__decap_3
XFILLER_66_206 VGND VGND VPWR VPWR sky130_fd_sc_hd__decap_3
XFILLER_67_729 VGND VGND VPWR VPWR sky130_fd_sc_hd__decap_3
XFILLER_94_504 VGND VGND VPWR VPWR sky130_fd_sc_hd__decap_3
XTAP_TAPCELL_ROW_72_1199 VGND VPWR sky130_fd_sc_hd__tapvpwrvgnd_1
XFILLER_19_100 VGND VGND VPWR VPWR sky130_fd_sc_hd__decap_3
XFILLER_19_122 VGND VGND VPWR VPWR sky130_fd_sc_hd__decap_3
XFILLER_47_420 VGND VGND VPWR VPWR sky130_fd_sc_hd__decap_3
XFILLER_66_239 VGND VGND VPWR VPWR sky130_fd_sc_hd__decap_3
XFILLER_86_85 VGND VGND VPWR VPWR sky130_fd_sc_hd__decap_3
XFILLER_19_155 VGND VGND VPWR VPWR sky130_fd_sc_hd__decap_3
XFILLER_81_209 VGND VGND VPWR VPWR sky130_fd_sc_hd__decap_3
XFILLER_35_615 VGND VGND VPWR VPWR sky130_fd_sc_hd__fill_1
XFILLER_35_648 VGND VGND VPWR VPWR sky130_fd_sc_hd__decap_3
XFILLER_47_486 VGND VGND VPWR VPWR sky130_fd_sc_hd__decap_3
XFILLER_62_412 VGND VGND VPWR VPWR sky130_fd_sc_hd__decap_3
XFILLER_90_710 VGND VGND VPWR VPWR sky130_fd_sc_hd__decap_3
XFILLER_34_125 VGND VGND VPWR VPWR sky130_fd_sc_hd__decap_3
XFILLER_34_147 VGND VGND VPWR VPWR sky130_fd_sc_hd__decap_3
XFILLER_62_445 VGND VGND VPWR VPWR sky130_fd_sc_hd__decap_3
XFILLER_15_350 VGND VGND VPWR VPWR sky130_fd_sc_hd__decap_3
XFILLER_22_309 VGND VGND VPWR VPWR sky130_fd_sc_hd__decap_3
XFILLER_43_670 VGND VGND VPWR VPWR sky130_fd_sc_hd__fill_2
XFILLER_50_629 VGND VGND VPWR VPWR sky130_fd_sc_hd__decap_3
XFILLER_15_383 VGND VGND VPWR VPWR sky130_fd_sc_hd__fill_1
XFILLER_30_353 VGND VGND VPWR VPWR sky130_fd_sc_hd__decap_3
X_4620_ _7898_/B _8114_/Q VGND VGND VPWR VPWR _4621_/A sky130_fd_sc_hd__and2_2
X_4551_ _4551_/A VGND VGND VPWR VPWR _8213_/D sky130_fd_sc_hd__buf_1
XFILLER_7_582 VGND VGND VPWR VPWR sky130_fd_sc_hd__fill_2
Xmax_cap235 _5093_/X VGND VGND VPWR VPWR _5400_/A sky130_fd_sc_hd__buf_4
Xmax_cap224 _6023_/A VGND VGND VPWR VPWR _7475_/A sky130_fd_sc_hd__buf_4
Xmax_cap213 _5193_/X VGND VGND VPWR VPWR _7606_/A1 sky130_fd_sc_hd__buf_6
X_7270_ _7269_/X _7112_/X _7623_/S VGND VGND VPWR VPWR _7270_/X sky130_fd_sc_hd__mux2_2
X_4482_ _7898_/B _8045_/Q VGND VGND VPWR VPWR _4483_/A sky130_fd_sc_hd__and2_2
Xmax_cap246 _6507_/S VGND VGND VPWR VPWR _6707_/S sky130_fd_sc_hd__buf_12
X_6221_ _6210_/X _8245_/Q _8181_/Q VGND VGND VPWR VPWR _6221_/X sky130_fd_sc_hd__a21bo_2
X_6152_ _5407_/X _6099_/B _6192_/D _5732_/X VGND VGND VPWR VPWR _6152_/X sky130_fd_sc_hd__o31a_2
XFILLER_58_707 VGND VGND VPWR VPWR sky130_fd_sc_hd__decap_3
XFILLER_97_353 VGND VGND VPWR VPWR sky130_fd_sc_hd__decap_3
X_5103_ _6775_/B _5858_/B VGND VGND VPWR VPWR _7626_/A sky130_fd_sc_hd__nor2_2
XFILLER_112_686 VGND VGND VPWR VPWR sky130_fd_sc_hd__decap_3
XFILLER_58_729 VGND VGND VPWR VPWR sky130_fd_sc_hd__decap_3
XFILLER_97_375 VGND VGND VPWR VPWR sky130_fd_sc_hd__decap_3
X_6083_ _8241_/Q _6043_/B _6082_/X VGND VGND VPWR VPWR _6084_/B sky130_fd_sc_hd__o21ai_2
XFILLER_111_185 VGND VGND VPWR VPWR sky130_fd_sc_hd__decap_3
XFILLER_57_228 VGND VGND VPWR VPWR sky130_fd_sc_hd__decap_3
XFILLER_85_548 VGND VGND VPWR VPWR sky130_fd_sc_hd__decap_3
X_5034_ _8239_/Q _5032_/X _5977_/A VGND VGND VPWR VPWR _5034_/X sky130_fd_sc_hd__o21a_2
XFILLER_38_453 VGND VGND VPWR VPWR sky130_fd_sc_hd__decap_3
XFILLER_72_209 VGND VGND VPWR VPWR sky130_fd_sc_hd__decap_3
XFILLER_26_648 VGND VGND VPWR VPWR sky130_fd_sc_hd__decap_3
XFILLER_53_423 VGND VGND VPWR VPWR sky130_fd_sc_hd__decap_3
XFILLER_81_710 VGND VGND VPWR VPWR sky130_fd_sc_hd__decap_3
XFILLER_81_721 VGND VGND VPWR VPWR sky130_fd_sc_hd__decap_3
XFILLER_81_732 VGND VGND VPWR VPWR sky130_fd_sc_hd__fill_1
XFILLER_25_158 VGND VGND VPWR VPWR sky130_fd_sc_hd__decap_3
XFILLER_53_467 VGND VGND VPWR VPWR sky130_fd_sc_hd__decap_3
XFILLER_80_220 VGND VGND VPWR VPWR sky130_fd_sc_hd__decap_3
XTAP_TAPCELL_ROW_0_246 VGND VPWR sky130_fd_sc_hd__tapvpwrvgnd_1
XTAP_TAPCELL_ROW_0_257 VGND VPWR sky130_fd_sc_hd__tapvpwrvgnd_1
X_6985_ _6999_/A1 _6983_/X _6984_/Y _5332_/X VGND VGND VPWR VPWR _6985_/X sky130_fd_sc_hd__a22o_2
XFILLER_25_169 VGND VGND VPWR VPWR sky130_fd_sc_hd__decap_3
XFILLER_53_489 VGND VGND VPWR VPWR sky130_fd_sc_hd__decap_3
XFILLER_80_253 VGND VGND VPWR VPWR sky130_fd_sc_hd__decap_3
X_5936_ _5587_/A _5934_/X _6302_/D _5108_/X VGND VGND VPWR VPWR _5936_/X sky130_fd_sc_hd__a22o_2
XFILLER_80_286 VGND VGND VPWR VPWR sky130_fd_sc_hd__decap_3
XFILLER_21_331 VGND VGND VPWR VPWR sky130_fd_sc_hd__decap_3
X_7606_ _7606_/A1 _7580_/X _7605_/X _7843_/A VGND VGND VPWR VPWR _8356_/D sky130_fd_sc_hd__o211a_4
X_5867_ _5867_/A _5867_/B _5867_/C VGND VGND VPWR VPWR _5868_/C sky130_fd_sc_hd__and3_4
XFILLER_31_14 VGND VGND VPWR VPWR sky130_fd_sc_hd__decap_3
X_5798_ _7121_/A _5798_/B VGND VGND VPWR VPWR _8304_/D sky130_fd_sc_hd__nor2_2
X_4818_ _8266_/Q VGND VGND VPWR VPWR _6967_/A sky130_fd_sc_hd__inv_2
XFILLER_31_47 VGND VGND VPWR VPWR sky130_fd_sc_hd__decap_3
XFILLER_5_508 VGND VGND VPWR VPWR sky130_fd_sc_hd__decap_3
X_7537_ _8284_/Q _5292_/X _7536_/X _5111_/X VGND VGND VPWR VPWR _7537_/X sky130_fd_sc_hd__a211o_2
Xrebuffer635 _5311_/X VGND VGND VPWR VPWR _5312_/B sky130_fd_sc_hd__buf_2
X_4749_ _4749_/A _8282_/Q VGND VGND VPWR VPWR _4750_/B sky130_fd_sc_hd__nor2_2
XFILLER_119_274 VGND VGND VPWR VPWR sky130_fd_sc_hd__decap_3
X_7468_ _5333_/A _8218_/Q _7467_/Y _5402_/A _4750_/A VGND VGND VPWR VPWR _7468_/X
+ sky130_fd_sc_hd__a32o_2
XFILLER_103_6 VGND VGND VPWR VPWR sky130_fd_sc_hd__decap_3
X_6419_ _8187_/Q _8186_/Q _8185_/Q _8184_/Q _6380_/S _5452_/S VGND VGND VPWR VPWR
+ _6419_/X sky130_fd_sc_hd__mux4_2
XFILLER_1_725 VGND VGND VPWR VPWR sky130_fd_sc_hd__decap_3
XTAP_TAPCELL_ROW_112_1712 VGND VPWR sky130_fd_sc_hd__tapvpwrvgnd_1
X_7399_ _8212_/Q _8276_/Q _7327_/X _7328_/X VGND VGND VPWR VPWR _7399_/X sky130_fd_sc_hd__a31o_2
XFILLER_103_620 VGND VGND VPWR VPWR sky130_fd_sc_hd__decap_3
XFILLER_49_707 VGND VGND VPWR VPWR sky130_fd_sc_hd__fill_1
XTAP_TAPCELL_ROW_8_368 VGND VPWR sky130_fd_sc_hd__tapvpwrvgnd_1
XTAP_TAPCELL_ROW_8_357 VGND VPWR sky130_fd_sc_hd__tapvpwrvgnd_1
XFILLER_0_268 VGND VGND VPWR VPWR sky130_fd_sc_hd__decap_3
XFILLER_102_141 VGND VGND VPWR VPWR sky130_fd_sc_hd__decap_3
XFILLER_49_729 VGND VGND VPWR VPWR sky130_fd_sc_hd__decap_3
Xinput103 operand_b[3] VGND VGND VPWR VPWR _4310_/B sky130_fd_sc_hd__clkdlybuf4s25_1
Xinput114 operand_b[4] VGND VGND VPWR VPWR _4312_/B sky130_fd_sc_hd__clkdlybuf4s25_1
Xinput125 operand_b[5] VGND VGND VPWR VPWR _4314_/B sky130_fd_sc_hd__clkdlybuf4s25_1
XFILLER_102_174 VGND VGND VPWR VPWR sky130_fd_sc_hd__decap_3
XFILLER_29_420 VGND VGND VPWR VPWR sky130_fd_sc_hd__decap_3
XFILLER_76_548 VGND VGND VPWR VPWR sky130_fd_sc_hd__decap_3
XFILLER_29_464 VGND VGND VPWR VPWR sky130_fd_sc_hd__decap_3
XFILLER_56_55 VGND VGND VPWR VPWR sky130_fd_sc_hd__decap_3
XFILLER_44_401 VGND VGND VPWR VPWR sky130_fd_sc_hd__decap_3
XFILLER_56_88 VGND VGND VPWR VPWR sky130_fd_sc_hd__decap_3
XFILLER_84_592 VGND VGND VPWR VPWR sky130_fd_sc_hd__fill_2
XTAP_TAPCELL_ROW_27_610 VGND VPWR sky130_fd_sc_hd__tapvpwrvgnd_1
XFILLER_16_147 VGND VGND VPWR VPWR sky130_fd_sc_hd__decap_3
XFILLER_17_648 VGND VGND VPWR VPWR sky130_fd_sc_hd__fill_2
XFILLER_71_231 VGND VGND VPWR VPWR sky130_fd_sc_hd__decap_3
XFILLER_32_607 VGND VGND VPWR VPWR sky130_fd_sc_hd__decap_3
XFILLER_71_253 VGND VGND VPWR VPWR sky130_fd_sc_hd__decap_3
XFILLER_72_32 VGND VGND VPWR VPWR sky130_fd_sc_hd__decap_3
XTAP_TAPCELL_ROW_55_974 VGND VPWR sky130_fd_sc_hd__tapvpwrvgnd_1
XFILLER_24_180 VGND VGND VPWR VPWR sky130_fd_sc_hd__decap_3
XFILLER_12_331 VGND VGND VPWR VPWR sky130_fd_sc_hd__decap_3
XFILLER_12_353 VGND VGND VPWR VPWR sky130_fd_sc_hd__fill_1
XFILLER_40_662 VGND VGND VPWR VPWR sky130_fd_sc_hd__decap_3
XFILLER_8_302 VGND VGND VPWR VPWR sky130_fd_sc_hd__decap_3
XFILLER_8_368 VGND VGND VPWR VPWR sky130_fd_sc_hd__decap_3
XFILLER_4_541 VGND VGND VPWR VPWR sky130_fd_sc_hd__decap_3
XTAP_TAPCELL_ROW_74_1217 VGND VPWR sky130_fd_sc_hd__tapvpwrvgnd_1
XFILLER_4_563 VGND VGND VPWR VPWR sky130_fd_sc_hd__decap_3
XFILLER_79_320 VGND VGND VPWR VPWR sky130_fd_sc_hd__fill_2
XFILLER_98_139 VGND VGND VPWR VPWR sky130_fd_sc_hd__fill_1
XFILLER_79_375 VGND VGND VPWR VPWR sky130_fd_sc_hd__decap_3
XFILLER_94_301 VGND VGND VPWR VPWR sky130_fd_sc_hd__decap_3
XFILLER_39_228 VGND VGND VPWR VPWR sky130_fd_sc_hd__decap_3
XFILLER_54_209 VGND VGND VPWR VPWR sky130_fd_sc_hd__decap_3
XFILLER_35_423 VGND VGND VPWR VPWR sky130_fd_sc_hd__decap_3
XFILLER_63_732 VGND VGND VPWR VPWR sky130_fd_sc_hd__fill_1
XFILLER_75_592 VGND VGND VPWR VPWR sky130_fd_sc_hd__decap_3
XFILLER_94_389 VGND VGND VPWR VPWR sky130_fd_sc_hd__decap_3
XFILLER_47_294 VGND VGND VPWR VPWR sky130_fd_sc_hd__fill_1
XFILLER_90_551 VGND VGND VPWR VPWR sky130_fd_sc_hd__fill_2
XFILLER_22_106 VGND VGND VPWR VPWR sky130_fd_sc_hd__decap_3
XFILLER_23_629 VGND VGND VPWR VPWR sky130_fd_sc_hd__decap_3
XFILLER_50_404 VGND VGND VPWR VPWR sky130_fd_sc_hd__decap_3
XFILLER_62_253 VGND VGND VPWR VPWR sky130_fd_sc_hd__decap_3
XFILLER_90_562 VGND VGND VPWR VPWR sky130_fd_sc_hd__decap_3
XFILLER_90_584 VGND VGND VPWR VPWR sky130_fd_sc_hd__decap_3
X_6770_ _6721_/A _6623_/B _6766_/X _4827_/B _6769_/X VGND VGND VPWR VPWR _6770_/X
+ sky130_fd_sc_hd__o221a_2
X_3982_ _8344_/Q _7930_/B VGND VGND VPWR VPWR _3983_/A sky130_fd_sc_hd__and2_2
XTAP_TAPCELL_ROW_85_1368 VGND VPWR sky130_fd_sc_hd__tapvpwrvgnd_1
XFILLER_16_692 VGND VGND VPWR VPWR sky130_fd_sc_hd__decap_3
XFILLER_50_448 VGND VGND VPWR VPWR sky130_fd_sc_hd__decap_3
XFILLER_62_286 VGND VGND VPWR VPWR sky130_fd_sc_hd__decap_3
XFILLER_90_595 VGND VGND VPWR VPWR sky130_fd_sc_hd__decap_3
X_5721_ _5026_/B _5399_/X wire225/X VGND VGND VPWR VPWR _5721_/Y sky130_fd_sc_hd__o21ai_2
XFILLER_30_150 VGND VGND VPWR VPWR sky130_fd_sc_hd__decap_3
XFILLER_31_673 VGND VGND VPWR VPWR sky130_fd_sc_hd__decap_3
X_5652_ _8164_/Q _4958_/A _5100_/A VGND VGND VPWR VPWR _5656_/C sky130_fd_sc_hd__o21ai_2
X_8371_ _8385_/CLK _8371_/D VGND VGND VPWR VPWR _8371_/Q sky130_fd_sc_hd__dfxtp_2
X_5583_ _5572_/Y _5582_/Y _6247_/B VGND VGND VPWR VPWR _5583_/Y sky130_fd_sc_hd__a21oi_2
X_4603_ _4603_/A VGND VGND VPWR VPWR _8239_/D sky130_fd_sc_hd__buf_1
XFILLER_117_723 VGND VGND VPWR VPWR sky130_fd_sc_hd__decap_3
XFILLER_7_60 VGND VGND VPWR VPWR sky130_fd_sc_hd__decap_3
X_7322_ _6782_/X _7321_/X _6506_/X _7038_/X _6070_/A _6507_/S VGND VGND VPWR VPWR
+ _7322_/X sky130_fd_sc_hd__mux4_2
X_4534_ _7898_/B _8071_/Q VGND VGND VPWR VPWR _4535_/A sky130_fd_sc_hd__and2_2
XFILLER_104_406 VGND VGND VPWR VPWR sky130_fd_sc_hd__decap_3
XFILLER_117_39 VGND VGND VPWR VPWR sky130_fd_sc_hd__decap_3
XFILLER_89_128 VGND VGND VPWR VPWR sky130_fd_sc_hd__decap_3
X_7253_ _8274_/Q _7218_/B _7216_/X _8210_/Q VGND VGND VPWR VPWR _7255_/C sky130_fd_sc_hd__a31o_4
X_4465_ _4465_/A VGND VGND VPWR VPWR _8170_/D sky130_fd_sc_hd__buf_1
XFILLER_98_651 VGND VGND VPWR VPWR sky130_fd_sc_hd__fill_2
X_7184_ _8273_/Q VGND VGND VPWR VPWR _7221_/B sky130_fd_sc_hd__inv_2
X_6204_ _5550_/X _5520_/X _5552_/X _5521_/X _6130_/A _6648_/A VGND VGND VPWR VPWR
+ _6204_/X sky130_fd_sc_hd__mux4_2
X_4396_ _7930_/B _4396_/B VGND VGND VPWR VPWR _4397_/A sky130_fd_sc_hd__and2_2
XFILLER_112_461 VGND VGND VPWR VPWR sky130_fd_sc_hd__decap_3
X_6135_ _6353_/A _5447_/B _6009_/Y VGND VGND VPWR VPWR _6135_/X sky130_fd_sc_hd__o21a_2
XTAP_TAPCELL_ROW_5_327 VGND VPWR sky130_fd_sc_hd__tapvpwrvgnd_1
XFILLER_100_634 VGND VGND VPWR VPWR sky130_fd_sc_hd__decap_3
XFILLER_100_645 VGND VGND VPWR VPWR sky130_fd_sc_hd__decap_3
XFILLER_112_483 VGND VGND VPWR VPWR sky130_fd_sc_hd__decap_3
XFILLER_58_526 VGND VGND VPWR VPWR sky130_fd_sc_hd__decap_3
XFILLER_85_334 VGND VGND VPWR VPWR sky130_fd_sc_hd__fill_2
XFILLER_97_172 VGND VGND VPWR VPWR sky130_fd_sc_hd__decap_3
XFILLER_98_695 VGND VGND VPWR VPWR sky130_fd_sc_hd__decap_3
X_6066_ _6109_/A _6065_/X _5124_/A VGND VGND VPWR VPWR _6066_/Y sky130_fd_sc_hd__o21ai_2
X_5017_ _8165_/Q _5017_/B VGND VGND VPWR VPWR _5017_/Y sky130_fd_sc_hd__nand2_2
XFILLER_26_14 VGND VGND VPWR VPWR sky130_fd_sc_hd__decap_3
XFILLER_26_401 VGND VGND VPWR VPWR sky130_fd_sc_hd__decap_3
XFILLER_38_250 VGND VGND VPWR VPWR sky130_fd_sc_hd__fill_2
XFILLER_66_570 VGND VGND VPWR VPWR sky130_fd_sc_hd__fill_2
XFILLER_85_389 VGND VGND VPWR VPWR sky130_fd_sc_hd__decap_3
XFILLER_26_445 VGND VGND VPWR VPWR sky130_fd_sc_hd__fill_1
XFILLER_53_220 VGND VGND VPWR VPWR sky130_fd_sc_hd__decap_3
XFILLER_66_592 VGND VGND VPWR VPWR sky130_fd_sc_hd__decap_3
XFILLER_14_607 VGND VGND VPWR VPWR sky130_fd_sc_hd__fill_1
XFILLER_26_489 VGND VGND VPWR VPWR sky130_fd_sc_hd__decap_3
XFILLER_81_573 VGND VGND VPWR VPWR sky130_fd_sc_hd__fill_2
XFILLER_81_584 VGND VGND VPWR VPWR sky130_fd_sc_hd__decap_3
XFILLER_53_297 VGND VGND VPWR VPWR sky130_fd_sc_hd__decap_3
X_6968_ _8202_/Q _6966_/Y _6967_/Y VGND VGND VPWR VPWR _6968_/Y sky130_fd_sc_hd__a21oi_4
XTAP_TAPCELL_ROW_52_933 VGND VPWR sky130_fd_sc_hd__tapvpwrvgnd_1
XFILLER_22_651 VGND VGND VPWR VPWR sky130_fd_sc_hd__decap_3
XFILLER_42_35 VGND VGND VPWR VPWR sky130_fd_sc_hd__decap_3
X_6899_ _6899_/A _7009_/C VGND VGND VPWR VPWR _6975_/D sky130_fd_sc_hd__and2_2
X_5919_ _7202_/A _5919_/B VGND VGND VPWR VPWR _5919_/Y sky130_fd_sc_hd__nand2_2
XFILLER_21_172 VGND VGND VPWR VPWR sky130_fd_sc_hd__fill_1
XFILLER_22_695 VGND VGND VPWR VPWR sky130_fd_sc_hd__decap_3
XFILLER_108_701 VGND VGND VPWR VPWR sky130_fd_sc_hd__fill_1
XFILLER_21_194 VGND VGND VPWR VPWR sky130_fd_sc_hd__decap_3
XFILLER_107_211 VGND VGND VPWR VPWR sky130_fd_sc_hd__decap_3
Xrebuffer454 _8189_/Q VGND VGND VPWR VPWR _6549_/C sky130_fd_sc_hd__buf_2
XFILLER_107_244 VGND VGND VPWR VPWR sky130_fd_sc_hd__decap_3
XFILLER_107_277 VGND VGND VPWR VPWR sky130_fd_sc_hd__decap_3
XFILLER_3_18 VGND VGND VPWR VPWR sky130_fd_sc_hd__decap_3
XFILLER_103_461 VGND VGND VPWR VPWR sky130_fd_sc_hd__decap_3
XFILLER_110_409 VGND VGND VPWR VPWR sky130_fd_sc_hd__decap_3
XFILLER_89_651 VGND VGND VPWR VPWR sky130_fd_sc_hd__decap_3
XFILLER_89_673 VGND VGND VPWR VPWR sky130_fd_sc_hd__decap_3
XFILLER_103_472 VGND VGND VPWR VPWR sky130_fd_sc_hd__fill_1
XFILLER_103_494 VGND VGND VPWR VPWR sky130_fd_sc_hd__decap_3
XFILLER_88_183 VGND VGND VPWR VPWR sky130_fd_sc_hd__decap_3
XFILLER_76_345 VGND VGND VPWR VPWR sky130_fd_sc_hd__decap_3
XFILLER_17_412 VGND VGND VPWR VPWR sky130_fd_sc_hd__decap_3
XFILLER_29_250 VGND VGND VPWR VPWR sky130_fd_sc_hd__decap_3
XFILLER_57_570 VGND VGND VPWR VPWR sky130_fd_sc_hd__decap_3
XFILLER_76_389 VGND VGND VPWR VPWR sky130_fd_sc_hd__decap_3
XFILLER_91_315 VGND VGND VPWR VPWR sky130_fd_sc_hd__decap_3
XFILLER_17_434 VGND VGND VPWR VPWR sky130_fd_sc_hd__fill_2
XFILLER_29_294 VGND VGND VPWR VPWR sky130_fd_sc_hd__fill_1
XFILLER_45_732 VGND VGND VPWR VPWR sky130_fd_sc_hd__fill_1
XFILLER_83_20 VGND VGND VPWR VPWR sky130_fd_sc_hd__fill_1
XFILLER_83_53 VGND VGND VPWR VPWR sky130_fd_sc_hd__decap_3
XFILLER_91_337 VGND VGND VPWR VPWR sky130_fd_sc_hd__decap_3
XPHY_EDGE_ROW_103_Left_223 VGND VGND VPWR VPWR sky130_fd_sc_hd__decap_3
XFILLER_17_467 VGND VGND VPWR VPWR sky130_fd_sc_hd__decap_3
XFILLER_17_478 VGND VGND VPWR VPWR sky130_fd_sc_hd__decap_3
XFILLER_17_489 VGND VGND VPWR VPWR sky130_fd_sc_hd__decap_3
XFILLER_44_253 VGND VGND VPWR VPWR sky130_fd_sc_hd__decap_3
XFILLER_13_651 VGND VGND VPWR VPWR sky130_fd_sc_hd__decap_3
XFILLER_12_150 VGND VGND VPWR VPWR sky130_fd_sc_hd__decap_3
XFILLER_13_673 VGND VGND VPWR VPWR sky130_fd_sc_hd__decap_3
XFILLER_40_492 VGND VGND VPWR VPWR sky130_fd_sc_hd__decap_3
XTAP_TAPCELL_ROW_80_1298 VGND VPWR sky130_fd_sc_hd__tapvpwrvgnd_1
XTAP_TAPCELL_ROW_30_649 VGND VPWR sky130_fd_sc_hd__tapvpwrvgnd_1
XFILLER_9_699 VGND VGND VPWR VPWR sky130_fd_sc_hd__decap_3
XPHY_EDGE_ROW_112_Left_232 VGND VGND VPWR VPWR sky130_fd_sc_hd__decap_3
XTAP_TAPCELL_ROW_10_384 VGND VPWR sky130_fd_sc_hd__tapvpwrvgnd_1
XTAP_TAPCELL_ROW_10_395 VGND VPWR sky130_fd_sc_hd__tapvpwrvgnd_1
XFILLER_4_371 VGND VGND VPWR VPWR sky130_fd_sc_hd__decap_3
XFILLER_99_437 VGND VGND VPWR VPWR sky130_fd_sc_hd__decap_3
X_4250_ _7898_/B _4250_/B VGND VGND VPWR VPWR _4251_/A sky130_fd_sc_hd__and2_2
X_4181_ _4181_/A VGND VGND VPWR VPWR _8028_/D sky130_fd_sc_hd__buf_1
XFILLER_67_334 VGND VGND VPWR VPWR sky130_fd_sc_hd__fill_2
XFILLER_67_367 VGND VGND VPWR VPWR sky130_fd_sc_hd__decap_3
XFILLER_94_131 VGND VGND VPWR VPWR sky130_fd_sc_hd__decap_3
XFILLER_95_654 VGND VGND VPWR VPWR sky130_fd_sc_hd__fill_1
XFILLER_95_676 VGND VGND VPWR VPWR sky130_fd_sc_hd__decap_3
XFILLER_103_19 VGND VGND VPWR VPWR sky130_fd_sc_hd__decap_3
XFILLER_27_209 VGND VGND VPWR VPWR sky130_fd_sc_hd__decap_3
XFILLER_55_529 VGND VGND VPWR VPWR sky130_fd_sc_hd__decap_3
XFILLER_82_304 VGND VGND VPWR VPWR sky130_fd_sc_hd__decap_3
XFILLER_82_315 VGND VGND VPWR VPWR sky130_fd_sc_hd__decap_3
XFILLER_82_326 VGND VGND VPWR VPWR sky130_fd_sc_hd__decap_3
XFILLER_94_186 VGND VGND VPWR VPWR sky130_fd_sc_hd__decap_3
X_7940_ _8385_/CLK _7940_/D VGND VGND VPWR VPWR _7940_/Q sky130_fd_sc_hd__dfxtp_2
XFILLER_94_197 VGND VGND VPWR VPWR sky130_fd_sc_hd__decap_3
X_7871_ _7871_/A VGND VGND VPWR VPWR _8372_/D sky130_fd_sc_hd__buf_1
XTAP_TAPCELL_ROW_38_749 VGND VPWR sky130_fd_sc_hd__tapvpwrvgnd_1
X_6822_ _5671_/A _6248_/A _5581_/X _6070_/B VGND VGND VPWR VPWR _6822_/X sky130_fd_sc_hd__o211a_2
XFILLER_35_275 VGND VGND VPWR VPWR sky130_fd_sc_hd__decap_3
XTAP_TAPCELL_ROW_18_495 VGND VPWR sky130_fd_sc_hd__tapvpwrvgnd_1
XFILLER_50_234 VGND VGND VPWR VPWR sky130_fd_sc_hd__decap_3
XFILLER_50_256 VGND VGND VPWR VPWR sky130_fd_sc_hd__fill_2
X_6753_ _8196_/Q _8260_/Q _6752_/X VGND VGND VPWR VPWR _6753_/X sky130_fd_sc_hd__a21o_2
X_6684_ _8194_/Q _8258_/Q _7619_/A VGND VGND VPWR VPWR _6684_/X sky130_fd_sc_hd__o21a_2
X_5704_ _5585_/A _5867_/A _5703_/Y VGND VGND VPWR VPWR _5704_/Y sky130_fd_sc_hd__a21oi_2
XFILLER_12_27 VGND VGND VPWR VPWR sky130_fd_sc_hd__fill_1
X_5635_ _5634_/X _5391_/X _6706_/S VGND VGND VPWR VPWR _5635_/X sky130_fd_sc_hd__mux2_2
XTAP_TAPCELL_ROW_98_1537 VGND VPWR sky130_fd_sc_hd__tapvpwrvgnd_1
X_8354_ _8355_/CLK _8354_/D VGND VGND VPWR VPWR _8354_/Q sky130_fd_sc_hd__dfxtp_2
X_5566_ _5566_/A _5566_/B VGND VGND VPWR VPWR _5566_/Y sky130_fd_sc_hd__xnor2_2
XFILLER_104_203 VGND VGND VPWR VPWR sky130_fd_sc_hd__decap_3
XFILLER_117_564 VGND VGND VPWR VPWR sky130_fd_sc_hd__decap_3
X_8285_ _8285_/CLK _8285_/D VGND VGND VPWR VPWR _8285_/Q sky130_fd_sc_hd__dfxtp_2
X_7305_ _7305_/A1 _7280_/X _7304_/X _7930_/B VGND VGND VPWR VPWR _8346_/D sky130_fd_sc_hd__o211a_2
X_5497_ _7825_/A _8164_/Q VGND VGND VPWR VPWR _5497_/Y sky130_fd_sc_hd__nor2_2
X_4517_ _4517_/A VGND VGND VPWR VPWR _8196_/D sky130_fd_sc_hd__buf_1
XFILLER_104_236 VGND VGND VPWR VPWR sky130_fd_sc_hd__decap_3
X_7236_ _7619_/A _7233_/S _7235_/X _5601_/X _4786_/B VGND VGND VPWR VPWR _7236_/X
+ sky130_fd_sc_hd__o32a_2
X_4448_ _7898_/B _8028_/Q VGND VGND VPWR VPWR _4449_/A sky130_fd_sc_hd__and2_2
XFILLER_58_301 VGND VGND VPWR VPWR sky130_fd_sc_hd__decap_3
XFILLER_58_312 VGND VGND VPWR VPWR sky130_fd_sc_hd__decap_3
XFILLER_86_632 VGND VGND VPWR VPWR sky130_fd_sc_hd__decap_3
X_7167_ _6885_/A _7167_/B _7167_/C _7167_/D VGND VGND VPWR VPWR _7167_/X sky130_fd_sc_hd__and4b_2
X_4379_ _4379_/A VGND VGND VPWR VPWR _8127_/D sky130_fd_sc_hd__buf_1
XFILLER_37_24 VGND VGND VPWR VPWR sky130_fd_sc_hd__fill_2
XFILLER_86_654 VGND VGND VPWR VPWR sky130_fd_sc_hd__decap_3
X_7098_ _7095_/Y _7097_/Y _7098_/S VGND VGND VPWR VPWR _7098_/X sky130_fd_sc_hd__mux2_2
X_6118_ _4913_/B wire225/X _5399_/X _8179_/Q _8288_/Q VGND VGND VPWR VPWR _6118_/X
+ sky130_fd_sc_hd__o221a_2
XFILLER_27_710 VGND VGND VPWR VPWR sky130_fd_sc_hd__fill_2
XFILLER_37_57 VGND VGND VPWR VPWR sky130_fd_sc_hd__decap_3
XFILLER_46_529 VGND VGND VPWR VPWR sky130_fd_sc_hd__decap_3
XFILLER_58_389 VGND VGND VPWR VPWR sky130_fd_sc_hd__decap_3
XFILLER_73_315 VGND VGND VPWR VPWR sky130_fd_sc_hd__decap_3
XFILLER_85_164 VGND VGND VPWR VPWR sky130_fd_sc_hd__decap_3
X_6049_ _8241_/Q _5337_/A _5400_/A VGND VGND VPWR VPWR _6049_/Y sky130_fd_sc_hd__o21ai_2
XFILLER_27_732 VGND VGND VPWR VPWR sky130_fd_sc_hd__fill_1
XFILLER_73_337 VGND VGND VPWR VPWR sky130_fd_sc_hd__decap_3
XTAP_TAPCELL_ROW_107_1644 VGND VPWR sky130_fd_sc_hd__tapvpwrvgnd_1
XFILLER_26_253 VGND VGND VPWR VPWR sky130_fd_sc_hd__decap_3
XTAP_TAPCELL_ROW_107_1655 VGND VPWR sky130_fd_sc_hd__tapvpwrvgnd_1
XFILLER_26_286 VGND VGND VPWR VPWR sky130_fd_sc_hd__decap_3
XFILLER_41_212 VGND VGND VPWR VPWR sky130_fd_sc_hd__fill_2
XFILLER_41_223 VGND VGND VPWR VPWR sky130_fd_sc_hd__fill_1
XFILLER_53_34 VGND VGND VPWR VPWR sky130_fd_sc_hd__decap_3
XFILLER_81_370 VGND VGND VPWR VPWR sky130_fd_sc_hd__decap_3
XFILLER_41_256 VGND VGND VPWR VPWR sky130_fd_sc_hd__decap_3
XFILLER_53_78 VGND VGND VPWR VPWR sky130_fd_sc_hd__decap_3
XFILLER_22_470 VGND VGND VPWR VPWR sky130_fd_sc_hd__decap_3
XFILLER_22_492 VGND VGND VPWR VPWR sky130_fd_sc_hd__decap_3
XFILLER_5_113 VGND VGND VPWR VPWR sky130_fd_sc_hd__decap_3
XFILLER_10_698 VGND VGND VPWR VPWR sky130_fd_sc_hd__fill_2
XFILLER_5_146 VGND VGND VPWR VPWR sky130_fd_sc_hd__fill_2
Xrebuffer273 _6096_/A VGND VGND VPWR VPWR _5727_/B sky130_fd_sc_hd__buf_2
Xrebuffer262 _6838_/X VGND VGND VPWR VPWR _6856_/A2 sky130_fd_sc_hd__buf_2
XTAP_TAPCELL_ROW_58_1009 VGND VPWR sky130_fd_sc_hd__tapvpwrvgnd_1
XFILLER_108_575 VGND VGND VPWR VPWR sky130_fd_sc_hd__fill_1
XFILLER_5_157 VGND VGND VPWR VPWR sky130_fd_sc_hd__decap_3
XFILLER_5_179 VGND VGND VPWR VPWR sky130_fd_sc_hd__decap_3
XTAP_TAPCELL_ROW_118_1795 VGND VPWR sky130_fd_sc_hd__tapvpwrvgnd_1
Xrebuffer284 _8169_/Q VGND VGND VPWR VPWR _5828_/A2 sky130_fd_sc_hd__buf_2
XFILLER_118_71 VGND VGND VPWR VPWR sky130_fd_sc_hd__fill_2
XFILLER_78_20 VGND VGND VPWR VPWR sky130_fd_sc_hd__decap_3
XFILLER_110_206 VGND VGND VPWR VPWR sky130_fd_sc_hd__decap_3
XFILLER_111_729 VGND VGND VPWR VPWR sky130_fd_sc_hd__decap_3
XFILLER_68_109 VGND VGND VPWR VPWR sky130_fd_sc_hd__fill_2
XFILLER_110_239 VGND VGND VPWR VPWR sky130_fd_sc_hd__decap_3
XFILLER_1_385 VGND VGND VPWR VPWR sky130_fd_sc_hd__decap_3
XFILLER_49_312 VGND VGND VPWR VPWR sky130_fd_sc_hd__decap_3
XFILLER_77_632 VGND VGND VPWR VPWR sky130_fd_sc_hd__decap_3
XFILLER_78_97 VGND VGND VPWR VPWR sky130_fd_sc_hd__decap_3
XFILLER_49_334 VGND VGND VPWR VPWR sky130_fd_sc_hd__fill_2
XFILLER_49_367 VGND VGND VPWR VPWR sky130_fd_sc_hd__decap_3
XFILLER_64_315 VGND VGND VPWR VPWR sky130_fd_sc_hd__decap_3
XFILLER_76_153 VGND VGND VPWR VPWR sky130_fd_sc_hd__decap_3
XFILLER_92_602 VGND VGND VPWR VPWR sky130_fd_sc_hd__decap_3
XFILLER_17_220 VGND VGND VPWR VPWR sky130_fd_sc_hd__decap_3
XFILLER_18_721 VGND VGND VPWR VPWR sky130_fd_sc_hd__decap_3
XFILLER_64_348 VGND VGND VPWR VPWR sky130_fd_sc_hd__decap_3
XFILLER_76_197 VGND VGND VPWR VPWR sky130_fd_sc_hd__decap_3
XFILLER_91_134 VGND VGND VPWR VPWR sky130_fd_sc_hd__decap_3
XFILLER_17_231 VGND VGND VPWR VPWR sky130_fd_sc_hd__decap_3
XFILLER_91_156 VGND VGND VPWR VPWR sky130_fd_sc_hd__decap_3
XTAP_TAPCELL_ROW_35_719 VGND VPWR sky130_fd_sc_hd__tapvpwrvgnd_1
XTAP_TAPCELL_ROW_35_708 VGND VPWR sky130_fd_sc_hd__tapvpwrvgnd_1
XFILLER_17_275 VGND VGND VPWR VPWR sky130_fd_sc_hd__decap_3
XTAP_TAPCELL_ROW_82_1327 VGND VPWR sky130_fd_sc_hd__tapvpwrvgnd_1
XFILLER_60_565 VGND VGND VPWR VPWR sky130_fd_sc_hd__decap_3
XFILLER_32_267 VGND VGND VPWR VPWR sky130_fd_sc_hd__decap_3
XFILLER_32_278 VGND VGND VPWR VPWR sky130_fd_sc_hd__decap_3
XFILLER_60_576 VGND VGND VPWR VPWR sky130_fd_sc_hd__decap_3
XTAP_TAPCELL_ROW_15_454 VGND VPWR sky130_fd_sc_hd__tapvpwrvgnd_1
XFILLER_118_306 VGND VGND VPWR VPWR sky130_fd_sc_hd__fill_2
X_5420_ _5491_/A _5418_/X _5419_/X _6648_/A VGND VGND VPWR VPWR _5420_/X sky130_fd_sc_hd__a2bb2o_2
XFILLER_114_512 VGND VGND VPWR VPWR sky130_fd_sc_hd__decap_3
Xoutput204 _8022_/Q VGND VGND VPWR VPWR zero_flag sky130_fd_sc_hd__clkdlybuf4s25_1
X_5351_ _8290_/Q _5345_/X _5350_/Y _5276_/Y VGND VGND VPWR VPWR _5351_/X sky130_fd_sc_hd__a22o_2
XFILLER_99_212 VGND VGND VPWR VPWR sky130_fd_sc_hd__decap_3
XFILLER_99_245 VGND VGND VPWR VPWR sky130_fd_sc_hd__decap_3
X_8070_ _8228_/CLK _8070_/D VGND VGND VPWR VPWR _8070_/Q sky130_fd_sc_hd__dfxtp_2
X_5282_ _6767_/A _8290_/Q VGND VGND VPWR VPWR _6686_/B sky130_fd_sc_hd__nor2_2
X_4302_ _7898_/B _4302_/B VGND VGND VPWR VPWR _4303_/A sky130_fd_sc_hd__and2_2
XTAP_TAPCELL_ROW_93_1467 VGND VPWR sky130_fd_sc_hd__tapvpwrvgnd_1
XFILLER_102_707 VGND VGND VPWR VPWR sky130_fd_sc_hd__fill_1
X_7021_ _6452_/X _7020_/X _6166_/X _6742_/X _6708_/A _6818_/S VGND VGND VPWR VPWR
+ _7021_/X sky130_fd_sc_hd__mux4_2
X_4233_ _4233_/A VGND VGND VPWR VPWR _8054_/D sky130_fd_sc_hd__buf_1
XFILLER_101_228 VGND VGND VPWR VPWR sky130_fd_sc_hd__decap_3
XFILLER_4_94 VGND VGND VPWR VPWR sky130_fd_sc_hd__decap_3
XFILLER_68_610 VGND VGND VPWR VPWR sky130_fd_sc_hd__decap_3
XFILLER_114_18 VGND VGND VPWR VPWR sky130_fd_sc_hd__decap_3
XFILLER_114_29 VGND VGND VPWR VPWR sky130_fd_sc_hd__decap_3
X_4164_ _7930_/B _7952_/Q VGND VGND VPWR VPWR _4165_/A sky130_fd_sc_hd__and2_2
X_4095_ _4095_/A VGND VGND VPWR VPWR _7985_/D sky130_fd_sc_hd__buf_1
XFILLER_67_186 VGND VGND VPWR VPWR sky130_fd_sc_hd__decap_3
XFILLER_67_197 VGND VGND VPWR VPWR sky130_fd_sc_hd__decap_3
XFILLER_83_646 VGND VGND VPWR VPWR sky130_fd_sc_hd__decap_3
X_7923_ _7923_/A VGND VGND VPWR VPWR _8398_/D sky130_fd_sc_hd__buf_1
XFILLER_24_713 VGND VGND VPWR VPWR sky130_fd_sc_hd__fill_2
XFILLER_36_540 VGND VGND VPWR VPWR sky130_fd_sc_hd__decap_3
XFILLER_70_318 VGND VGND VPWR VPWR sky130_fd_sc_hd__decap_3
XFILLER_24_724 VGND VGND VPWR VPWR sky130_fd_sc_hd__fill_1
XFILLER_36_595 VGND VGND VPWR VPWR sky130_fd_sc_hd__decap_3
XFILLER_63_370 VGND VGND VPWR VPWR sky130_fd_sc_hd__decap_3
X_7854_ _8297_/Q _7930_/B VGND VGND VPWR VPWR _7855_/A sky130_fd_sc_hd__and2_2
XFILLER_23_256 VGND VGND VPWR VPWR sky130_fd_sc_hd__fill_2
X_7785_ _7652_/Y _7785_/B _7785_/C VGND VGND VPWR VPWR _7785_/X sky130_fd_sc_hd__and3b_2
X_6805_ _5508_/A _6762_/Y _6788_/X _6804_/X VGND VGND VPWR VPWR _6806_/B sky130_fd_sc_hd__o211a_2
X_6736_ _6874_/D _6736_/B VGND VGND VPWR VPWR _6736_/X sky130_fd_sc_hd__xor2_2
X_4997_ _8287_/Q _4997_/B VGND VGND VPWR VPWR _4997_/Y sky130_fd_sc_hd__nand2_2
XTAP_TAPCELL_ROW_102_1585 VGND VPWR sky130_fd_sc_hd__tapvpwrvgnd_1
X_6667_ _6667_/A _6725_/D VGND VGND VPWR VPWR _6669_/C sky130_fd_sc_hd__or2_2
X_6598_ _8191_/Q _8255_/Q _6593_/X _6594_/X _6597_/X VGND VGND VPWR VPWR _6599_/B
+ sky130_fd_sc_hd__a221o_2
X_5618_ _5618_/A VGND VGND VPWR VPWR _5718_/A sky130_fd_sc_hd__buf_1
XFILLER_117_361 VGND VGND VPWR VPWR sky130_fd_sc_hd__fill_1
X_8337_ _8401_/CLK _8337_/D VGND VGND VPWR VPWR _8337_/Q sky130_fd_sc_hd__dfxtp_2
X_5549_ _5249_/X _5248_/X _7653_/A VGND VGND VPWR VPWR _5549_/X sky130_fd_sc_hd__mux2_2
XFILLER_105_545 VGND VGND VPWR VPWR sky130_fd_sc_hd__fill_2
XFILLER_105_567 VGND VGND VPWR VPWR sky130_fd_sc_hd__fill_2
XFILLER_78_407 VGND VGND VPWR VPWR sky130_fd_sc_hd__decap_3
X_8268_ _8398_/CLK _8268_/D VGND VGND VPWR VPWR _8268_/Q sky130_fd_sc_hd__dfxtp_2
XFILLER_105_589 VGND VGND VPWR VPWR sky130_fd_sc_hd__decap_3
XFILLER_48_23 VGND VGND VPWR VPWR sky130_fd_sc_hd__decap_3
X_8199_ _8199_/CLK _8199_/D VGND VGND VPWR VPWR _8199_/Q sky130_fd_sc_hd__dfxtp_2
X_7219_ _7226_/A _7219_/B VGND VGND VPWR VPWR _7219_/Y sky130_fd_sc_hd__xnor2_2
XFILLER_58_131 VGND VGND VPWR VPWR sky130_fd_sc_hd__decap_3
XFILLER_59_665 VGND VGND VPWR VPWR sky130_fd_sc_hd__decap_3
XFILLER_86_451 VGND VGND VPWR VPWR sky130_fd_sc_hd__decap_3
XFILLER_19_529 VGND VGND VPWR VPWR sky130_fd_sc_hd__decap_3
XFILLER_46_315 VGND VGND VPWR VPWR sky130_fd_sc_hd__decap_3
XFILLER_59_676 VGND VGND VPWR VPWR sky130_fd_sc_hd__decap_3
XFILLER_86_473 VGND VGND VPWR VPWR sky130_fd_sc_hd__decap_3
XFILLER_58_197 VGND VGND VPWR VPWR sky130_fd_sc_hd__decap_3
XFILLER_73_134 VGND VGND VPWR VPWR sky130_fd_sc_hd__decap_3
XFILLER_74_657 VGND VGND VPWR VPWR sky130_fd_sc_hd__decap_3
XFILLER_61_307 VGND VGND VPWR VPWR sky130_fd_sc_hd__decap_3
XFILLER_64_44 VGND VGND VPWR VPWR sky130_fd_sc_hd__decap_3
XFILLER_73_167 VGND VGND VPWR VPWR sky130_fd_sc_hd__fill_1
XFILLER_27_573 VGND VGND VPWR VPWR sky130_fd_sc_hd__decap_3
XFILLER_27_595 VGND VGND VPWR VPWR sky130_fd_sc_hd__decap_3
XFILLER_64_88 VGND VGND VPWR VPWR sky130_fd_sc_hd__decap_3
XFILLER_14_234 VGND VGND VPWR VPWR sky130_fd_sc_hd__decap_3
XFILLER_14_256 VGND VGND VPWR VPWR sky130_fd_sc_hd__fill_1
XFILLER_42_543 VGND VGND VPWR VPWR sky130_fd_sc_hd__decap_3
XFILLER_14_278 VGND VGND VPWR VPWR sky130_fd_sc_hd__decap_3
XFILLER_80_32 VGND VGND VPWR VPWR sky130_fd_sc_hd__decap_3
XTAP_TAPCELL_ROW_12_413 VGND VPWR sky130_fd_sc_hd__tapvpwrvgnd_1
XTAP_TAPCELL_ROW_40_777 VGND VPWR sky130_fd_sc_hd__tapvpwrvgnd_1
XFILLER_10_473 VGND VGND VPWR VPWR sky130_fd_sc_hd__decap_3
XFILLER_13_81 VGND VGND VPWR VPWR sky130_fd_sc_hd__fill_1
XFILLER_6_433 VGND VGND VPWR VPWR sky130_fd_sc_hd__decap_3
XFILLER_108_361 VGND VGND VPWR VPWR sky130_fd_sc_hd__decap_3
XFILLER_115_309 VGND VGND VPWR VPWR sky130_fd_sc_hd__decap_3
XFILLER_108_372 VGND VGND VPWR VPWR sky130_fd_sc_hd__decap_3
XFILLER_69_418 VGND VGND VPWR VPWR sky130_fd_sc_hd__fill_2
XFILLER_89_96 VGND VGND VPWR VPWR sky130_fd_sc_hd__fill_1
XFILLER_2_683 VGND VGND VPWR VPWR sky130_fd_sc_hd__fill_2
XFILLER_96_215 VGND VGND VPWR VPWR sky130_fd_sc_hd__decap_3
XFILLER_29_6 VGND VGND VPWR VPWR sky130_fd_sc_hd__decap_3
XFILLER_49_131 VGND VGND VPWR VPWR sky130_fd_sc_hd__fill_1
XFILLER_96_248 VGND VGND VPWR VPWR sky130_fd_sc_hd__decap_3
XFILLER_96_259 VGND VGND VPWR VPWR sky130_fd_sc_hd__decap_3
XFILLER_37_315 VGND VGND VPWR VPWR sky130_fd_sc_hd__decap_3
XFILLER_49_175 VGND VGND VPWR VPWR sky130_fd_sc_hd__decap_3
XFILLER_92_410 VGND VGND VPWR VPWR sky130_fd_sc_hd__decap_3
XFILLER_37_337 VGND VGND VPWR VPWR sky130_fd_sc_hd__fill_1
XFILLER_37_348 VGND VGND VPWR VPWR sky130_fd_sc_hd__decap_3
XFILLER_64_134 VGND VGND VPWR VPWR sky130_fd_sc_hd__decap_3
XFILLER_77_495 VGND VGND VPWR VPWR sky130_fd_sc_hd__decap_3
XFILLER_92_421 VGND VGND VPWR VPWR sky130_fd_sc_hd__decap_3
XFILLER_64_156 VGND VGND VPWR VPWR sky130_fd_sc_hd__decap_3
XTAP_TAPCELL_ROW_48_888 VGND VPWR sky130_fd_sc_hd__tapvpwrvgnd_1
XTAP_TAPCELL_ROW_48_877 VGND VPWR sky130_fd_sc_hd__tapvpwrvgnd_1
XFILLER_18_595 VGND VGND VPWR VPWR sky130_fd_sc_hd__decap_3
XFILLER_52_318 VGND VGND VPWR VPWR sky130_fd_sc_hd__decap_3
X_4920_ _5900_/S _8237_/Q VGND VGND VPWR VPWR _5928_/A sky130_fd_sc_hd__or2_2
XFILLER_33_532 VGND VGND VPWR VPWR sky130_fd_sc_hd__fill_1
XFILLER_60_340 VGND VGND VPWR VPWR sky130_fd_sc_hd__decap_3
X_4851_ _4852_/A _8259_/Q VGND VGND VPWR VPWR _4851_/Y sky130_fd_sc_hd__nor2_2
XFILLER_60_362 VGND VGND VPWR VPWR sky130_fd_sc_hd__fill_2
XFILLER_20_215 VGND VGND VPWR VPWR sky130_fd_sc_hd__decap_3
XFILLER_20_248 VGND VGND VPWR VPWR sky130_fd_sc_hd__decap_3
X_4782_ _8274_/Q VGND VGND VPWR VPWR _4783_/B sky130_fd_sc_hd__inv_2
X_6521_ _6521_/A1 _6486_/B _6520_/X VGND VGND VPWR VPWR _6523_/B sky130_fd_sc_hd__o21a_2
XFILLER_119_648 VGND VGND VPWR VPWR sky130_fd_sc_hd__decap_3
X_6452_ _6451_/X _6380_/X _6322_/X _6239_/X _7812_/A _7670_/A VGND VGND VPWR VPWR
+ _6452_/X sky130_fd_sc_hd__mux4_2
XFILLER_106_309 VGND VGND VPWR VPWR sky130_fd_sc_hd__decap_3
Xclkload30 _8355_/CLK VGND VGND VPWR VPWR clkload30/X sky130_fd_sc_hd__clkbuf_4
X_5403_ _7619_/A _6648_/A _5417_/A _5402_/X VGND VGND VPWR VPWR _5403_/X sky130_fd_sc_hd__o211a_2
XFILLER_114_320 VGND VGND VPWR VPWR sky130_fd_sc_hd__decap_3
X_8122_ _8396_/CLK _8122_/D VGND VGND VPWR VPWR _8122_/Q sky130_fd_sc_hd__dfxtp_2
X_6383_ _7825_/A _6383_/B VGND VGND VPWR VPWR _6383_/Y sky130_fd_sc_hd__nor2_2
X_5334_ _7631_/B _6769_/B VGND VGND VPWR VPWR _5335_/A sky130_fd_sc_hd__or2_2
XFILLER_88_727 VGND VGND VPWR VPWR sky130_fd_sc_hd__decap_3
X_8053_ _8187_/CLK _8053_/D VGND VGND VPWR VPWR _8053_/Q sky130_fd_sc_hd__dfxtp_2
X_5265_ _8173_/Q _6024_/A _7805_/A VGND VGND VPWR VPWR _5265_/X sky130_fd_sc_hd__mux2_2
X_7004_ _5627_/A _6999_/X _7003_/X _8290_/Q _6687_/A VGND VGND VPWR VPWR _7024_/A
+ sky130_fd_sc_hd__a221o_2
X_5196_ _5286_/A _8292_/Q split/A VGND VGND VPWR VPWR _5197_/C sky130_fd_sc_hd__a21o_2
X_4216_ _7898_/B _4216_/B VGND VGND VPWR VPWR _4217_/A sky130_fd_sc_hd__and2_2
XFILLER_28_315 VGND VGND VPWR VPWR sky130_fd_sc_hd__fill_2
XFILLER_56_613 VGND VGND VPWR VPWR sky130_fd_sc_hd__decap_3
XFILLER_68_451 VGND VGND VPWR VPWR sky130_fd_sc_hd__decap_3
X_4147_ _4147_/A VGND VGND VPWR VPWR _8011_/D sky130_fd_sc_hd__buf_1
XFILLER_110_592 VGND VGND VPWR VPWR sky130_fd_sc_hd__decap_3
XFILLER_56_657 VGND VGND VPWR VPWR sky130_fd_sc_hd__decap_3
XFILLER_68_495 VGND VGND VPWR VPWR sky130_fd_sc_hd__decap_3
XFILLER_83_421 VGND VGND VPWR VPWR sky130_fd_sc_hd__fill_1
XFILLER_28_359 VGND VGND VPWR VPWR sky130_fd_sc_hd__decap_3
XFILLER_43_307 VGND VGND VPWR VPWR sky130_fd_sc_hd__decap_3
XFILLER_55_167 VGND VGND VPWR VPWR sky130_fd_sc_hd__fill_1
XFILLER_56_679 VGND VGND VPWR VPWR sky130_fd_sc_hd__decap_3
XFILLER_83_476 VGND VGND VPWR VPWR sky130_fd_sc_hd__decap_3
X_4078_ _7898_/B _8380_/Q VGND VGND VPWR VPWR _4079_/A sky130_fd_sc_hd__and2_2
XFILLER_24_521 VGND VGND VPWR VPWR sky130_fd_sc_hd__fill_2
XFILLER_55_189 VGND VGND VPWR VPWR sky130_fd_sc_hd__decap_3
XFILLER_70_126 VGND VGND VPWR VPWR sky130_fd_sc_hd__decap_3
XFILLER_71_638 VGND VGND VPWR VPWR sky130_fd_sc_hd__fill_2
XTAP_TAPCELL_ROW_104_1614 VGND VPWR sky130_fd_sc_hd__tapvpwrvgnd_1
X_7906_ _8323_/Q _7930_/B VGND VGND VPWR VPWR _7907_/A sky130_fd_sc_hd__and2_2
XFILLER_34_14 VGND VGND VPWR VPWR sky130_fd_sc_hd__decap_3
XFILLER_51_340 VGND VGND VPWR VPWR sky130_fd_sc_hd__decap_3
X_7837_ _8223_/Q _8287_/Q _7638_/Y _7836_/X VGND VGND VPWR VPWR _7837_/X sky130_fd_sc_hd__o31a_4
XFILLER_11_204 VGND VGND VPWR VPWR sky130_fd_sc_hd__fill_1
XFILLER_12_727 VGND VGND VPWR VPWR sky130_fd_sc_hd__decap_3
XFILLER_24_587 VGND VGND VPWR VPWR sky130_fd_sc_hd__fill_1
XFILLER_11_237 VGND VGND VPWR VPWR sky130_fd_sc_hd__decap_3
XFILLER_24_598 VGND VGND VPWR VPWR sky130_fd_sc_hd__decap_3
X_7768_ _7776_/A _7767_/B _7670_/B _7670_/A VGND VGND VPWR VPWR _7768_/Y sky130_fd_sc_hd__a211oi_2
X_7699_ _8187_/Q _7680_/B _7672_/A VGND VGND VPWR VPWR _7699_/Y sky130_fd_sc_hd__o21ai_2
Xclkload2 clkload2/A VGND VGND VPWR VPWR clkload2/Y sky130_fd_sc_hd__clkinvlp_4
X_6719_ _6717_/X _6718_/X _8195_/Q VGND VGND VPWR VPWR _6719_/Y sky130_fd_sc_hd__a21oi_2
XFILLER_109_169 VGND VGND VPWR VPWR sky130_fd_sc_hd__decap_3
XFILLER_105_320 VGND VGND VPWR VPWR sky130_fd_sc_hd__decap_3
XFILLER_3_436 VGND VGND VPWR VPWR sky130_fd_sc_hd__decap_3
XTAP_TAPCELL_ROW_115_1754 VGND VPWR sky130_fd_sc_hd__tapvpwrvgnd_1
XFILLER_3_458 VGND VGND VPWR VPWR sky130_fd_sc_hd__decap_3
XFILLER_59_55 VGND VGND VPWR VPWR sky130_fd_sc_hd__fill_1
XFILLER_59_99 VGND VGND VPWR VPWR sky130_fd_sc_hd__decap_3
XFILLER_78_248 VGND VGND VPWR VPWR sky130_fd_sc_hd__decap_3
XFILLER_78_259 VGND VGND VPWR VPWR sky130_fd_sc_hd__fill_1
XFILLER_94_719 VGND VGND VPWR VPWR sky130_fd_sc_hd__decap_3
XFILLER_115_72 VGND VGND VPWR VPWR sky130_fd_sc_hd__fill_2
XFILLER_19_304 VGND VGND VPWR VPWR sky130_fd_sc_hd__decap_3
XFILLER_75_21 VGND VGND VPWR VPWR sky130_fd_sc_hd__fill_1
XFILLER_93_218 VGND VGND VPWR VPWR sky130_fd_sc_hd__decap_3
XFILLER_19_337 VGND VGND VPWR VPWR sky130_fd_sc_hd__decap_3
XFILLER_46_101 VGND VGND VPWR VPWR sky130_fd_sc_hd__decap_3
XFILLER_59_484 VGND VGND VPWR VPWR sky130_fd_sc_hd__decap_3
XFILLER_59_495 VGND VGND VPWR VPWR sky130_fd_sc_hd__decap_3
XFILLER_74_410 VGND VGND VPWR VPWR sky130_fd_sc_hd__fill_1
XFILLER_74_421 VGND VGND VPWR VPWR sky130_fd_sc_hd__decap_3
XFILLER_75_43 VGND VGND VPWR VPWR sky130_fd_sc_hd__decap_3
XFILLER_46_156 VGND VGND VPWR VPWR sky130_fd_sc_hd__decap_3
XFILLER_47_668 VGND VGND VPWR VPWR sky130_fd_sc_hd__decap_3
XFILLER_74_454 VGND VGND VPWR VPWR sky130_fd_sc_hd__decap_3
XFILLER_75_87 VGND VGND VPWR VPWR sky130_fd_sc_hd__decap_3
XFILLER_27_370 VGND VGND VPWR VPWR sky130_fd_sc_hd__decap_3
XFILLER_34_318 VGND VGND VPWR VPWR sky130_fd_sc_hd__decap_3
XFILLER_74_487 VGND VGND VPWR VPWR sky130_fd_sc_hd__decap_3
XTAP_TAPCELL_ROW_66_1119 VGND VPWR sky130_fd_sc_hd__tapvpwrvgnd_1
XFILLER_15_532 VGND VGND VPWR VPWR sky130_fd_sc_hd__decap_3
XFILLER_61_159 VGND VGND VPWR VPWR sky130_fd_sc_hd__decap_3
XTAP_TAPCELL_ROW_45_847 VGND VPWR sky130_fd_sc_hd__tapvpwrvgnd_1
XFILLER_30_513 VGND VGND VPWR VPWR sky130_fd_sc_hd__decap_3
XFILLER_42_351 VGND VGND VPWR VPWR sky130_fd_sc_hd__decap_3
XFILLER_42_373 VGND VGND VPWR VPWR sky130_fd_sc_hd__decap_3
XFILLER_15_598 VGND VGND VPWR VPWR sky130_fd_sc_hd__decap_3
XFILLER_91_86 VGND VGND VPWR VPWR sky130_fd_sc_hd__decap_3
XTAP_TAPCELL_ROW_25_582 VGND VPWR sky130_fd_sc_hd__tapvpwrvgnd_1
XFILLER_24_91 VGND VGND VPWR VPWR sky130_fd_sc_hd__fill_1
XFILLER_30_557 VGND VGND VPWR VPWR sky130_fd_sc_hd__decap_3
XFILLER_6_241 VGND VGND VPWR VPWR sky130_fd_sc_hd__decap_3
XFILLER_6_296 VGND VGND VPWR VPWR sky130_fd_sc_hd__decap_3
XTAP_TAPCELL_ROW_77_1259 VGND VPWR sky130_fd_sc_hd__tapvpwrvgnd_1
XFILLER_111_312 VGND VGND VPWR VPWR sky130_fd_sc_hd__decap_3
XTAP_TAPCELL_ROW_90_1426 VGND VPWR sky130_fd_sc_hd__tapvpwrvgnd_1
XFILLER_2_491 VGND VGND VPWR VPWR sky130_fd_sc_hd__fill_1
XFILLER_85_708 VGND VGND VPWR VPWR sky130_fd_sc_hd__decap_3
XFILLER_97_546 VGND VGND VPWR VPWR sky130_fd_sc_hd__decap_3
X_5050_ _8251_/Q _5048_/X _5049_/X VGND VGND VPWR VPWR _5050_/X sky130_fd_sc_hd__o21a_2
XFILLER_111_378 VGND VGND VPWR VPWR sky130_fd_sc_hd__fill_1
XFILLER_27_3 VGND VGND VPWR VPWR sky130_fd_sc_hd__decap_3
XFILLER_84_218 VGND VGND VPWR VPWR sky130_fd_sc_hd__decap_3
X_4001_ _4001_/A VGND VGND VPWR VPWR _7949_/D sky130_fd_sc_hd__buf_1
XFILLER_65_432 VGND VGND VPWR VPWR sky130_fd_sc_hd__decap_3
XFILLER_77_270 VGND VGND VPWR VPWR sky130_fd_sc_hd__decap_3
XFILLER_77_281 VGND VGND VPWR VPWR sky130_fd_sc_hd__decap_3
XFILLER_65_454 VGND VGND VPWR VPWR sky130_fd_sc_hd__decap_3
XFILLER_92_240 VGND VGND VPWR VPWR sky130_fd_sc_hd__decap_3
XFILLER_1_84 VGND VGND VPWR VPWR sky130_fd_sc_hd__fill_1
XFILLER_25_318 VGND VGND VPWR VPWR sky130_fd_sc_hd__decap_3
XFILLER_52_115 VGND VGND VPWR VPWR sky130_fd_sc_hd__decap_3
XFILLER_53_638 VGND VGND VPWR VPWR sky130_fd_sc_hd__decap_3
XFILLER_65_487 VGND VGND VPWR VPWR sky130_fd_sc_hd__decap_3
XFILLER_80_424 VGND VGND VPWR VPWR sky130_fd_sc_hd__decap_3
X_5952_ _8223_/Q _7825_/B _5951_/Y _6070_/A VGND VGND VPWR VPWR _5952_/X sky130_fd_sc_hd__a211o_2
XTAP_TAPCELL_ROW_88_1399 VGND VPWR sky130_fd_sc_hd__tapvpwrvgnd_1
XFILLER_18_392 VGND VGND VPWR VPWR sky130_fd_sc_hd__decap_3
XFILLER_46_690 VGND VGND VPWR VPWR sky130_fd_sc_hd__decap_3
XFILLER_80_446 VGND VGND VPWR VPWR sky130_fd_sc_hd__decap_3
X_4903_ _6097_/A _8240_/Q VGND VGND VPWR VPWR _6039_/A sky130_fd_sc_hd__and2b_2
XFILLER_33_340 VGND VGND VPWR VPWR sky130_fd_sc_hd__decap_3
XFILLER_33_373 VGND VGND VPWR VPWR sky130_fd_sc_hd__decap_3
XFILLER_61_660 VGND VGND VPWR VPWR sky130_fd_sc_hd__decap_3
XFILLER_61_682 VGND VGND VPWR VPWR sky130_fd_sc_hd__decap_3
X_5883_ _8172_/Q _5884_/B _4939_/B _4928_/A VGND VGND VPWR VPWR _5883_/Y sky130_fd_sc_hd__a211oi_2
XFILLER_60_192 VGND VGND VPWR VPWR sky130_fd_sc_hd__decap_3
X_7622_ _8223_/Q _8222_/Q _8221_/Q _8220_/Q _7796_/A _7765_/A VGND VGND VPWR VPWR
+ _7622_/X sky130_fd_sc_hd__mux4_2
X_4834_ _8198_/Q _4834_/B VGND VGND VPWR VPWR _7152_/A sky130_fd_sc_hd__nand2_2
X_7553_ _8285_/Q _5296_/X _7552_/X _6686_/A _7453_/A VGND VGND VPWR VPWR _7567_/B
+ sky130_fd_sc_hd__a221o_2
X_4765_ _4980_/B _7366_/C VGND VGND VPWR VPWR _4766_/A sky130_fd_sc_hd__or2_2
Xrebuffer828 _8161_/Q VGND VGND VPWR VPWR _5284_/A sky130_fd_sc_hd__buf_4
Xrebuffer839 _8167_/Q VGND VGND VPWR VPWR _5690_/B sky130_fd_sc_hd__buf_2
X_6504_ _7694_/B _6504_/A2 _6503_/X VGND VGND VPWR VPWR _6504_/X sky130_fd_sc_hd__a21o_2
XFILLER_119_489 VGND VGND VPWR VPWR sky130_fd_sc_hd__decap_3
X_7484_ _6220_/X _7462_/Y _7463_/X _7483_/X VGND VGND VPWR VPWR _7484_/X sky130_fd_sc_hd__a31o_4
X_4696_ _7843_/A _8152_/Q VGND VGND VPWR VPWR _4697_/A sky130_fd_sc_hd__and2_2
X_6435_ _8185_/Q _8186_/Q _6336_/X _7264_/A VGND VGND VPWR VPWR _6435_/X sky130_fd_sc_hd__a31o_2
X_6366_ _6363_/X _6365_/Y _6366_/S VGND VGND VPWR VPWR _6366_/X sky130_fd_sc_hd__mux2_4
XFILLER_0_417 VGND VGND VPWR VPWR sky130_fd_sc_hd__decap_3
XFILLER_102_312 VGND VGND VPWR VPWR sky130_fd_sc_hd__decap_3
XFILLER_114_150 VGND VGND VPWR VPWR sky130_fd_sc_hd__decap_3
XFILLER_115_673 VGND VGND VPWR VPWR sky130_fd_sc_hd__decap_3
X_8105_ clkload5/A _8105_/D VGND VGND VPWR VPWR _8105_/Q sky130_fd_sc_hd__dfxtp_2
X_5317_ _5615_/A VGND VGND VPWR VPWR _6148_/A sky130_fd_sc_hd__buf_1
XFILLER_88_557 VGND VGND VPWR VPWR sky130_fd_sc_hd__fill_1
X_8036_ _8360_/CLK _8036_/D VGND VGND VPWR VPWR _8036_/Q sky130_fd_sc_hd__dfxtp_2
X_6297_ _6297_/A _6297_/B _6297_/C _6297_/D VGND VGND VPWR VPWR _6297_/X sky130_fd_sc_hd__and4_2
XFILLER_102_356 VGND VGND VPWR VPWR sky130_fd_sc_hd__decap_3
XFILLER_29_36 VGND VGND VPWR VPWR sky130_fd_sc_hd__decap_3
XTAP_TAPCELL_ROW_110_1684 VGND VPWR sky130_fd_sc_hd__tapvpwrvgnd_1
X_5248_ _7732_/B _7725_/B _7805_/A VGND VGND VPWR VPWR _5248_/X sky130_fd_sc_hd__mux2_2
XFILLER_102_389 VGND VGND VPWR VPWR sky130_fd_sc_hd__decap_3
XFILLER_28_112 VGND VGND VPWR VPWR sky130_fd_sc_hd__decap_3
XFILLER_56_410 VGND VGND VPWR VPWR sky130_fd_sc_hd__decap_3
XFILLER_56_421 VGND VGND VPWR VPWR sky130_fd_sc_hd__decap_3
XFILLER_68_281 VGND VGND VPWR VPWR sky130_fd_sc_hd__decap_3
XTAP_TAPCELL_ROW_110_1695 VGND VPWR sky130_fd_sc_hd__tapvpwrvgnd_1
X_5179_ _5175_/X _5176_/X _5177_/X _5178_/X _5684_/S _7745_/A VGND VGND VPWR VPWR
+ _5179_/X sky130_fd_sc_hd__mux4_2
XFILLER_29_668 VGND VGND VPWR VPWR sky130_fd_sc_hd__decap_3
XFILLER_29_679 VGND VGND VPWR VPWR sky130_fd_sc_hd__decap_3
XFILLER_16_318 VGND VGND VPWR VPWR sky130_fd_sc_hd__fill_1
XFILLER_28_167 VGND VGND VPWR VPWR sky130_fd_sc_hd__decap_3
XFILLER_45_35 VGND VGND VPWR VPWR sky130_fd_sc_hd__fill_1
XFILLER_71_402 VGND VGND VPWR VPWR sky130_fd_sc_hd__decap_3
XFILLER_83_262 VGND VGND VPWR VPWR sky130_fd_sc_hd__decap_3
XTAP_TAPCELL_ROW_3_299 VGND VPWR sky130_fd_sc_hd__tapvpwrvgnd_1
XFILLER_43_159 VGND VGND VPWR VPWR sky130_fd_sc_hd__decap_3
XFILLER_45_57 VGND VGND VPWR VPWR sky130_fd_sc_hd__decap_3
XFILLER_45_79 VGND VGND VPWR VPWR sky130_fd_sc_hd__decap_3
XFILLER_71_446 VGND VGND VPWR VPWR sky130_fd_sc_hd__fill_2
XFILLER_101_30 VGND VGND VPWR VPWR sky130_fd_sc_hd__decap_3
XFILLER_24_340 VGND VGND VPWR VPWR sky130_fd_sc_hd__fill_2
XFILLER_24_362 VGND VGND VPWR VPWR sky130_fd_sc_hd__fill_2
XTAP_TAPCELL_ROW_42_806 VGND VPWR sky130_fd_sc_hd__tapvpwrvgnd_1
XFILLER_101_63 VGND VGND VPWR VPWR sky130_fd_sc_hd__decap_3
XFILLER_12_513 VGND VGND VPWR VPWR sky130_fd_sc_hd__decap_3
XFILLER_12_568 VGND VGND VPWR VPWR sky130_fd_sc_hd__decap_3
XFILLER_8_528 VGND VGND VPWR VPWR sky130_fd_sc_hd__decap_3
XTAP_TAPCELL_ROW_61_1049 VGND VPWR sky130_fd_sc_hd__tapvpwrvgnd_1
XTAP_TAPCELL_ROW_22_541 VGND VPWR sky130_fd_sc_hd__tapvpwrvgnd_1
XFILLER_61_78 VGND VGND VPWR VPWR sky130_fd_sc_hd__decap_3
XFILLER_8_539 VGND VGND VPWR VPWR sky130_fd_sc_hd__fill_1
XFILLER_6_29 VGND VGND VPWR VPWR sky130_fd_sc_hd__decap_3
XFILLER_10_71 VGND VGND VPWR VPWR sky130_fd_sc_hd__decap_3
XFILLER_105_172 VGND VGND VPWR VPWR sky130_fd_sc_hd__decap_3
XFILLER_10_93 VGND VGND VPWR VPWR sky130_fd_sc_hd__decap_3
XFILLER_79_546 VGND VGND VPWR VPWR sky130_fd_sc_hd__decap_3
XFILLER_86_20 VGND VGND VPWR VPWR sky130_fd_sc_hd__decap_3
XFILLER_86_42 VGND VGND VPWR VPWR sky130_fd_sc_hd__decap_3
XFILLER_94_516 VGND VGND VPWR VPWR sky130_fd_sc_hd__decap_3
XTAP_TAPCELL_ROW_72_1189 VGND VPWR sky130_fd_sc_hd__tapvpwrvgnd_1
XFILLER_59_281 VGND VGND VPWR VPWR sky130_fd_sc_hd__decap_3
XFILLER_86_97 VGND VGND VPWR VPWR sky130_fd_sc_hd__decap_3
XFILLER_19_134 VGND VGND VPWR VPWR sky130_fd_sc_hd__decap_3
XFILLER_19_167 VGND VGND VPWR VPWR sky130_fd_sc_hd__fill_1
XFILLER_19_178 VGND VGND VPWR VPWR sky130_fd_sc_hd__fill_1
XFILLER_35_627 VGND VGND VPWR VPWR sky130_fd_sc_hd__decap_3
XFILLER_47_476 VGND VGND VPWR VPWR sky130_fd_sc_hd__decap_3
XFILLER_62_424 VGND VGND VPWR VPWR sky130_fd_sc_hd__decap_3
XFILLER_74_251 VGND VGND VPWR VPWR sky130_fd_sc_hd__fill_1
XFILLER_74_262 VGND VGND VPWR VPWR sky130_fd_sc_hd__decap_3
XFILLER_34_137 VGND VGND VPWR VPWR sky130_fd_sc_hd__decap_3
XFILLER_62_457 VGND VGND VPWR VPWR sky130_fd_sc_hd__decap_3
XFILLER_15_362 VGND VGND VPWR VPWR sky130_fd_sc_hd__decap_3
XFILLER_43_660 VGND VGND VPWR VPWR sky130_fd_sc_hd__decap_3
XFILLER_50_608 VGND VGND VPWR VPWR sky130_fd_sc_hd__decap_3
XFILLER_30_321 VGND VGND VPWR VPWR sky130_fd_sc_hd__fill_2
XFILLER_30_332 VGND VGND VPWR VPWR sky130_fd_sc_hd__decap_3
XFILLER_30_387 VGND VGND VPWR VPWR sky130_fd_sc_hd__decap_3
XFILLER_116_404 VGND VGND VPWR VPWR sky130_fd_sc_hd__decap_3
XFILLER_7_550 VGND VGND VPWR VPWR sky130_fd_sc_hd__decap_3
X_4550_ _7843_/A _8079_/Q VGND VGND VPWR VPWR _4551_/A sky130_fd_sc_hd__and2_2
XFILLER_7_561 VGND VGND VPWR VPWR sky130_fd_sc_hd__decap_3
Xmax_cap214 _6011_/X VGND VGND VPWR VPWR _7193_/B sky130_fd_sc_hd__buf_4
X_4481_ _4481_/A VGND VGND VPWR VPWR _8178_/D sky130_fd_sc_hd__buf_1
XFILLER_116_459 VGND VGND VPWR VPWR sky130_fd_sc_hd__decap_3
Xmax_cap247 _8227_/Q VGND VGND VPWR VPWR _6507_/S sky130_fd_sc_hd__buf_12
Xmax_cap236 _7787_/A VGND VGND VPWR VPWR _7797_/A1 sky130_fd_sc_hd__buf_4
X_6220_ _6220_/A VGND VGND VPWR VPWR _6220_/X sky130_fd_sc_hd__clkbuf_1
X_6151_ _8178_/Q _8179_/Q VGND VGND VPWR VPWR _6192_/D sky130_fd_sc_hd__nand2_2
XFILLER_112_643 VGND VGND VPWR VPWR sky130_fd_sc_hd__fill_1
XFILLER_112_654 VGND VGND VPWR VPWR sky130_fd_sc_hd__decap_3
XFILLER_97_321 VGND VGND VPWR VPWR sky130_fd_sc_hd__decap_3
X_5102_ _5107_/A _7631_/B VGND VGND VPWR VPWR _5858_/B sky130_fd_sc_hd__nand2_2
XFILLER_57_207 VGND VGND VPWR VPWR sky130_fd_sc_hd__decap_3
XFILLER_85_505 VGND VGND VPWR VPWR sky130_fd_sc_hd__decap_3
X_6082_ _8241_/Q _6043_/B _8177_/Q VGND VGND VPWR VPWR _6082_/X sky130_fd_sc_hd__a21bo_2
XFILLER_112_698 VGND VGND VPWR VPWR sky130_fd_sc_hd__fill_2
X_5033_ _6022_/B VGND VGND VPWR VPWR _5977_/A sky130_fd_sc_hd__inv_2
XFILLER_26_605 VGND VGND VPWR VPWR sky130_fd_sc_hd__decap_3
XFILLER_38_432 VGND VGND VPWR VPWR sky130_fd_sc_hd__decap_3
XFILLER_38_465 VGND VGND VPWR VPWR sky130_fd_sc_hd__decap_3
XFILLER_65_240 VGND VGND VPWR VPWR sky130_fd_sc_hd__decap_3
XFILLER_38_487 VGND VGND VPWR VPWR sky130_fd_sc_hd__decap_3
XFILLER_38_498 VGND VGND VPWR VPWR sky130_fd_sc_hd__decap_3
XFILLER_65_262 VGND VGND VPWR VPWR sky130_fd_sc_hd__fill_2
XFILLER_65_284 VGND VGND VPWR VPWR sky130_fd_sc_hd__decap_3
XFILLER_93_582 VGND VGND VPWR VPWR sky130_fd_sc_hd__decap_3
XFILLER_53_435 VGND VGND VPWR VPWR sky130_fd_sc_hd__decap_3
XTAP_TAPCELL_ROW_0_247 VGND VPWR sky130_fd_sc_hd__tapvpwrvgnd_1
XTAP_TAPCELL_ROW_0_258 VGND VPWR sky130_fd_sc_hd__tapvpwrvgnd_1
X_6984_ _8288_/Q _4814_/A _4814_/B VGND VGND VPWR VPWR _6984_/Y sky130_fd_sc_hd__o21ai_2
XFILLER_53_479 VGND VGND VPWR VPWR sky130_fd_sc_hd__fill_2
XFILLER_80_265 VGND VGND VPWR VPWR sky130_fd_sc_hd__fill_2
X_5935_ _6024_/A _8238_/Q VGND VGND VPWR VPWR _6302_/D sky130_fd_sc_hd__or2_2
XFILLER_34_693 VGND VGND VPWR VPWR sky130_fd_sc_hd__decap_3
XFILLER_40_129 VGND VGND VPWR VPWR sky130_fd_sc_hd__fill_2
XFILLER_80_298 VGND VGND VPWR VPWR sky130_fd_sc_hd__decap_3
X_5866_ _8229_/Q _5857_/Y _5863_/Y _5865_/Y VGND VGND VPWR VPWR _5866_/X sky130_fd_sc_hd__a22o_2
XFILLER_21_343 VGND VGND VPWR VPWR sky130_fd_sc_hd__decap_3
X_7605_ _7209_/A _7588_/Y _7590_/Y _7604_/X VGND VGND VPWR VPWR _7605_/X sky130_fd_sc_hd__a211o_2
X_4817_ _4817_/A _8266_/Q VGND VGND VPWR VPWR _4820_/A sky130_fd_sc_hd__nand2_2
XFILLER_21_365 VGND VGND VPWR VPWR sky130_fd_sc_hd__decap_3
X_5797_ _5193_/X _5788_/X _5796_/X VGND VGND VPWR VPWR _5798_/B sky130_fd_sc_hd__a21oi_2
X_7536_ _7474_/A _7561_/B _5615_/A _7536_/B2 VGND VGND VPWR VPWR _7536_/X sky130_fd_sc_hd__a2bb2o_2
X_4748_ _8218_/Q VGND VGND VPWR VPWR _4749_/A sky130_fd_sc_hd__inv_2
XFILLER_107_426 VGND VGND VPWR VPWR sky130_fd_sc_hd__decap_3
X_7467_ _8282_/Q _5398_/A _5338_/A VGND VGND VPWR VPWR _7467_/Y sky130_fd_sc_hd__o21ai_2
X_4679_ _4679_/A VGND VGND VPWR VPWR _8277_/D sky130_fd_sc_hd__buf_1
XPHY_EDGE_ROW_1_Right_1 VGND VGND VPWR VPWR sky130_fd_sc_hd__decap_3
X_6418_ _8187_/Q _8251_/Q _6417_/X VGND VGND VPWR VPWR _6418_/X sky130_fd_sc_hd__a21o_2
XTAP_TAPCELL_ROW_112_1713 VGND VPWR sky130_fd_sc_hd__tapvpwrvgnd_1
X_7398_ _7398_/A _7398_/B _7398_/C _7398_/D VGND VGND VPWR VPWR _7398_/X sky130_fd_sc_hd__and4_2
XFILLER_102_120 VGND VGND VPWR VPWR sky130_fd_sc_hd__decap_3
XFILLER_103_632 VGND VGND VPWR VPWR sky130_fd_sc_hd__fill_2
XFILLER_103_643 VGND VGND VPWR VPWR sky130_fd_sc_hd__decap_3
XFILLER_88_343 VGND VGND VPWR VPWR sky130_fd_sc_hd__fill_2
X_6349_ _7825_/A _6349_/B VGND VGND VPWR VPWR _6349_/Y sky130_fd_sc_hd__nor2_2
XTAP_TAPCELL_ROW_8_369 VGND VPWR sky130_fd_sc_hd__tapvpwrvgnd_1
XTAP_TAPCELL_ROW_8_358 VGND VPWR sky130_fd_sc_hd__tapvpwrvgnd_1
XFILLER_102_153 VGND VGND VPWR VPWR sky130_fd_sc_hd__decap_3
XFILLER_103_665 VGND VGND VPWR VPWR sky130_fd_sc_hd__decap_3
XFILLER_76_516 VGND VGND VPWR VPWR sky130_fd_sc_hd__decap_3
XFILLER_88_365 VGND VGND VPWR VPWR sky130_fd_sc_hd__decap_3
Xinput104 operand_b[40] VGND VGND VPWR VPWR _4384_/B sky130_fd_sc_hd__clkdlybuf4s25_1
Xinput115 operand_b[50] VGND VGND VPWR VPWR _4404_/B sky130_fd_sc_hd__clkdlybuf4s25_1
Xinput126 operand_b[60] VGND VGND VPWR VPWR _4424_/B sky130_fd_sc_hd__clkdlybuf4s25_1
XFILLER_102_186 VGND VGND VPWR VPWR sky130_fd_sc_hd__decap_3
XFILLER_102_197 VGND VGND VPWR VPWR sky130_fd_sc_hd__decap_3
XFILLER_48_218 VGND VGND VPWR VPWR sky130_fd_sc_hd__decap_3
X_8019_ _8353_/CLK _8019_/D VGND VGND VPWR VPWR _8019_/Q sky130_fd_sc_hd__dfxtp_2
XFILLER_91_508 VGND VGND VPWR VPWR sky130_fd_sc_hd__decap_3
XFILLER_91_519 VGND VGND VPWR VPWR sky130_fd_sc_hd__decap_3
XFILLER_29_476 VGND VGND VPWR VPWR sky130_fd_sc_hd__decap_3
XFILLER_29_498 VGND VGND VPWR VPWR sky130_fd_sc_hd__decap_3
XFILLER_44_413 VGND VGND VPWR VPWR sky130_fd_sc_hd__decap_3
XFILLER_56_251 VGND VGND VPWR VPWR sky130_fd_sc_hd__fill_1
XFILLER_56_273 VGND VGND VPWR VPWR sky130_fd_sc_hd__decap_3
XFILLER_56_67 VGND VGND VPWR VPWR sky130_fd_sc_hd__decap_3
XFILLER_84_560 VGND VGND VPWR VPWR sky130_fd_sc_hd__decap_3
XTAP_TAPCELL_ROW_27_611 VGND VPWR sky130_fd_sc_hd__tapvpwrvgnd_1
XFILLER_44_424 VGND VGND VPWR VPWR sky130_fd_sc_hd__decap_3
XFILLER_44_457 VGND VGND VPWR VPWR sky130_fd_sc_hd__decap_3
XFILLER_16_159 VGND VGND VPWR VPWR sky130_fd_sc_hd__decap_3
XFILLER_25_660 VGND VGND VPWR VPWR sky130_fd_sc_hd__fill_1
XFILLER_31_107 VGND VGND VPWR VPWR sky130_fd_sc_hd__decap_3
XFILLER_71_265 VGND VGND VPWR VPWR sky130_fd_sc_hd__decap_3
XTAP_TAPCELL_ROW_55_975 VGND VPWR sky130_fd_sc_hd__tapvpwrvgnd_1
XFILLER_24_192 VGND VGND VPWR VPWR sky130_fd_sc_hd__decap_3
XFILLER_72_88 VGND VGND VPWR VPWR sky130_fd_sc_hd__decap_3
XFILLER_12_365 VGND VGND VPWR VPWR sky130_fd_sc_hd__decap_3
XFILLER_40_674 VGND VGND VPWR VPWR sky130_fd_sc_hd__decap_3
XFILLER_40_696 VGND VGND VPWR VPWR sky130_fd_sc_hd__decap_3
XFILLER_4_531 VGND VGND VPWR VPWR sky130_fd_sc_hd__fill_1
XTAP_TAPCELL_ROW_74_1218 VGND VPWR sky130_fd_sc_hd__tapvpwrvgnd_1
XFILLER_4_553 VGND VGND VPWR VPWR sky130_fd_sc_hd__fill_1
XFILLER_4_586 VGND VGND VPWR VPWR sky130_fd_sc_hd__fill_2
XFILLER_97_41 VGND VGND VPWR VPWR sky130_fd_sc_hd__decap_3
XFILLER_4_597 VGND VGND VPWR VPWR sky130_fd_sc_hd__fill_1
XFILLER_79_354 VGND VGND VPWR VPWR sky130_fd_sc_hd__decap_3
XFILLER_67_527 VGND VGND VPWR VPWR sky130_fd_sc_hd__decap_3
XFILLER_94_335 VGND VGND VPWR VPWR sky130_fd_sc_hd__decap_3
XFILLER_94_368 VGND VGND VPWR VPWR sky130_fd_sc_hd__decap_3
Xsplit267 _5943_/A VGND VGND VPWR VPWR _7783_/B sky130_fd_sc_hd__buf_4
XFILLER_35_402 VGND VGND VPWR VPWR sky130_fd_sc_hd__decap_3
XFILLER_82_519 VGND VGND VPWR VPWR sky130_fd_sc_hd__decap_3
XFILLER_35_435 VGND VGND VPWR VPWR sky130_fd_sc_hd__decap_3
XFILLER_47_284 VGND VGND VPWR VPWR sky130_fd_sc_hd__fill_1
XFILLER_62_232 VGND VGND VPWR VPWR sky130_fd_sc_hd__decap_3
XFILLER_16_660 VGND VGND VPWR VPWR sky130_fd_sc_hd__decap_3
XFILLER_35_479 VGND VGND VPWR VPWR sky130_fd_sc_hd__decap_3
XFILLER_62_243 VGND VGND VPWR VPWR sky130_fd_sc_hd__decap_3
XFILLER_62_265 VGND VGND VPWR VPWR sky130_fd_sc_hd__decap_3
X_3981_ _3981_/A VGND VGND VPWR VPWR _7939_/D sky130_fd_sc_hd__buf_1
XTAP_TAPCELL_ROW_85_1369 VGND VPWR sky130_fd_sc_hd__tapvpwrvgnd_1
XTAP_TAPCELL_ROW_85_1358 VGND VPWR sky130_fd_sc_hd__tapvpwrvgnd_1
XFILLER_22_118 VGND VGND VPWR VPWR sky130_fd_sc_hd__decap_3
XFILLER_50_427 VGND VGND VPWR VPWR sky130_fd_sc_hd__decap_3
XFILLER_62_298 VGND VGND VPWR VPWR sky130_fd_sc_hd__decap_3
X_5720_ _5026_/B _5718_/X _6121_/B _5719_/Y VGND VGND VPWR VPWR _5720_/X sky130_fd_sc_hd__a22o_2
XFILLER_31_630 VGND VGND VPWR VPWR sky130_fd_sc_hd__decap_3
XFILLER_43_490 VGND VGND VPWR VPWR sky130_fd_sc_hd__decap_3
Xclkbuf_leaf_42_clk clkload0/A VGND VGND VPWR VPWR clkload9/A sky130_fd_sc_hd__clkbuf_8
X_5651_ _5651_/A _5651_/B VGND VGND VPWR VPWR _5651_/Y sky130_fd_sc_hd__nand2_2
XFILLER_30_184 VGND VGND VPWR VPWR sky130_fd_sc_hd__decap_3
X_8370_ _8385_/CLK _8370_/D VGND VGND VPWR VPWR _8370_/Q sky130_fd_sc_hd__dfxtp_2
X_5582_ _5671_/A _6248_/A _5581_/X _7193_/A VGND VGND VPWR VPWR _5582_/Y sky130_fd_sc_hd__o211ai_2
X_4602_ _7898_/B _8105_/Q VGND VGND VPWR VPWR _4603_/A sky130_fd_sc_hd__and2_2
XFILLER_7_50 VGND VGND VPWR VPWR sky130_fd_sc_hd__decap_3
XFILLER_7_72 VGND VGND VPWR VPWR sky130_fd_sc_hd__decap_3
X_7321_ _7320_/X _7199_/X _7670_/A VGND VGND VPWR VPWR _7321_/X sky130_fd_sc_hd__mux2_2
X_4533_ _4533_/A VGND VGND VPWR VPWR _8204_/D sky130_fd_sc_hd__buf_1
XFILLER_117_18 VGND VGND VPWR VPWR sky130_fd_sc_hd__decap_3
XFILLER_7_380 VGND VGND VPWR VPWR sky130_fd_sc_hd__decap_3
X_7252_ _7216_/X _7218_/B _8274_/Q VGND VGND VPWR VPWR _7255_/B sky130_fd_sc_hd__a21o_2
XFILLER_116_256 VGND VGND VPWR VPWR sky130_fd_sc_hd__decap_3
X_6203_ _6529_/A _6203_/B VGND VGND VPWR VPWR _6203_/Y sky130_fd_sc_hd__nand2_2
X_4464_ _7898_/B _8036_/Q VGND VGND VPWR VPWR _4465_/A sky130_fd_sc_hd__and2_2
X_7183_ _8209_/Q _6334_/A _7130_/A _7182_/Y VGND VGND VPWR VPWR _7183_/X sky130_fd_sc_hd__o31a_2
X_4395_ _4395_/A VGND VGND VPWR VPWR _8135_/D sky130_fd_sc_hd__buf_1
XFILLER_100_602 VGND VGND VPWR VPWR sky130_fd_sc_hd__decap_3
XFILLER_98_674 VGND VGND VPWR VPWR sky130_fd_sc_hd__decap_3
X_6134_ _6109_/A _6133_/X _5186_/A VGND VGND VPWR VPWR _6134_/Y sky130_fd_sc_hd__o21ai_2
XTAP_TAPCELL_ROW_5_328 VGND VPWR sky130_fd_sc_hd__tapvpwrvgnd_1
XFILLER_112_473 VGND VGND VPWR VPWR sky130_fd_sc_hd__decap_3
XFILLER_112_495 VGND VGND VPWR VPWR sky130_fd_sc_hd__decap_3
XFILLER_58_549 VGND VGND VPWR VPWR sky130_fd_sc_hd__decap_3
XFILLER_97_184 VGND VGND VPWR VPWR sky130_fd_sc_hd__decap_3
X_6065_ _5250_/X _5228_/X _5262_/X _5235_/X _6130_/A _6648_/A VGND VGND VPWR VPWR
+ _6065_/X sky130_fd_sc_hd__mux4_2
XFILLER_100_657 VGND VGND VPWR VPWR sky130_fd_sc_hd__decap_3
XFILLER_85_346 VGND VGND VPWR VPWR sky130_fd_sc_hd__decap_3
X_5016_ _8165_/Q _5017_/B VGND VGND VPWR VPWR _5016_/Y sky130_fd_sc_hd__nor2_2
XFILLER_26_413 VGND VGND VPWR VPWR sky130_fd_sc_hd__decap_3
XFILLER_26_26 VGND VGND VPWR VPWR sky130_fd_sc_hd__fill_2
XFILLER_26_424 VGND VGND VPWR VPWR sky130_fd_sc_hd__decap_3
XFILLER_81_530 VGND VGND VPWR VPWR sky130_fd_sc_hd__decap_3
XFILLER_81_541 VGND VGND VPWR VPWR sky130_fd_sc_hd__decap_3
XFILLER_41_405 VGND VGND VPWR VPWR sky130_fd_sc_hd__decap_3
XFILLER_53_243 VGND VGND VPWR VPWR sky130_fd_sc_hd__fill_2
X_6967_ _6967_/A _6967_/B VGND VGND VPWR VPWR _6967_/Y sky130_fd_sc_hd__nor2_2
XFILLER_41_427 VGND VGND VPWR VPWR sky130_fd_sc_hd__decap_3
XFILLER_41_449 VGND VGND VPWR VPWR sky130_fd_sc_hd__decap_3
XFILLER_81_596 VGND VGND VPWR VPWR sky130_fd_sc_hd__decap_3
X_5918_ _5917_/X _5545_/X _6421_/S VGND VGND VPWR VPWR _5919_/B sky130_fd_sc_hd__mux2_2
XTAP_TAPCELL_ROW_52_934 VGND VPWR sky130_fd_sc_hd__tapvpwrvgnd_1
Xclkbuf_leaf_33_clk clkbuf_2_2__f_clk/X VGND VGND VPWR VPWR _8382_/CLK sky130_fd_sc_hd__clkbuf_8
X_6898_ _8197_/Q _8198_/Q _8199_/Q VGND VGND VPWR VPWR _7009_/C sky130_fd_sc_hd__and3_2
XFILLER_21_151 VGND VGND VPWR VPWR sky130_fd_sc_hd__decap_3
XFILLER_22_663 VGND VGND VPWR VPWR sky130_fd_sc_hd__decap_3
XFILLER_42_47 VGND VGND VPWR VPWR sky130_fd_sc_hd__decap_3
X_5849_ _4927_/A _5815_/X _5844_/X _6769_/B _5848_/Y VGND VGND VPWR VPWR _5849_/X
+ sky130_fd_sc_hd__o221a_2
XTAP_TAPCELL_ROW_32_680 VGND VPWR sky130_fd_sc_hd__tapvpwrvgnd_1
XFILLER_5_328 VGND VGND VPWR VPWR sky130_fd_sc_hd__decap_3
X_7519_ _8218_/Q _4747_/B _7437_/B _4986_/X _7518_/X VGND VGND VPWR VPWR _7583_/C
+ sky130_fd_sc_hd__a221o_2
Xrebuffer444 _6733_/X VGND VGND VPWR VPWR _6735_/A sky130_fd_sc_hd__buf_4
XFILLER_107_223 VGND VGND VPWR VPWR sky130_fd_sc_hd__fill_1
XFILLER_107_256 VGND VGND VPWR VPWR sky130_fd_sc_hd__decap_3
XFILLER_1_556 VGND VGND VPWR VPWR sky130_fd_sc_hd__fill_1
XFILLER_49_505 VGND VGND VPWR VPWR sky130_fd_sc_hd__decap_3
XFILLER_67_44 VGND VGND VPWR VPWR sky130_fd_sc_hd__decap_3
XFILLER_67_66 VGND VGND VPWR VPWR sky130_fd_sc_hd__decap_3
XFILLER_76_302 VGND VGND VPWR VPWR sky130_fd_sc_hd__fill_1
XFILLER_76_335 VGND VGND VPWR VPWR sky130_fd_sc_hd__fill_1
XFILLER_76_368 VGND VGND VPWR VPWR sky130_fd_sc_hd__decap_3
XFILLER_88_195 VGND VGND VPWR VPWR sky130_fd_sc_hd__fill_1
XFILLER_29_262 VGND VGND VPWR VPWR sky130_fd_sc_hd__decap_3
XFILLER_45_700 VGND VGND VPWR VPWR sky130_fd_sc_hd__decap_3
XFILLER_57_582 VGND VGND VPWR VPWR sky130_fd_sc_hd__decap_3
XFILLER_72_530 VGND VGND VPWR VPWR sky130_fd_sc_hd__fill_2
XFILLER_91_349 VGND VGND VPWR VPWR sky130_fd_sc_hd__fill_2
XFILLER_32_405 VGND VGND VPWR VPWR sky130_fd_sc_hd__decap_3
XFILLER_44_243 VGND VGND VPWR VPWR sky130_fd_sc_hd__decap_3
XFILLER_44_265 VGND VGND VPWR VPWR sky130_fd_sc_hd__decap_3
XFILLER_72_563 VGND VGND VPWR VPWR sky130_fd_sc_hd__decap_3
XFILLER_32_427 VGND VGND VPWR VPWR sky130_fd_sc_hd__decap_3
XFILLER_32_449 VGND VGND VPWR VPWR sky130_fd_sc_hd__decap_3
Xclkbuf_leaf_24_clk clkbuf_2_2__f_clk/X VGND VGND VPWR VPWR _8396_/CLK sky130_fd_sc_hd__clkbuf_8
XFILLER_12_162 VGND VGND VPWR VPWR sky130_fd_sc_hd__decap_3
XFILLER_13_685 VGND VGND VPWR VPWR sky130_fd_sc_hd__decap_3
XFILLER_40_460 VGND VGND VPWR VPWR sky130_fd_sc_hd__decap_3
XFILLER_80_9 VGND VGND VPWR VPWR sky130_fd_sc_hd__fill_2
XFILLER_9_623 VGND VGND VPWR VPWR sky130_fd_sc_hd__decap_3
XFILLER_8_144 VGND VGND VPWR VPWR sky130_fd_sc_hd__decap_3
XTAP_TAPCELL_ROW_80_1299 VGND VPWR sky130_fd_sc_hd__tapvpwrvgnd_1
XFILLER_32_91 VGND VGND VPWR VPWR sky130_fd_sc_hd__decap_3
XFILLER_8_188 VGND VGND VPWR VPWR sky130_fd_sc_hd__decap_3
XTAP_TAPCELL_ROW_10_385 VGND VPWR sky130_fd_sc_hd__tapvpwrvgnd_1
XFILLER_113_204 VGND VGND VPWR VPWR sky130_fd_sc_hd__decap_3
XFILLER_4_361 VGND VGND VPWR VPWR sky130_fd_sc_hd__decap_3
XFILLER_59_6 VGND VGND VPWR VPWR sky130_fd_sc_hd__decap_3
XFILLER_99_405 VGND VGND VPWR VPWR sky130_fd_sc_hd__decap_3
XFILLER_113_215 VGND VGND VPWR VPWR sky130_fd_sc_hd__decap_3
XFILLER_99_449 VGND VGND VPWR VPWR sky130_fd_sc_hd__decap_3
X_4180_ _7898_/B _4180_/B VGND VGND VPWR VPWR _4181_/A sky130_fd_sc_hd__and2_2
XFILLER_67_302 VGND VGND VPWR VPWR sky130_fd_sc_hd__decap_3
XFILLER_79_184 VGND VGND VPWR VPWR sky130_fd_sc_hd__decap_3
XFILLER_55_508 VGND VGND VPWR VPWR sky130_fd_sc_hd__decap_3
XFILLER_67_346 VGND VGND VPWR VPWR sky130_fd_sc_hd__decap_3
XFILLER_48_560 VGND VGND VPWR VPWR sky130_fd_sc_hd__decap_3
XFILLER_67_379 VGND VGND VPWR VPWR sky130_fd_sc_hd__decap_3
XFILLER_95_688 VGND VGND VPWR VPWR sky130_fd_sc_hd__decap_3
XFILLER_63_530 VGND VGND VPWR VPWR sky130_fd_sc_hd__decap_3
X_7870_ _8305_/Q _7930_/B VGND VGND VPWR VPWR _7871_/A sky130_fd_sc_hd__and2_2
XFILLER_23_405 VGND VGND VPWR VPWR sky130_fd_sc_hd__decap_3
XFILLER_35_254 VGND VGND VPWR VPWR sky130_fd_sc_hd__decap_3
X_6821_ _7193_/A _5596_/X _6354_/B _6820_/X VGND VGND VPWR VPWR _6821_/X sky130_fd_sc_hd__a31o_2
XFILLER_35_287 VGND VGND VPWR VPWR sky130_fd_sc_hd__decap_3
XFILLER_50_213 VGND VGND VPWR VPWR sky130_fd_sc_hd__decap_3
XFILLER_90_360 VGND VGND VPWR VPWR sky130_fd_sc_hd__decap_3
XFILLER_90_371 VGND VGND VPWR VPWR sky130_fd_sc_hd__fill_2
XFILLER_90_382 VGND VGND VPWR VPWR sky130_fd_sc_hd__decap_3
XFILLER_23_449 VGND VGND VPWR VPWR sky130_fd_sc_hd__decap_3
Xclkbuf_leaf_15_clk clkload2/A VGND VGND VPWR VPWR _8352_/CLK sky130_fd_sc_hd__clkbuf_8
X_6752_ _8196_/Q _8260_/Q _6999_/A1 VGND VGND VPWR VPWR _6752_/X sky130_fd_sc_hd__o21a_2
XTAP_TAPCELL_ROW_18_496 VGND VPWR sky130_fd_sc_hd__tapvpwrvgnd_1
X_6683_ _7619_/A _6680_/X _6682_/X VGND VGND VPWR VPWR _6683_/X sky130_fd_sc_hd__a21o_2
X_5703_ _7631_/B _5702_/Y _8290_/Q VGND VGND VPWR VPWR _5703_/Y sky130_fd_sc_hd__a21oi_2
XFILLER_31_482 VGND VGND VPWR VPWR sky130_fd_sc_hd__decap_3
X_5634_ _5257_/X _5249_/X _5634_/S VGND VGND VPWR VPWR _5634_/X sky130_fd_sc_hd__mux2_2
XTAP_TAPCELL_ROW_98_1538 VGND VPWR sky130_fd_sc_hd__tapvpwrvgnd_1
XTAP_TAPCELL_ROW_98_1527 VGND VPWR sky130_fd_sc_hd__tapvpwrvgnd_1
X_8353_ _8353_/CLK _8353_/D VGND VGND VPWR VPWR _8353_/Q sky130_fd_sc_hd__dfxtp_2
X_7304_ _7285_/Y _7286_/X _7290_/Y _5563_/X _7303_/X VGND VGND VPWR VPWR _7304_/X
+ sky130_fd_sc_hd__a221o_2
X_5565_ _8165_/Q _5548_/B _5564_/X VGND VGND VPWR VPWR _5566_/B sky130_fd_sc_hd__o21a_2
XFILLER_2_309 VGND VGND VPWR VPWR sky130_fd_sc_hd__fill_2
X_8284_ _8285_/CLK _8284_/D VGND VGND VPWR VPWR _8284_/Q sky130_fd_sc_hd__dfxtp_2
X_5496_ _5493_/X _5495_/X _8164_/Q VGND VGND VPWR VPWR _5496_/X sky130_fd_sc_hd__mux2_2
X_4516_ _7898_/B _8062_/Q VGND VGND VPWR VPWR _4517_/A sky130_fd_sc_hd__and2_2
XFILLER_104_215 VGND VGND VPWR VPWR sky130_fd_sc_hd__decap_3
X_7235_ _8274_/Q _5337_/X _5338_/X VGND VGND VPWR VPWR _7235_/X sky130_fd_sc_hd__o21a_2
X_4447_ _4447_/A VGND VGND VPWR VPWR _8161_/D sky130_fd_sc_hd__buf_1
XFILLER_104_248 VGND VGND VPWR VPWR sky130_fd_sc_hd__decap_3
XFILLER_104_259 VGND VGND VPWR VPWR sky130_fd_sc_hd__decap_3
XFILLER_86_600 VGND VGND VPWR VPWR sky130_fd_sc_hd__decap_3
X_7166_ _7166_/A _7166_/B _7166_/C _7166_/D VGND VGND VPWR VPWR _7167_/D sky130_fd_sc_hd__and4_2
XFILLER_58_324 VGND VGND VPWR VPWR sky130_fd_sc_hd__decap_3
XFILLER_98_493 VGND VGND VPWR VPWR sky130_fd_sc_hd__decap_3
X_6117_ _6115_/Y _6116_/X _8178_/Q VGND VGND VPWR VPWR _6117_/X sky130_fd_sc_hd__mux2_2
X_4378_ _7930_/B _4378_/B VGND VGND VPWR VPWR _4379_/A sky130_fd_sc_hd__and2_2
XFILLER_100_421 VGND VGND VPWR VPWR sky130_fd_sc_hd__decap_3
XFILLER_100_443 VGND VGND VPWR VPWR sky130_fd_sc_hd__decap_3
XFILLER_58_357 VGND VGND VPWR VPWR sky130_fd_sc_hd__decap_3
XFILLER_86_666 VGND VGND VPWR VPWR sky130_fd_sc_hd__fill_1
X_7097_ _8206_/Q _8270_/Q _7102_/C VGND VGND VPWR VPWR _7097_/Y sky130_fd_sc_hd__o21ai_2
XFILLER_100_465 VGND VGND VPWR VPWR sky130_fd_sc_hd__decap_3
X_6048_ _8177_/Q _5600_/A _5718_/A _8241_/Q VGND VGND VPWR VPWR _6048_/X sky130_fd_sc_hd__a2bb2o_2
XFILLER_26_221 VGND VGND VPWR VPWR sky130_fd_sc_hd__fill_1
XFILLER_54_530 VGND VGND VPWR VPWR sky130_fd_sc_hd__fill_2
XFILLER_66_390 VGND VGND VPWR VPWR sky130_fd_sc_hd__decap_3
XTAP_TAPCELL_ROW_107_1645 VGND VPWR sky130_fd_sc_hd__tapvpwrvgnd_1
XTAP_TAPCELL_ROW_107_1656 VGND VPWR sky130_fd_sc_hd__tapvpwrvgnd_1
XFILLER_14_427 VGND VGND VPWR VPWR sky130_fd_sc_hd__fill_1
XFILLER_26_265 VGND VGND VPWR VPWR sky130_fd_sc_hd__decap_3
XFILLER_54_574 VGND VGND VPWR VPWR sky130_fd_sc_hd__decap_3
XFILLER_81_382 VGND VGND VPWR VPWR sky130_fd_sc_hd__decap_3
X_7999_ _8402_/CLK _7999_/D VGND VGND VPWR VPWR _7999_/Q sky130_fd_sc_hd__dfxtp_2
XFILLER_53_57 VGND VGND VPWR VPWR sky130_fd_sc_hd__decap_3
XFILLER_81_393 VGND VGND VPWR VPWR sky130_fd_sc_hd__decap_3
XFILLER_41_268 VGND VGND VPWR VPWR sky130_fd_sc_hd__decap_3
XFILLER_5_103 VGND VGND VPWR VPWR sky130_fd_sc_hd__decap_3
XFILLER_6_626 VGND VGND VPWR VPWR sky130_fd_sc_hd__fill_2
XFILLER_6_637 VGND VGND VPWR VPWR sky130_fd_sc_hd__decap_3
XFILLER_6_648 VGND VGND VPWR VPWR sky130_fd_sc_hd__fill_1
Xrebuffer274 _8160_/Q VGND VGND VPWR VPWR split/A sky130_fd_sc_hd__buf_8
XFILLER_108_587 VGND VGND VPWR VPWR sky130_fd_sc_hd__fill_1
XFILLER_5_169 VGND VGND VPWR VPWR sky130_fd_sc_hd__fill_1
XTAP_TAPCELL_ROW_118_1796 VGND VPWR sky130_fd_sc_hd__tapvpwrvgnd_1
Xrebuffer285 _8169_/Q VGND VGND VPWR VPWR _4936_/A sky130_fd_sc_hd__buf_6
XFILLER_78_32 VGND VGND VPWR VPWR sky130_fd_sc_hd__fill_1
XFILLER_78_54 VGND VGND VPWR VPWR sky130_fd_sc_hd__decap_3
XFILLER_103_270 VGND VGND VPWR VPWR sky130_fd_sc_hd__decap_3
XFILLER_110_218 VGND VGND VPWR VPWR sky130_fd_sc_hd__decap_3
XFILLER_49_324 VGND VGND VPWR VPWR sky130_fd_sc_hd__fill_1
XFILLER_89_482 VGND VGND VPWR VPWR sky130_fd_sc_hd__decap_3
XFILLER_103_292 VGND VGND VPWR VPWR sky130_fd_sc_hd__decap_3
XFILLER_49_346 VGND VGND VPWR VPWR sky130_fd_sc_hd__decap_3
XFILLER_77_644 VGND VGND VPWR VPWR sky130_fd_sc_hd__decap_3
XFILLER_37_508 VGND VGND VPWR VPWR sky130_fd_sc_hd__decap_3
XFILLER_49_379 VGND VGND VPWR VPWR sky130_fd_sc_hd__decap_3
XFILLER_92_614 VGND VGND VPWR VPWR sky130_fd_sc_hd__decap_3
XFILLER_57_390 VGND VGND VPWR VPWR sky130_fd_sc_hd__fill_2
XFILLER_64_327 VGND VGND VPWR VPWR sky130_fd_sc_hd__decap_3
XFILLER_76_187 VGND VGND VPWR VPWR sky130_fd_sc_hd__decap_3
XFILLER_91_113 VGND VGND VPWR VPWR sky130_fd_sc_hd__decap_3
XFILLER_45_541 VGND VGND VPWR VPWR sky130_fd_sc_hd__decap_3
XFILLER_94_97 VGND VGND VPWR VPWR sky130_fd_sc_hd__fill_1
XTAP_TAPCELL_ROW_35_709 VGND VPWR sky130_fd_sc_hd__tapvpwrvgnd_1
XFILLER_17_287 VGND VGND VPWR VPWR sky130_fd_sc_hd__decap_3
XFILLER_72_360 VGND VGND VPWR VPWR sky130_fd_sc_hd__decap_3
XTAP_TAPCELL_ROW_82_1328 VGND VPWR sky130_fd_sc_hd__tapvpwrvgnd_1
XFILLER_32_246 VGND VGND VPWR VPWR sky130_fd_sc_hd__decap_3
XFILLER_60_533 VGND VGND VPWR VPWR sky130_fd_sc_hd__decap_3
XFILLER_60_555 VGND VGND VPWR VPWR sky130_fd_sc_hd__decap_3
XFILLER_20_419 VGND VGND VPWR VPWR sky130_fd_sc_hd__fill_1
XTAP_TAPCELL_ROW_15_455 VGND VPWR sky130_fd_sc_hd__tapvpwrvgnd_1
XFILLER_13_471 VGND VGND VPWR VPWR sky130_fd_sc_hd__decap_3
XFILLER_13_493 VGND VGND VPWR VPWR sky130_fd_sc_hd__decap_3
XFILLER_43_90 VGND VGND VPWR VPWR sky130_fd_sc_hd__decap_3
XFILLER_9_431 VGND VGND VPWR VPWR sky130_fd_sc_hd__decap_3
XFILLER_9_486 VGND VGND VPWR VPWR sky130_fd_sc_hd__fill_1
X_5350_ _5350_/A VGND VGND VPWR VPWR _5350_/Y sky130_fd_sc_hd__inv_2
XFILLER_5_670 VGND VGND VPWR VPWR sky130_fd_sc_hd__fill_2
X_5281_ _5430_/A _6462_/A _6763_/A VGND VGND VPWR VPWR _5281_/X sky130_fd_sc_hd__mux2_2
X_4301_ _4301_/A VGND VGND VPWR VPWR _8088_/D sky130_fd_sc_hd__buf_1
XTAP_TAPCELL_ROW_93_1468 VGND VPWR sky130_fd_sc_hd__tapvpwrvgnd_1
XFILLER_87_408 VGND VGND VPWR VPWR sky130_fd_sc_hd__decap_3
XFILLER_99_257 VGND VGND VPWR VPWR sky130_fd_sc_hd__decap_3
X_7020_ _7019_/X _6949_/X _6889_/X _6816_/X _7812_/A _7670_/A VGND VGND VPWR VPWR
+ _7020_/X sky130_fd_sc_hd__mux4_2
X_4232_ _7898_/B _4232_/B VGND VGND VPWR VPWR _4233_/A sky130_fd_sc_hd__and2_2
XFILLER_101_218 VGND VGND VPWR VPWR sky130_fd_sc_hd__decap_3
Xclkbuf_leaf_4_clk clkload1/A VGND VGND VPWR VPWR _8229_/CLK sky130_fd_sc_hd__clkbuf_8
XFILLER_95_441 VGND VGND VPWR VPWR sky130_fd_sc_hd__fill_1
X_4163_ _4163_/A VGND VGND VPWR VPWR _8019_/D sky130_fd_sc_hd__buf_1
XFILLER_55_305 VGND VGND VPWR VPWR sky130_fd_sc_hd__fill_2
XFILLER_55_316 VGND VGND VPWR VPWR sky130_fd_sc_hd__fill_2
XFILLER_68_688 VGND VGND VPWR VPWR sky130_fd_sc_hd__decap_3
XFILLER_83_625 VGND VGND VPWR VPWR sky130_fd_sc_hd__decap_3
X_4094_ _7930_/B _8388_/Q VGND VGND VPWR VPWR _4095_/A sky130_fd_sc_hd__and2_2
XFILLER_55_349 VGND VGND VPWR VPWR sky130_fd_sc_hd__decap_3
XFILLER_83_658 VGND VGND VPWR VPWR sky130_fd_sc_hd__decap_3
X_7922_ _8331_/Q _7930_/B VGND VGND VPWR VPWR _7923_/A sky130_fd_sc_hd__and2_2
XFILLER_36_552 VGND VGND VPWR VPWR sky130_fd_sc_hd__fill_2
XFILLER_36_563 VGND VGND VPWR VPWR sky130_fd_sc_hd__decap_3
XFILLER_48_390 VGND VGND VPWR VPWR sky130_fd_sc_hd__fill_1
XFILLER_23_213 VGND VGND VPWR VPWR sky130_fd_sc_hd__decap_3
XFILLER_36_574 VGND VGND VPWR VPWR sky130_fd_sc_hd__decap_3
XFILLER_51_500 VGND VGND VPWR VPWR sky130_fd_sc_hd__decap_3
XFILLER_51_511 VGND VGND VPWR VPWR sky130_fd_sc_hd__decap_3
XFILLER_63_382 VGND VGND VPWR VPWR sky130_fd_sc_hd__decap_3
X_7853_ _7853_/A VGND VGND VPWR VPWR _8363_/D sky130_fd_sc_hd__buf_1
XFILLER_63_393 VGND VGND VPWR VPWR sky130_fd_sc_hd__decap_3
X_7784_ _5363_/X _6095_/A _7655_/A _7782_/Y _7783_/X VGND VGND VPWR VPWR _7785_/C
+ sky130_fd_sc_hd__a311o_2
X_6804_ _6804_/A _6804_/B _6804_/C VGND VGND VPWR VPWR _6804_/X sky130_fd_sc_hd__or3_2
X_4996_ _8287_/Q _4997_/B _7646_/A VGND VGND VPWR VPWR _4996_/Y sky130_fd_sc_hd__o21ai_2
X_6735_ _6735_/A _6735_/B VGND VGND VPWR VPWR _6736_/B sky130_fd_sc_hd__and2_2
XTAP_TAPCELL_ROW_102_1586 VGND VPWR sky130_fd_sc_hd__tapvpwrvgnd_1
XFILLER_109_307 VGND VGND VPWR VPWR sky130_fd_sc_hd__decap_3
XFILLER_31_290 VGND VGND VPWR VPWR sky130_fd_sc_hd__decap_3
X_6666_ _8193_/Q _8257_/Q VGND VGND VPWR VPWR _6725_/D sky130_fd_sc_hd__and2_2
X_6597_ _8191_/Q _8255_/Q _6545_/X _6596_/X VGND VGND VPWR VPWR _6597_/X sky130_fd_sc_hd__o211a_2
X_5617_ _5593_/C _5593_/B _5817_/A _6148_/A _8166_/Q _7809_/A1 VGND VGND VPWR VPWR
+ _5617_/X sky130_fd_sc_hd__mux4_2
XFILLER_117_340 VGND VGND VPWR VPWR sky130_fd_sc_hd__fill_1
X_8336_ _8402_/CLK _8336_/D VGND VGND VPWR VPWR _8336_/Q sky130_fd_sc_hd__dfxtp_2
X_5548_ _5548_/A _5548_/B VGND VGND VPWR VPWR _5548_/Y sky130_fd_sc_hd__xnor2_2
XFILLER_105_524 VGND VGND VPWR VPWR sky130_fd_sc_hd__fill_2
XFILLER_2_106 VGND VGND VPWR VPWR sky130_fd_sc_hd__decap_3
XFILLER_3_629 VGND VGND VPWR VPWR sky130_fd_sc_hd__decap_3
X_8267_ _8269_/CLK _8267_/D VGND VGND VPWR VPWR _8267_/Q sky130_fd_sc_hd__dfxtp_2
X_7218_ _7218_/A _7218_/B VGND VGND VPWR VPWR _7219_/B sky130_fd_sc_hd__nand2_2
X_5479_ _5475_/A _5478_/X _5464_/Y VGND VGND VPWR VPWR _5479_/X sky130_fd_sc_hd__a21bo_2
XFILLER_78_419 VGND VGND VPWR VPWR sky130_fd_sc_hd__fill_1
X_8198_ _8199_/CLK _8198_/D VGND VGND VPWR VPWR _8198_/Q sky130_fd_sc_hd__dfxtp_2
XFILLER_48_35 VGND VGND VPWR VPWR sky130_fd_sc_hd__decap_3
XFILLER_58_110 VGND VGND VPWR VPWR sky130_fd_sc_hd__decap_3
XFILLER_59_644 VGND VGND VPWR VPWR sky130_fd_sc_hd__decap_3
XFILLER_86_430 VGND VGND VPWR VPWR sky130_fd_sc_hd__decap_3
X_7149_ _7102_/C _7145_/Y _7148_/Y _8270_/Q VGND VGND VPWR VPWR _7149_/X sky130_fd_sc_hd__a22o_2
XFILLER_100_262 VGND VGND VPWR VPWR sky130_fd_sc_hd__decap_3
XFILLER_19_508 VGND VGND VPWR VPWR sky130_fd_sc_hd__decap_3
XFILLER_46_305 VGND VGND VPWR VPWR sky130_fd_sc_hd__decap_3
XFILLER_59_688 VGND VGND VPWR VPWR sky130_fd_sc_hd__decap_3
XFILLER_74_603 VGND VGND VPWR VPWR sky130_fd_sc_hd__decap_3
XFILLER_74_625 VGND VGND VPWR VPWR sky130_fd_sc_hd__decap_3
XFILLER_46_327 VGND VGND VPWR VPWR sky130_fd_sc_hd__decap_3
XFILLER_46_349 VGND VGND VPWR VPWR sky130_fd_sc_hd__decap_3
XFILLER_27_541 VGND VGND VPWR VPWR sky130_fd_sc_hd__decap_3
XFILLER_64_23 VGND VGND VPWR VPWR sky130_fd_sc_hd__decap_3
XFILLER_73_146 VGND VGND VPWR VPWR sky130_fd_sc_hd__decap_3
XFILLER_14_213 VGND VGND VPWR VPWR sky130_fd_sc_hd__decap_3
XFILLER_54_382 VGND VGND VPWR VPWR sky130_fd_sc_hd__decap_3
XFILLER_61_319 VGND VGND VPWR VPWR sky130_fd_sc_hd__decap_3
XFILLER_82_691 VGND VGND VPWR VPWR sky130_fd_sc_hd__fill_2
XFILLER_42_555 VGND VGND VPWR VPWR sky130_fd_sc_hd__decap_3
XFILLER_81_190 VGND VGND VPWR VPWR sky130_fd_sc_hd__fill_2
XFILLER_14_268 VGND VGND VPWR VPWR sky130_fd_sc_hd__decap_3
XFILLER_42_577 VGND VGND VPWR VPWR sky130_fd_sc_hd__decap_3
XFILLER_80_44 VGND VGND VPWR VPWR sky130_fd_sc_hd__decap_3
XTAP_TAPCELL_ROW_12_414 VGND VPWR sky130_fd_sc_hd__tapvpwrvgnd_1
XFILLER_10_430 VGND VGND VPWR VPWR sky130_fd_sc_hd__fill_2
XTAP_TAPCELL_ROW_40_778 VGND VPWR sky130_fd_sc_hd__tapvpwrvgnd_1
XFILLER_89_20 VGND VGND VPWR VPWR sky130_fd_sc_hd__decap_3
XFILLER_6_489 VGND VGND VPWR VPWR sky130_fd_sc_hd__decap_3
XTAP_TAPCELL_ROW_79_1290 VGND VPWR sky130_fd_sc_hd__tapvpwrvgnd_1
XFILLER_2_662 VGND VGND VPWR VPWR sky130_fd_sc_hd__fill_1
XFILLER_96_227 VGND VGND VPWR VPWR sky130_fd_sc_hd__decap_3
XFILLER_111_549 VGND VGND VPWR VPWR sky130_fd_sc_hd__decap_3
XFILLER_49_110 VGND VGND VPWR VPWR sky130_fd_sc_hd__fill_2
XFILLER_77_430 VGND VGND VPWR VPWR sky130_fd_sc_hd__decap_3
XFILLER_49_165 VGND VGND VPWR VPWR sky130_fd_sc_hd__decap_3
XFILLER_65_614 VGND VGND VPWR VPWR sky130_fd_sc_hd__fill_2
XFILLER_77_452 VGND VGND VPWR VPWR sky130_fd_sc_hd__decap_3
XFILLER_77_474 VGND VGND VPWR VPWR sky130_fd_sc_hd__decap_3
XFILLER_37_327 VGND VGND VPWR VPWR sky130_fd_sc_hd__decap_3
XFILLER_49_187 VGND VGND VPWR VPWR sky130_fd_sc_hd__decap_3
XFILLER_65_625 VGND VGND VPWR VPWR sky130_fd_sc_hd__decap_3
XFILLER_92_433 VGND VGND VPWR VPWR sky130_fd_sc_hd__decap_3
XFILLER_18_530 VGND VGND VPWR VPWR sky130_fd_sc_hd__fill_2
XFILLER_80_606 VGND VGND VPWR VPWR sky130_fd_sc_hd__decap_3
XTAP_TAPCELL_ROW_48_878 VGND VPWR sky130_fd_sc_hd__tapvpwrvgnd_1
XFILLER_18_585 VGND VGND VPWR VPWR sky130_fd_sc_hd__decap_3
XFILLER_33_500 VGND VGND VPWR VPWR sky130_fd_sc_hd__decap_3
XFILLER_33_511 VGND VGND VPWR VPWR sky130_fd_sc_hd__decap_3
XFILLER_45_371 VGND VGND VPWR VPWR sky130_fd_sc_hd__decap_3
XFILLER_80_639 VGND VGND VPWR VPWR sky130_fd_sc_hd__fill_1
XFILLER_92_499 VGND VGND VPWR VPWR sky130_fd_sc_hd__decap_3
XTAP_TAPCELL_ROW_48_889 VGND VPWR sky130_fd_sc_hd__tapvpwrvgnd_1
XFILLER_33_544 VGND VGND VPWR VPWR sky130_fd_sc_hd__decap_3
XFILLER_45_393 VGND VGND VPWR VPWR sky130_fd_sc_hd__decap_3
XFILLER_72_190 VGND VGND VPWR VPWR sky130_fd_sc_hd__decap_3
X_4850_ _8195_/Q VGND VGND VPWR VPWR _4852_/A sky130_fd_sc_hd__inv_2
XFILLER_20_227 VGND VGND VPWR VPWR sky130_fd_sc_hd__decap_3
XFILLER_60_385 VGND VGND VPWR VPWR sky130_fd_sc_hd__decap_3
X_6520_ _6521_/A1 _6486_/B _7694_/B VGND VGND VPWR VPWR _6520_/X sky130_fd_sc_hd__a21o_2
X_4781_ _4781_/A _4781_/B VGND VGND VPWR VPWR _7213_/A sky130_fd_sc_hd__nand2_2
XFILLER_9_250 VGND VGND VPWR VPWR sky130_fd_sc_hd__decap_3
Xclkload20 _8322_/CLK VGND VGND VPWR VPWR clkload20/Y sky130_fd_sc_hd__clkinvlp_4
X_6451_ _8188_/Q _8187_/Q _7796_/A VGND VGND VPWR VPWR _6451_/X sky130_fd_sc_hd__mux2_2
Xclkload31 _8353_/CLK VGND VGND VPWR VPWR clkload31/X sky130_fd_sc_hd__clkbuf_4
X_6382_ _6381_/X _6105_/X _6507_/S VGND VGND VPWR VPWR _6383_/B sky130_fd_sc_hd__mux2_2
X_5402_ _5402_/A VGND VGND VPWR VPWR _5402_/X sky130_fd_sc_hd__buf_1
X_8121_ _8389_/CLK _8121_/D VGND VGND VPWR VPWR _8121_/Q sky130_fd_sc_hd__dfxtp_2
X_5333_ _5333_/A VGND VGND VPWR VPWR _5396_/A sky130_fd_sc_hd__buf_1
XFILLER_114_365 VGND VGND VPWR VPWR sky130_fd_sc_hd__decap_3
XFILLER_87_205 VGND VGND VPWR VPWR sky130_fd_sc_hd__decap_3
X_8052_ _8224_/CLK _8052_/D VGND VGND VPWR VPWR _8052_/Q sky130_fd_sc_hd__dfxtp_2
X_5264_ _5943_/C _8172_/Q _7805_/A VGND VGND VPWR VPWR _5264_/X sky130_fd_sc_hd__mux2_2
XFILLER_102_549 VGND VGND VPWR VPWR sky130_fd_sc_hd__fill_2
XFILLER_68_430 VGND VGND VPWR VPWR sky130_fd_sc_hd__decap_3
XFILLER_87_249 VGND VGND VPWR VPWR sky130_fd_sc_hd__decap_3
X_7003_ _7619_/A _7000_/X _7002_/X VGND VGND VPWR VPWR _7003_/X sky130_fd_sc_hd__a21o_2
X_5195_ _8224_/Q _8292_/Q VGND VGND VPWR VPWR _5197_/B sky130_fd_sc_hd__or2_4
X_4215_ _4215_/A VGND VGND VPWR VPWR _8045_/D sky130_fd_sc_hd__buf_1
XFILLER_28_305 VGND VGND VPWR VPWR sky130_fd_sc_hd__decap_3
XFILLER_68_463 VGND VGND VPWR VPWR sky130_fd_sc_hd__decap_3
XFILLER_95_260 VGND VGND VPWR VPWR sky130_fd_sc_hd__decap_3
X_4146_ _7930_/B _7943_/Q VGND VGND VPWR VPWR _4147_/A sky130_fd_sc_hd__and2_2
XFILLER_110_571 VGND VGND VPWR VPWR sky130_fd_sc_hd__decap_3
XFILLER_18_38 VGND VGND VPWR VPWR sky130_fd_sc_hd__fill_1
XFILLER_55_113 VGND VGND VPWR VPWR sky130_fd_sc_hd__decap_3
XFILLER_56_636 VGND VGND VPWR VPWR sky130_fd_sc_hd__decap_3
XFILLER_83_411 VGND VGND VPWR VPWR sky130_fd_sc_hd__decap_3
X_4077_ _4077_/A VGND VGND VPWR VPWR _7976_/D sky130_fd_sc_hd__buf_1
XFILLER_36_371 VGND VGND VPWR VPWR sky130_fd_sc_hd__decap_3
XFILLER_43_319 VGND VGND VPWR VPWR sky130_fd_sc_hd__decap_3
XFILLER_83_488 VGND VGND VPWR VPWR sky130_fd_sc_hd__decap_3
XTAP_TAPCELL_ROW_104_1615 VGND VPWR sky130_fd_sc_hd__tapvpwrvgnd_1
X_7905_ _7905_/A VGND VGND VPWR VPWR _8389_/D sky130_fd_sc_hd__buf_1
XFILLER_24_533 VGND VGND VPWR VPWR sky130_fd_sc_hd__decap_3
XFILLER_34_26 VGND VGND VPWR VPWR sky130_fd_sc_hd__fill_2
X_7836_ _8286_/Q _7836_/B _7838_/C VGND VGND VPWR VPWR _7836_/X sky130_fd_sc_hd__or3_4
XFILLER_51_385 VGND VGND VPWR VPWR sky130_fd_sc_hd__decap_3
XFILLER_51_396 VGND VGND VPWR VPWR sky130_fd_sc_hd__decap_3
X_7767_ _7796_/A _7767_/B VGND VGND VPWR VPWR _7767_/Y sky130_fd_sc_hd__nand2_2
X_4979_ _4974_/Y _4978_/X _4789_/A VGND VGND VPWR VPWR _4979_/Y sky130_fd_sc_hd__a21oi_2
XTAP_TAPCELL_ROW_63_1080 VGND VPWR sky130_fd_sc_hd__tapvpwrvgnd_1
X_7698_ _5684_/S _5242_/X _7696_/Y _7697_/Y VGND VGND VPWR VPWR _7698_/X sky130_fd_sc_hd__a31o_2
Xclkload3 clkload3/A VGND VGND VPWR VPWR clkload3/Y sky130_fd_sc_hd__clkinvlp_4
X_6718_ _7474_/A _7067_/A VGND VGND VPWR VPWR _6718_/X sky130_fd_sc_hd__or2_2
XFILLER_50_25 VGND VGND VPWR VPWR sky130_fd_sc_hd__decap_3
XFILLER_50_47 VGND VGND VPWR VPWR sky130_fd_sc_hd__decap_3
X_6649_ _6645_/Y _6648_/X _7825_/A _6650_/B VGND VGND VPWR VPWR _6649_/X sky130_fd_sc_hd__a211o_2
XFILLER_109_159 VGND VGND VPWR VPWR sky130_fd_sc_hd__decap_3
XFILLER_50_69 VGND VGND VPWR VPWR sky130_fd_sc_hd__decap_3
XFILLER_3_415 VGND VGND VPWR VPWR sky130_fd_sc_hd__decap_3
XFILLER_105_332 VGND VGND VPWR VPWR sky130_fd_sc_hd__decap_3
XFILLER_105_343 VGND VGND VPWR VPWR sky130_fd_sc_hd__decap_3
XFILLER_117_181 VGND VGND VPWR VPWR sky130_fd_sc_hd__fill_1
XFILLER_59_12 VGND VGND VPWR VPWR sky130_fd_sc_hd__fill_2
XFILLER_59_34 VGND VGND VPWR VPWR sky130_fd_sc_hd__decap_3
XTAP_TAPCELL_ROW_115_1755 VGND VPWR sky130_fd_sc_hd__tapvpwrvgnd_1
X_8319_ _8386_/CLK _8319_/D VGND VGND VPWR VPWR _8319_/Q sky130_fd_sc_hd__dfxtp_2
XFILLER_105_365 VGND VGND VPWR VPWR sky130_fd_sc_hd__decap_3
XFILLER_78_227 VGND VGND VPWR VPWR sky130_fd_sc_hd__decap_3
XFILLER_47_603 VGND VGND VPWR VPWR sky130_fd_sc_hd__decap_3
XFILLER_59_441 VGND VGND VPWR VPWR sky130_fd_sc_hd__decap_3
XFILLER_59_452 VGND VGND VPWR VPWR sky130_fd_sc_hd__decap_3
XFILLER_46_113 VGND VGND VPWR VPWR sky130_fd_sc_hd__decap_3
XFILLER_74_433 VGND VGND VPWR VPWR sky130_fd_sc_hd__decap_3
XFILLER_75_55 VGND VGND VPWR VPWR sky130_fd_sc_hd__fill_1
XFILLER_19_349 VGND VGND VPWR VPWR sky130_fd_sc_hd__decap_3
XFILLER_74_466 VGND VGND VPWR VPWR sky130_fd_sc_hd__decap_3
XFILLER_15_511 VGND VGND VPWR VPWR sky130_fd_sc_hd__fill_2
XFILLER_46_168 VGND VGND VPWR VPWR sky130_fd_sc_hd__decap_3
XFILLER_61_116 VGND VGND VPWR VPWR sky130_fd_sc_hd__decap_3
XFILLER_74_477 VGND VGND VPWR VPWR sky130_fd_sc_hd__fill_1
XFILLER_74_499 VGND VGND VPWR VPWR sky130_fd_sc_hd__decap_3
XFILLER_75_99 VGND VGND VPWR VPWR sky130_fd_sc_hd__decap_3
XFILLER_27_382 VGND VGND VPWR VPWR sky130_fd_sc_hd__decap_3
XFILLER_27_393 VGND VGND VPWR VPWR sky130_fd_sc_hd__decap_3
XFILLER_91_32 VGND VGND VPWR VPWR sky130_fd_sc_hd__decap_3
XTAP_TAPCELL_ROW_45_848 VGND VPWR sky130_fd_sc_hd__tapvpwrvgnd_1
XFILLER_70_650 VGND VGND VPWR VPWR sky130_fd_sc_hd__decap_3
XFILLER_91_65 VGND VGND VPWR VPWR sky130_fd_sc_hd__decap_3
XFILLER_30_525 VGND VGND VPWR VPWR sky130_fd_sc_hd__decap_3
XFILLER_30_536 VGND VGND VPWR VPWR sky130_fd_sc_hd__decap_3
XFILLER_42_385 VGND VGND VPWR VPWR sky130_fd_sc_hd__decap_3
XTAP_TAPCELL_ROW_25_583 VGND VPWR sky130_fd_sc_hd__tapvpwrvgnd_1
XFILLER_7_721 VGND VGND VPWR VPWR sky130_fd_sc_hd__decap_3
XFILLER_7_732 VGND VGND VPWR VPWR sky130_fd_sc_hd__fill_1
XFILLER_109_660 VGND VGND VPWR VPWR sky130_fd_sc_hd__decap_3
XFILLER_6_253 VGND VGND VPWR VPWR sky130_fd_sc_hd__decap_3
XFILLER_40_91 VGND VGND VPWR VPWR sky130_fd_sc_hd__fill_1
XFILLER_69_205 VGND VGND VPWR VPWR sky130_fd_sc_hd__decap_3
XFILLER_97_514 VGND VGND VPWR VPWR sky130_fd_sc_hd__fill_1
XFILLER_97_525 VGND VGND VPWR VPWR sky130_fd_sc_hd__decap_3
XTAP_TAPCELL_ROW_90_1427 VGND VPWR sky130_fd_sc_hd__tapvpwrvgnd_1
XFILLER_111_324 VGND VGND VPWR VPWR sky130_fd_sc_hd__decap_3
XFILLER_97_558 VGND VGND VPWR VPWR sky130_fd_sc_hd__fill_2
X_4000_ _8353_/Q _7930_/B VGND VGND VPWR VPWR _4001_/A sky130_fd_sc_hd__and2_2
XFILLER_37_113 VGND VGND VPWR VPWR sky130_fd_sc_hd__decap_3
XFILLER_38_625 VGND VGND VPWR VPWR sky130_fd_sc_hd__decap_3
XFILLER_65_411 VGND VGND VPWR VPWR sky130_fd_sc_hd__decap_3
XFILLER_1_63 VGND VGND VPWR VPWR sky130_fd_sc_hd__fill_1
XFILLER_65_444 VGND VGND VPWR VPWR sky130_fd_sc_hd__decap_3
XFILLER_65_466 VGND VGND VPWR VPWR sky130_fd_sc_hd__decap_3
XFILLER_77_293 VGND VGND VPWR VPWR sky130_fd_sc_hd__fill_1
XFILLER_18_371 VGND VGND VPWR VPWR sky130_fd_sc_hd__decap_3
XFILLER_53_617 VGND VGND VPWR VPWR sky130_fd_sc_hd__decap_3
XFILLER_65_499 VGND VGND VPWR VPWR sky130_fd_sc_hd__decap_3
X_5951_ _5951_/A _7825_/B VGND VGND VPWR VPWR _5951_/Y sky130_fd_sc_hd__nor2_2
XFILLER_33_330 VGND VGND VPWR VPWR sky130_fd_sc_hd__decap_3
XFILLER_52_127 VGND VGND VPWR VPWR sky130_fd_sc_hd__decap_3
XFILLER_80_458 VGND VGND VPWR VPWR sky130_fd_sc_hd__decap_3
X_4902_ _8240_/Q _6097_/A VGND VGND VPWR VPWR _5037_/A sky130_fd_sc_hd__and2b_2
XFILLER_33_352 VGND VGND VPWR VPWR sky130_fd_sc_hd__decap_3
X_5882_ _5894_/A _5882_/B VGND VGND VPWR VPWR _5882_/Y sky130_fd_sc_hd__xnor2_2
XFILLER_21_536 VGND VGND VPWR VPWR sky130_fd_sc_hd__fill_2
XFILLER_33_385 VGND VGND VPWR VPWR sky130_fd_sc_hd__decap_3
XFILLER_33_396 VGND VGND VPWR VPWR sky130_fd_sc_hd__decap_3
X_7621_ _8291_/Q _7621_/B VGND VGND VPWR VPWR _7621_/Y sky130_fd_sc_hd__nand2_2
X_4833_ _8198_/Q _4834_/B VGND VGND VPWR VPWR _6956_/C sky130_fd_sc_hd__nor2_2
XFILLER_21_558 VGND VGND VPWR VPWR sky130_fd_sc_hd__fill_2
X_7552_ _7619_/A _6686_/B _7579_/C _7551_/Y VGND VGND VPWR VPWR _7552_/X sky130_fd_sc_hd__a31o_2
X_4764_ _8212_/Q _4764_/B VGND VGND VPWR VPWR _7366_/C sky130_fd_sc_hd__nor2_2
X_7483_ _7483_/A _7483_/B _7482_/X VGND VGND VPWR VPWR _7483_/X sky130_fd_sc_hd__or3b_4
Xrebuffer829 _7488_/X VGND VGND VPWR VPWR _7575_/A sky130_fd_sc_hd__buf_2
X_6503_ _7694_/B _6504_/A2 _6999_/A1 VGND VGND VPWR VPWR _6503_/X sky130_fd_sc_hd__o21a_2
X_6434_ _6434_/A _6434_/B VGND VGND VPWR VPWR _6434_/Y sky130_fd_sc_hd__nand2_2
X_4695_ _4695_/A VGND VGND VPWR VPWR _8285_/D sky130_fd_sc_hd__buf_1
XFILLER_115_630 VGND VGND VPWR VPWR sky130_fd_sc_hd__decap_3
X_6365_ _6184_/B _6365_/A2 _6364_/X VGND VGND VPWR VPWR _6365_/Y sky130_fd_sc_hd__o21ai_2
XFILLER_102_302 VGND VGND VPWR VPWR sky130_fd_sc_hd__decap_3
X_8104_ clkload5/A _8104_/D VGND VGND VPWR VPWR _8104_/Q sky130_fd_sc_hd__dfxtp_2
X_6296_ _6024_/A _8238_/Q _8239_/Q _6024_/B VGND VGND VPWR VPWR _6300_/A sky130_fd_sc_hd__a22oi_2
X_5316_ _5316_/A _5316_/B VGND VGND VPWR VPWR _5316_/X sky130_fd_sc_hd__xor2_2
XFILLER_102_335 VGND VGND VPWR VPWR sky130_fd_sc_hd__decap_3
X_8035_ clkload3/A _8035_/D VGND VGND VPWR VPWR _8035_/Q sky130_fd_sc_hd__dfxtp_2
X_5247_ _8179_/Q _8180_/Q _7805_/A VGND VGND VPWR VPWR _5247_/X sky130_fd_sc_hd__mux2_2
XFILLER_102_368 VGND VGND VPWR VPWR sky130_fd_sc_hd__decap_3
XFILLER_29_48 VGND VGND VPWR VPWR sky130_fd_sc_hd__decap_3
XFILLER_29_625 VGND VGND VPWR VPWR sky130_fd_sc_hd__decap_3
XFILLER_29_636 VGND VGND VPWR VPWR sky130_fd_sc_hd__decap_3
XFILLER_68_260 VGND VGND VPWR VPWR sky130_fd_sc_hd__decap_3
XFILLER_75_219 VGND VGND VPWR VPWR sky130_fd_sc_hd__decap_3
XFILLER_84_731 VGND VGND VPWR VPWR sky130_fd_sc_hd__fill_2
XTAP_TAPCELL_ROW_110_1685 VGND VPWR sky130_fd_sc_hd__tapvpwrvgnd_1
X_5178_ _8172_/Q _8173_/Q _7767_/B _6022_/B _7805_/A _7783_/A VGND VGND VPWR VPWR
+ _5178_/X sky130_fd_sc_hd__mux4_2
XFILLER_56_433 VGND VGND VPWR VPWR sky130_fd_sc_hd__decap_3
XFILLER_68_293 VGND VGND VPWR VPWR sky130_fd_sc_hd__fill_1
XFILLER_83_241 VGND VGND VPWR VPWR sky130_fd_sc_hd__decap_3
X_4129_ _4129_/A VGND VGND VPWR VPWR _8002_/D sky130_fd_sc_hd__buf_1
XFILLER_43_116 VGND VGND VPWR VPWR sky130_fd_sc_hd__decap_3
XFILLER_44_617 VGND VGND VPWR VPWR sky130_fd_sc_hd__decap_3
XFILLER_56_477 VGND VGND VPWR VPWR sky130_fd_sc_hd__decap_3
XFILLER_56_499 VGND VGND VPWR VPWR sky130_fd_sc_hd__decap_3
XFILLER_71_425 VGND VGND VPWR VPWR sky130_fd_sc_hd__decap_3
XFILLER_45_69 VGND VGND VPWR VPWR sky130_fd_sc_hd__fill_1
XFILLER_36_190 VGND VGND VPWR VPWR sky130_fd_sc_hd__decap_3
XFILLER_52_661 VGND VGND VPWR VPWR sky130_fd_sc_hd__fill_1
XTAP_TAPCELL_ROW_42_807 VGND VPWR sky130_fd_sc_hd__tapvpwrvgnd_1
XFILLER_101_53 VGND VGND VPWR VPWR sky130_fd_sc_hd__decap_3
XFILLER_12_536 VGND VGND VPWR VPWR sky130_fd_sc_hd__decap_3
XFILLER_24_374 VGND VGND VPWR VPWR sky130_fd_sc_hd__decap_3
XFILLER_61_24 VGND VGND VPWR VPWR sky130_fd_sc_hd__decap_3
X_7819_ _7812_/A _7815_/X _7818_/X VGND VGND VPWR VPWR _7819_/Y sky130_fd_sc_hd__a21oi_2
XFILLER_51_193 VGND VGND VPWR VPWR sky130_fd_sc_hd__decap_3
XFILLER_61_57 VGND VGND VPWR VPWR sky130_fd_sc_hd__decap_3
XFILLER_8_507 VGND VGND VPWR VPWR sky130_fd_sc_hd__decap_3
XTAP_TAPCELL_ROW_22_542 VGND VPWR sky130_fd_sc_hd__tapvpwrvgnd_1
XFILLER_4_724 VGND VGND VPWR VPWR sky130_fd_sc_hd__decap_3
XFILLER_3_256 VGND VGND VPWR VPWR sky130_fd_sc_hd__decap_3
XFILLER_3_278 VGND VGND VPWR VPWR sky130_fd_sc_hd__fill_2
XFILLER_79_514 VGND VGND VPWR VPWR sky130_fd_sc_hd__decap_3
XFILLER_105_184 VGND VGND VPWR VPWR sky130_fd_sc_hd__decap_3
XFILLER_79_569 VGND VGND VPWR VPWR sky130_fd_sc_hd__decap_3
Xsplit449 _6596_/A1 VGND VGND VPWR VPWR _7694_/B sky130_fd_sc_hd__buf_4
XFILLER_19_113 VGND VGND VPWR VPWR sky130_fd_sc_hd__decap_3
XFILLER_47_411 VGND VGND VPWR VPWR sky130_fd_sc_hd__decap_3
XFILLER_59_271 VGND VGND VPWR VPWR sky130_fd_sc_hd__decap_3
XFILLER_94_528 VGND VGND VPWR VPWR sky130_fd_sc_hd__decap_3
XFILLER_19_146 VGND VGND VPWR VPWR sky130_fd_sc_hd__decap_3
XFILLER_47_444 VGND VGND VPWR VPWR sky130_fd_sc_hd__decap_3
XFILLER_47_455 VGND VGND VPWR VPWR sky130_fd_sc_hd__decap_3
XFILLER_74_230 VGND VGND VPWR VPWR sky130_fd_sc_hd__decap_3
XFILLER_35_639 VGND VGND VPWR VPWR sky130_fd_sc_hd__decap_3
XFILLER_62_403 VGND VGND VPWR VPWR sky130_fd_sc_hd__decap_3
XFILLER_74_274 VGND VGND VPWR VPWR sky130_fd_sc_hd__decap_3
XFILLER_90_701 VGND VGND VPWR VPWR sky130_fd_sc_hd__decap_3
XFILLER_28_691 VGND VGND VPWR VPWR sky130_fd_sc_hd__decap_3
XFILLER_62_436 VGND VGND VPWR VPWR sky130_fd_sc_hd__decap_3
XFILLER_15_330 VGND VGND VPWR VPWR sky130_fd_sc_hd__decap_3
XFILLER_62_469 VGND VGND VPWR VPWR sky130_fd_sc_hd__decap_3
XFILLER_15_374 VGND VGND VPWR VPWR sky130_fd_sc_hd__decap_3
XFILLER_35_91 VGND VGND VPWR VPWR sky130_fd_sc_hd__decap_3
XFILLER_42_182 VGND VGND VPWR VPWR sky130_fd_sc_hd__decap_3
XFILLER_30_344 VGND VGND VPWR VPWR sky130_fd_sc_hd__decap_3
XFILLER_30_399 VGND VGND VPWR VPWR sky130_fd_sc_hd__decap_3
XFILLER_116_416 VGND VGND VPWR VPWR sky130_fd_sc_hd__decap_3
XFILLER_116_427 VGND VGND VPWR VPWR sky130_fd_sc_hd__fill_2
Xmax_cap226 _5407_/A VGND VGND VPWR VPWR _7560_/A sky130_fd_sc_hd__buf_6
Xmax_cap215 _5714_/X VGND VGND VPWR VPWR _6184_/B sky130_fd_sc_hd__buf_6
X_4480_ _7898_/B _8044_/Q VGND VGND VPWR VPWR _4481_/A sky130_fd_sc_hd__and2_2
XFILLER_116_449 VGND VGND VPWR VPWR sky130_fd_sc_hd__decap_3
Xmax_cap248 _5596_/S VGND VGND VPWR VPWR _6706_/S sky130_fd_sc_hd__buf_12
Xmax_cap237 _6076_/A VGND VGND VPWR VPWR _7121_/A sky130_fd_sc_hd__buf_6
X_6150_ _8178_/Q _6150_/B VGND VGND VPWR VPWR _6711_/B sky130_fd_sc_hd__or2_4
XFILLER_111_110 VGND VGND VPWR VPWR sky130_fd_sc_hd__fill_2
XFILLER_97_311 VGND VGND VPWR VPWR sky130_fd_sc_hd__fill_1
X_5101_ _8290_/Q _6686_/A VGND VGND VPWR VPWR _6775_/B sky130_fd_sc_hd__nand2_2
XFILLER_112_666 VGND VGND VPWR VPWR sky130_fd_sc_hd__decap_3
XFILLER_112_677 VGND VGND VPWR VPWR sky130_fd_sc_hd__decap_3
X_6081_ _6084_/A _6081_/B VGND VGND VPWR VPWR _6081_/X sky130_fd_sc_hd__and2_2
XFILLER_57_219 VGND VGND VPWR VPWR sky130_fd_sc_hd__decap_3
XFILLER_85_539 VGND VGND VPWR VPWR sky130_fd_sc_hd__decap_3
XFILLER_97_388 VGND VGND VPWR VPWR sky130_fd_sc_hd__decap_3
X_5032_ _6039_/C _5031_/Y _4931_/X VGND VGND VPWR VPWR _5032_/X sky130_fd_sc_hd__o21a_2
XFILLER_38_444 VGND VGND VPWR VPWR sky130_fd_sc_hd__decap_3
XFILLER_93_550 VGND VGND VPWR VPWR sky130_fd_sc_hd__decap_3
XFILLER_53_414 VGND VGND VPWR VPWR sky130_fd_sc_hd__decap_3
XFILLER_81_701 VGND VGND VPWR VPWR sky130_fd_sc_hd__decap_3
XFILLER_93_561 VGND VGND VPWR VPWR sky130_fd_sc_hd__decap_3
XFILLER_53_447 VGND VGND VPWR VPWR sky130_fd_sc_hd__fill_1
XFILLER_65_296 VGND VGND VPWR VPWR sky130_fd_sc_hd__decap_3
XFILLER_80_233 VGND VGND VPWR VPWR sky130_fd_sc_hd__decap_3
XTAP_TAPCELL_ROW_0_248 VGND VPWR sky130_fd_sc_hd__tapvpwrvgnd_1
XTAP_TAPCELL_ROW_0_259 VGND VPWR sky130_fd_sc_hd__tapvpwrvgnd_1
X_6983_ _8203_/Q _5600_/A _5718_/A _8267_/Q VGND VGND VPWR VPWR _6983_/X sky130_fd_sc_hd__a2bb2o_2
XFILLER_53_458 VGND VGND VPWR VPWR sky130_fd_sc_hd__decap_3
X_5934_ _7767_/B _8238_/Q _8288_/Q VGND VGND VPWR VPWR _5934_/X sky130_fd_sc_hd__mux2_2
XFILLER_80_277 VGND VGND VPWR VPWR sky130_fd_sc_hd__decap_3
X_5865_ _8229_/Q _5864_/X _5124_/A VGND VGND VPWR VPWR _5865_/Y sky130_fd_sc_hd__o21ai_2
XFILLER_21_355 VGND VGND VPWR VPWR sky130_fd_sc_hd__fill_1
XFILLER_61_491 VGND VGND VPWR VPWR sky130_fd_sc_hd__decap_3
X_7604_ _8222_/Q _7604_/A2 _7596_/Y _7603_/X VGND VGND VPWR VPWR _7604_/X sky130_fd_sc_hd__a211o_2
X_4816_ _8202_/Q VGND VGND VPWR VPWR _4817_/A sky130_fd_sc_hd__inv_2
XFILLER_119_221 VGND VGND VPWR VPWR sky130_fd_sc_hd__decap_3
X_5796_ _5794_/X _5795_/X _5868_/A VGND VGND VPWR VPWR _5796_/X sky130_fd_sc_hd__mux2_2
XFILLER_21_399 VGND VGND VPWR VPWR sky130_fd_sc_hd__decap_3
XFILLER_31_38 VGND VGND VPWR VPWR sky130_fd_sc_hd__fill_2
X_7535_ _6944_/A _7536_/B2 _7561_/B _5732_/X VGND VGND VPWR VPWR _7535_/X sky130_fd_sc_hd__a2bb2o_2
X_4747_ _8218_/Q _4747_/B VGND VGND VPWR VPWR _4750_/A sky130_fd_sc_hd__nor2_2
XFILLER_107_405 VGND VGND VPWR VPWR sky130_fd_sc_hd__decap_3
XFILLER_119_287 VGND VGND VPWR VPWR sky130_fd_sc_hd__fill_1
X_7466_ _8282_/Q _5618_/A _5402_/A _4749_/A VGND VGND VPWR VPWR _7466_/X sky130_fd_sc_hd__a22o_2
X_4678_ _7930_/B _8143_/Q VGND VGND VPWR VPWR _4679_/A sky130_fd_sc_hd__and2_2
XFILLER_107_449 VGND VGND VPWR VPWR sky130_fd_sc_hd__decap_3
X_7397_ _7371_/X _7376_/Y _7396_/X _7930_/B VGND VGND VPWR VPWR _8349_/D sky130_fd_sc_hd__o31a_4
X_6417_ _8187_/Q _8251_/Q _6999_/A1 VGND VGND VPWR VPWR _6417_/X sky130_fd_sc_hd__o21a_2
XFILLER_1_716 VGND VGND VPWR VPWR sky130_fd_sc_hd__decap_3
XTAP_TAPCELL_ROW_112_1714 VGND VPWR sky130_fd_sc_hd__tapvpwrvgnd_1
X_6348_ _6645_/B _6059_/X _6707_/S VGND VGND VPWR VPWR _6349_/B sky130_fd_sc_hd__mux2_2
XFILLER_103_611 VGND VGND VPWR VPWR sky130_fd_sc_hd__decap_3
XFILLER_115_471 VGND VGND VPWR VPWR sky130_fd_sc_hd__fill_2
XTAP_TAPCELL_ROW_8_359 VGND VPWR sky130_fd_sc_hd__tapvpwrvgnd_1
XFILLER_0_259 VGND VGND VPWR VPWR sky130_fd_sc_hd__decap_3
XFILLER_76_506 VGND VGND VPWR VPWR sky130_fd_sc_hd__decap_3
XFILLER_88_377 VGND VGND VPWR VPWR sky130_fd_sc_hd__fill_2
Xinput105 operand_b[41] VGND VGND VPWR VPWR _4386_/B sky130_fd_sc_hd__clkdlybuf4s25_1
Xinput116 operand_b[51] VGND VGND VPWR VPWR _4406_/B sky130_fd_sc_hd__clkdlybuf4s25_1
Xinput127 operand_b[61] VGND VGND VPWR VPWR _4426_/B sky130_fd_sc_hd__clkdlybuf4s25_1
X_6279_ _5635_/X _5645_/X _5637_/X _5646_/X _6620_/A _6355_/A VGND VGND VPWR VPWR
+ _6279_/X sky130_fd_sc_hd__mux4_2
XFILLER_102_165 VGND VGND VPWR VPWR sky130_fd_sc_hd__decap_3
XFILLER_29_411 VGND VGND VPWR VPWR sky130_fd_sc_hd__decap_3
XFILLER_76_528 VGND VGND VPWR VPWR sky130_fd_sc_hd__decap_3
XFILLER_76_539 VGND VGND VPWR VPWR sky130_fd_sc_hd__decap_3
XFILLER_88_388 VGND VGND VPWR VPWR sky130_fd_sc_hd__decap_3
X_8018_ _8353_/CLK _8018_/D VGND VGND VPWR VPWR _8018_/Q sky130_fd_sc_hd__dfxtp_2
XFILLER_29_444 VGND VGND VPWR VPWR sky130_fd_sc_hd__decap_3
XFILLER_29_455 VGND VGND VPWR VPWR sky130_fd_sc_hd__decap_3
XFILLER_56_230 VGND VGND VPWR VPWR sky130_fd_sc_hd__decap_3
XFILLER_56_46 VGND VGND VPWR VPWR sky130_fd_sc_hd__decap_3
XFILLER_17_617 VGND VGND VPWR VPWR sky130_fd_sc_hd__decap_3
XFILLER_56_79 VGND VGND VPWR VPWR sky130_fd_sc_hd__decap_3
XFILLER_71_200 VGND VGND VPWR VPWR sky130_fd_sc_hd__decap_3
XFILLER_72_701 VGND VGND VPWR VPWR sky130_fd_sc_hd__decap_3
XFILLER_84_572 VGND VGND VPWR VPWR sky130_fd_sc_hd__decap_3
XFILLER_16_127 VGND VGND VPWR VPWR sky130_fd_sc_hd__fill_1
XFILLER_16_138 VGND VGND VPWR VPWR sky130_fd_sc_hd__fill_2
XFILLER_44_436 VGND VGND VPWR VPWR sky130_fd_sc_hd__decap_3
XFILLER_56_285 VGND VGND VPWR VPWR sky130_fd_sc_hd__decap_3
XTAP_TAPCELL_ROW_27_612 VGND VPWR sky130_fd_sc_hd__tapvpwrvgnd_1
XFILLER_71_244 VGND VGND VPWR VPWR sky130_fd_sc_hd__decap_3
XTAP_TAPCELL_ROW_55_976 VGND VPWR sky130_fd_sc_hd__tapvpwrvgnd_1
XFILLER_24_171 VGND VGND VPWR VPWR sky130_fd_sc_hd__decap_3
XFILLER_25_683 VGND VGND VPWR VPWR sky130_fd_sc_hd__decap_3
XFILLER_71_277 VGND VGND VPWR VPWR sky130_fd_sc_hd__decap_3
XFILLER_71_299 VGND VGND VPWR VPWR sky130_fd_sc_hd__decap_3
XFILLER_12_322 VGND VGND VPWR VPWR sky130_fd_sc_hd__decap_3
XFILLER_12_344 VGND VGND VPWR VPWR sky130_fd_sc_hd__decap_3
XFILLER_40_653 VGND VGND VPWR VPWR sky130_fd_sc_hd__decap_3
XFILLER_12_388 VGND VGND VPWR VPWR sky130_fd_sc_hd__decap_3
XFILLER_8_326 VGND VGND VPWR VPWR sky130_fd_sc_hd__decap_3
XFILLER_8_348 VGND VGND VPWR VPWR sky130_fd_sc_hd__fill_2
XTAP_TAPCELL_ROW_74_1219 VGND VPWR sky130_fd_sc_hd__tapvpwrvgnd_1
XFILLER_97_20 VGND VGND VPWR VPWR sky130_fd_sc_hd__decap_3
XFILLER_106_493 VGND VGND VPWR VPWR sky130_fd_sc_hd__decap_3
XFILLER_79_311 VGND VGND VPWR VPWR sky130_fd_sc_hd__decap_3
XFILLER_79_333 VGND VGND VPWR VPWR sky130_fd_sc_hd__decap_3
XFILLER_97_53 VGND VGND VPWR VPWR sky130_fd_sc_hd__decap_3
XFILLER_97_64 VGND VGND VPWR VPWR sky130_fd_sc_hd__decap_3
XFILLER_79_366 VGND VGND VPWR VPWR sky130_fd_sc_hd__decap_3
XFILLER_67_539 VGND VGND VPWR VPWR sky130_fd_sc_hd__decap_3
XFILLER_79_388 VGND VGND VPWR VPWR sky130_fd_sc_hd__decap_3
XFILLER_79_399 VGND VGND VPWR VPWR sky130_fd_sc_hd__fill_1
Xsplit257 _5780_/S VGND VGND VPWR VPWR _7805_/A sky130_fd_sc_hd__buf_12
XFILLER_82_509 VGND VGND VPWR VPWR sky130_fd_sc_hd__fill_2
XFILLER_75_550 VGND VGND VPWR VPWR sky130_fd_sc_hd__fill_2
XFILLER_35_447 VGND VGND VPWR VPWR sky130_fd_sc_hd__fill_1
XFILLER_62_200 VGND VGND VPWR VPWR sky130_fd_sc_hd__decap_3
XFILLER_90_520 VGND VGND VPWR VPWR sky130_fd_sc_hd__decap_3
XFILLER_90_542 VGND VGND VPWR VPWR sky130_fd_sc_hd__decap_3
X_3980_ _8343_/Q _7930_/B VGND VGND VPWR VPWR _3981_/A sky130_fd_sc_hd__and2_2
XTAP_TAPCELL_ROW_85_1359 VGND VPWR sky130_fd_sc_hd__tapvpwrvgnd_1
XFILLER_16_672 VGND VGND VPWR VPWR sky130_fd_sc_hd__decap_3
XFILLER_50_439 VGND VGND VPWR VPWR sky130_fd_sc_hd__decap_3
XFILLER_62_277 VGND VGND VPWR VPWR sky130_fd_sc_hd__decap_3
XFILLER_31_642 VGND VGND VPWR VPWR sky130_fd_sc_hd__fill_1
Xclkbuf_0_clk clk VGND VGND VPWR VPWR clkbuf_0_clk/X sky130_fd_sc_hd__clkbuf_16
X_5650_ _5633_/X _5640_/Y _5649_/X _7193_/A VGND VGND VPWR VPWR _5650_/Y sky130_fd_sc_hd__a22oi_2
XFILLER_30_141 VGND VGND VPWR VPWR sky130_fd_sc_hd__decap_3
XFILLER_87_3 VGND VGND VPWR VPWR sky130_fd_sc_hd__fill_2
X_4601_ _4601_/A VGND VGND VPWR VPWR _8238_/D sky130_fd_sc_hd__buf_1
X_5581_ _6277_/A _5581_/B VGND VGND VPWR VPWR _5581_/X sky130_fd_sc_hd__or2_2
X_7320_ _8213_/Q _8212_/Q _8211_/Q _8210_/Q _7796_/A _7765_/A VGND VGND VPWR VPWR
+ _7320_/X sky130_fd_sc_hd__mux4_2
X_4532_ _7843_/A _8070_/Q VGND VGND VPWR VPWR _4533_/A sky130_fd_sc_hd__and2_2
XFILLER_116_224 VGND VGND VPWR VPWR sky130_fd_sc_hd__decap_3
XFILLER_7_95 VGND VGND VPWR VPWR sky130_fd_sc_hd__decap_3
X_7251_ _7255_/A _7251_/B VGND VGND VPWR VPWR _7251_/X sky130_fd_sc_hd__xor2_2
X_4463_ _4463_/A VGND VGND VPWR VPWR _8169_/D sky130_fd_sc_hd__buf_1
XFILLER_104_419 VGND VGND VPWR VPWR sky130_fd_sc_hd__fill_1
X_6202_ _5545_/X _5673_/B _6784_/B _6708_/A VGND VGND VPWR VPWR _6203_/B sky130_fd_sc_hd__a22o_2
XPHY_EDGE_ROW_15_Right_15 VGND VGND VPWR VPWR sky130_fd_sc_hd__decap_3
X_7182_ _8209_/Q _7182_/B VGND VGND VPWR VPWR _7182_/Y sky130_fd_sc_hd__nand2_2
X_4394_ _7930_/B _4394_/B VGND VGND VPWR VPWR _4395_/A sky130_fd_sc_hd__and2_2
XFILLER_112_452 VGND VGND VPWR VPWR sky130_fd_sc_hd__decap_3
XFILLER_97_130 VGND VGND VPWR VPWR sky130_fd_sc_hd__decap_3
X_6133_ _5389_/X _5450_/X _5393_/X _5453_/X _6130_/A _6648_/A VGND VGND VPWR VPWR
+ _6133_/X sky130_fd_sc_hd__mux4_2
XTAP_TAPCELL_ROW_5_318 VGND VPWR sky130_fd_sc_hd__tapvpwrvgnd_1
XFILLER_100_614 VGND VGND VPWR VPWR sky130_fd_sc_hd__decap_3
XFILLER_100_625 VGND VGND VPWR VPWR sky130_fd_sc_hd__decap_3
XFILLER_85_314 VGND VGND VPWR VPWR sky130_fd_sc_hd__decap_3
XFILLER_98_686 VGND VGND VPWR VPWR sky130_fd_sc_hd__decap_3
X_6064_ _6650_/B _6064_/B VGND VGND VPWR VPWR _6064_/X sky130_fd_sc_hd__or2_2
XTAP_TAPCELL_ROW_5_329 VGND VPWR sky130_fd_sc_hd__tapvpwrvgnd_1
XFILLER_100_669 VGND VGND VPWR VPWR sky130_fd_sc_hd__decap_3
XFILLER_38_230 VGND VGND VPWR VPWR sky130_fd_sc_hd__decap_3
XFILLER_97_196 VGND VGND VPWR VPWR sky130_fd_sc_hd__decap_3
X_5015_ _8166_/Q VGND VGND VPWR VPWR _5598_/D sky130_fd_sc_hd__inv_2
XFILLER_54_701 VGND VGND VPWR VPWR sky130_fd_sc_hd__decap_3
XFILLER_26_436 VGND VGND VPWR VPWR sky130_fd_sc_hd__decap_3
XFILLER_53_211 VGND VGND VPWR VPWR sky130_fd_sc_hd__decap_3
XFILLER_93_391 VGND VGND VPWR VPWR sky130_fd_sc_hd__fill_1
XFILLER_53_255 VGND VGND VPWR VPWR sky130_fd_sc_hd__decap_3
XFILLER_81_553 VGND VGND VPWR VPWR sky130_fd_sc_hd__decap_3
XFILLER_81_564 VGND VGND VPWR VPWR sky130_fd_sc_hd__decap_3
XPHY_EDGE_ROW_24_Right_24 VGND VGND VPWR VPWR sky130_fd_sc_hd__decap_3
X_6966_ _6967_/B _6967_/A VGND VGND VPWR VPWR _6966_/Y sky130_fd_sc_hd__nand2_4
XFILLER_41_439 VGND VGND VPWR VPWR sky130_fd_sc_hd__decap_3
XFILLER_53_277 VGND VGND VPWR VPWR sky130_fd_sc_hd__decap_3
X_5917_ _5916_/X _5747_/X _6706_/S VGND VGND VPWR VPWR _5917_/X sky130_fd_sc_hd__mux2_2
XTAP_TAPCELL_ROW_52_935 VGND VPWR sky130_fd_sc_hd__tapvpwrvgnd_1
XFILLER_34_480 VGND VGND VPWR VPWR sky130_fd_sc_hd__decap_3
XFILLER_42_26 VGND VGND VPWR VPWR sky130_fd_sc_hd__fill_2
X_6897_ _6769_/B _6888_/X _6893_/X _6894_/X _6896_/Y VGND VGND VPWR VPWR _6897_/Y
+ sky130_fd_sc_hd__o2111ai_2
XFILLER_21_163 VGND VGND VPWR VPWR sky130_fd_sc_hd__decap_3
X_5848_ _8289_/Q _5848_/B VGND VGND VPWR VPWR _5848_/Y sky130_fd_sc_hd__nand2_2
XFILLER_21_185 VGND VGND VPWR VPWR sky130_fd_sc_hd__decap_3
X_5779_ _6353_/A _5774_/X _5777_/Y _6247_/B VGND VGND VPWR VPWR _5779_/X sky130_fd_sc_hd__a211o_2
XTAP_TAPCELL_ROW_32_681 VGND VPWR sky130_fd_sc_hd__tapvpwrvgnd_1
XTAP_TAPCELL_ROW_32_670 VGND VPWR sky130_fd_sc_hd__tapvpwrvgnd_1
XFILLER_107_202 VGND VGND VPWR VPWR sky130_fd_sc_hd__decap_3
XFILLER_5_307 VGND VGND VPWR VPWR sky130_fd_sc_hd__decap_3
X_7518_ _8219_/Q _4736_/B _4744_/B VGND VGND VPWR VPWR _7518_/X sky130_fd_sc_hd__a21o_2
Xrebuffer456 _8225_/Q VGND VGND VPWR VPWR clone455/A sky130_fd_sc_hd__buf_2
Xrebuffer445 _6880_/X VGND VGND VPWR VPWR _6882_/B sky130_fd_sc_hd__buf_2
XFILLER_107_235 VGND VGND VPWR VPWR sky130_fd_sc_hd__decap_3
XFILLER_107_268 VGND VGND VPWR VPWR sky130_fd_sc_hd__decap_3
XFILLER_1_502 VGND VGND VPWR VPWR sky130_fd_sc_hd__fill_2
XPHY_EDGE_ROW_33_Right_33 VGND VGND VPWR VPWR sky130_fd_sc_hd__decap_3
X_7449_ _7448_/X _7320_/X _7555_/S VGND VGND VPWR VPWR _7449_/X sky130_fd_sc_hd__mux2_2
XFILLER_89_620 VGND VGND VPWR VPWR sky130_fd_sc_hd__decap_3
XFILLER_103_441 VGND VGND VPWR VPWR sky130_fd_sc_hd__decap_3
XFILLER_103_452 VGND VGND VPWR VPWR sky130_fd_sc_hd__decap_3
XFILLER_115_290 VGND VGND VPWR VPWR sky130_fd_sc_hd__decap_3
XFILLER_67_23 VGND VGND VPWR VPWR sky130_fd_sc_hd__decap_3
XFILLER_88_130 VGND VGND VPWR VPWR sky130_fd_sc_hd__decap_3
XFILLER_88_141 VGND VGND VPWR VPWR sky130_fd_sc_hd__decap_3
XFILLER_89_642 VGND VGND VPWR VPWR sky130_fd_sc_hd__decap_3
XFILLER_49_517 VGND VGND VPWR VPWR sky130_fd_sc_hd__decap_3
XFILLER_49_528 VGND VGND VPWR VPWR sky130_fd_sc_hd__fill_1
XFILLER_49_539 VGND VGND VPWR VPWR sky130_fd_sc_hd__decap_3
XFILLER_67_34 VGND VGND VPWR VPWR sky130_fd_sc_hd__decap_3
XFILLER_76_325 VGND VGND VPWR VPWR sky130_fd_sc_hd__fill_2
XFILLER_88_174 VGND VGND VPWR VPWR sky130_fd_sc_hd__decap_3
XFILLER_67_78 VGND VGND VPWR VPWR sky130_fd_sc_hd__decap_3
XFILLER_57_561 VGND VGND VPWR VPWR sky130_fd_sc_hd__decap_3
XFILLER_91_306 VGND VGND VPWR VPWR sky130_fd_sc_hd__decap_3
XFILLER_29_274 VGND VGND VPWR VPWR sky130_fd_sc_hd__decap_3
XFILLER_44_200 VGND VGND VPWR VPWR sky130_fd_sc_hd__decap_3
XFILLER_57_594 VGND VGND VPWR VPWR sky130_fd_sc_hd__fill_2
XFILLER_83_44 VGND VGND VPWR VPWR sky130_fd_sc_hd__decap_3
XPHY_EDGE_ROW_42_Right_42 VGND VGND VPWR VPWR sky130_fd_sc_hd__decap_3
XFILLER_17_458 VGND VGND VPWR VPWR sky130_fd_sc_hd__decap_3
XFILLER_60_704 VGND VGND VPWR VPWR sky130_fd_sc_hd__decap_3
XFILLER_72_542 VGND VGND VPWR VPWR sky130_fd_sc_hd__decap_3
XFILLER_83_66 VGND VGND VPWR VPWR sky130_fd_sc_hd__decap_3
XFILLER_32_417 VGND VGND VPWR VPWR sky130_fd_sc_hd__decap_3
XFILLER_44_277 VGND VGND VPWR VPWR sky130_fd_sc_hd__decap_3
XFILLER_44_299 VGND VGND VPWR VPWR sky130_fd_sc_hd__decap_3
XFILLER_13_620 VGND VGND VPWR VPWR sky130_fd_sc_hd__fill_1
XFILLER_13_642 VGND VGND VPWR VPWR sky130_fd_sc_hd__decap_3
XFILLER_16_82 VGND VGND VPWR VPWR sky130_fd_sc_hd__fill_2
XPHY_EDGE_ROW_17_Left_137 VGND VGND VPWR VPWR sky130_fd_sc_hd__decap_3
XFILLER_12_141 VGND VGND VPWR VPWR sky130_fd_sc_hd__decap_3
XFILLER_13_664 VGND VGND VPWR VPWR sky130_fd_sc_hd__decap_3
XFILLER_40_472 VGND VGND VPWR VPWR sky130_fd_sc_hd__decap_3
XFILLER_8_112 VGND VGND VPWR VPWR sky130_fd_sc_hd__decap_3
XFILLER_9_613 VGND VGND VPWR VPWR sky130_fd_sc_hd__decap_3
XFILLER_9_635 VGND VGND VPWR VPWR sky130_fd_sc_hd__fill_2
XFILLER_40_483 VGND VGND VPWR VPWR sky130_fd_sc_hd__decap_3
XPHY_EDGE_ROW_51_Right_51 VGND VGND VPWR VPWR sky130_fd_sc_hd__decap_3
XTAP_TAPCELL_ROW_10_386 VGND VPWR sky130_fd_sc_hd__tapvpwrvgnd_1
XFILLER_99_417 VGND VGND VPWR VPWR sky130_fd_sc_hd__decap_3
XFILLER_4_384 VGND VGND VPWR VPWR sky130_fd_sc_hd__decap_3
XPHY_EDGE_ROW_26_Left_146 VGND VGND VPWR VPWR sky130_fd_sc_hd__decap_3
XFILLER_67_325 VGND VGND VPWR VPWR sky130_fd_sc_hd__decap_3
XFILLER_79_163 VGND VGND VPWR VPWR sky130_fd_sc_hd__decap_3
XFILLER_95_612 VGND VGND VPWR VPWR sky130_fd_sc_hd__decap_3
XFILLER_95_634 VGND VGND VPWR VPWR sky130_fd_sc_hd__fill_2
XFILLER_67_358 VGND VGND VPWR VPWR sky130_fd_sc_hd__decap_3
XFILLER_94_144 VGND VGND VPWR VPWR sky130_fd_sc_hd__decap_3
XFILLER_36_701 VGND VGND VPWR VPWR sky130_fd_sc_hd__fill_1
XFILLER_48_572 VGND VGND VPWR VPWR sky130_fd_sc_hd__fill_2
XPHY_EDGE_ROW_60_Right_60 VGND VGND VPWR VPWR sky130_fd_sc_hd__decap_3
XFILLER_75_391 VGND VGND VPWR VPWR sky130_fd_sc_hd__fill_1
XFILLER_35_233 VGND VGND VPWR VPWR sky130_fd_sc_hd__decap_3
X_6820_ _7825_/A _6818_/X _6819_/X _5464_/A VGND VGND VPWR VPWR _6820_/X sky130_fd_sc_hd__o211a_2
XFILLER_23_439 VGND VGND VPWR VPWR sky130_fd_sc_hd__decap_3
XFILLER_35_266 VGND VGND VPWR VPWR sky130_fd_sc_hd__decap_3
XFILLER_63_586 VGND VGND VPWR VPWR sky130_fd_sc_hd__decap_3
XPHY_EDGE_ROW_35_Left_155 VGND VGND VPWR VPWR sky130_fd_sc_hd__decap_3
XFILLER_35_299 VGND VGND VPWR VPWR sky130_fd_sc_hd__decap_3
XFILLER_50_225 VGND VGND VPWR VPWR sky130_fd_sc_hd__decap_3
XFILLER_90_394 VGND VGND VPWR VPWR sky130_fd_sc_hd__fill_1
X_6751_ _6999_/A1 _6748_/X _6750_/X VGND VGND VPWR VPWR _6751_/X sky130_fd_sc_hd__a21o_2
XTAP_TAPCELL_ROW_18_497 VGND VPWR sky130_fd_sc_hd__tapvpwrvgnd_1
X_6682_ _5396_/A _8194_/Q _6681_/Y _5402_/X _4849_/A VGND VGND VPWR VPWR _6682_/X
+ sky130_fd_sc_hd__a32o_2
X_5702_ _5702_/A _8232_/Q VGND VGND VPWR VPWR _5702_/Y sky130_fd_sc_hd__nand2_2
XFILLER_31_472 VGND VGND VPWR VPWR sky130_fd_sc_hd__decap_3
XFILLER_31_494 VGND VGND VPWR VPWR sky130_fd_sc_hd__decap_3
X_5633_ _5832_/A _5633_/B VGND VGND VPWR VPWR _5633_/X sky130_fd_sc_hd__or2_2
XTAP_TAPCELL_ROW_98_1528 VGND VPWR sky130_fd_sc_hd__tapvpwrvgnd_1
XFILLER_12_29 VGND VGND VPWR VPWR sky130_fd_sc_hd__fill_2
X_8352_ _8352_/CLK _8352_/D VGND VGND VPWR VPWR _8352_/Q sky130_fd_sc_hd__dfxtp_2
X_5564_ _8165_/Q _5548_/B _5464_/A VGND VGND VPWR VPWR _5564_/X sky130_fd_sc_hd__a21o_2
XTAP_TAPCELL_ROW_98_1539 VGND VPWR sky130_fd_sc_hd__tapvpwrvgnd_1
XFILLER_117_522 VGND VGND VPWR VPWR sky130_fd_sc_hd__fill_2
X_7303_ _8290_/Q _7294_/X _7295_/X _7300_/Y _7302_/X VGND VGND VPWR VPWR _7303_/X
+ sky130_fd_sc_hd__a221o_2
X_4515_ _4515_/A VGND VGND VPWR VPWR _8195_/D sky130_fd_sc_hd__buf_1
XPHY_EDGE_ROW_103_Right_103 VGND VGND VPWR VPWR sky130_fd_sc_hd__decap_3
XPHY_EDGE_ROW_44_Left_164 VGND VGND VPWR VPWR sky130_fd_sc_hd__decap_3
X_8283_ _8287_/CLK _8283_/D VGND VGND VPWR VPWR _8283_/Q sky130_fd_sc_hd__dfxtp_2
X_5495_ _7560_/A _5490_/A _5494_/X _5293_/Y VGND VGND VPWR VPWR _5495_/X sky130_fd_sc_hd__a211o_2
XFILLER_104_227 VGND VGND VPWR VPWR sky130_fd_sc_hd__decap_3
X_7234_ _4783_/B _5400_/X _5601_/X _8210_/Q VGND VGND VPWR VPWR _7234_/X sky130_fd_sc_hd__o22a_2
X_4446_ _7898_/B _8027_/Q VGND VGND VPWR VPWR _4447_/A sky130_fd_sc_hd__and2_2
X_7165_ _7844_/C _7165_/B VGND VGND VPWR VPWR _7165_/Y sky130_fd_sc_hd__nor2_2
X_4377_ _4377_/A VGND VGND VPWR VPWR _8126_/D sky130_fd_sc_hd__buf_1
XFILLER_86_612 VGND VGND VPWR VPWR sky130_fd_sc_hd__fill_2
XFILLER_86_623 VGND VGND VPWR VPWR sky130_fd_sc_hd__decap_3
XFILLER_98_472 VGND VGND VPWR VPWR sky130_fd_sc_hd__decap_3
X_6116_ _6099_/Y _5407_/X _8179_/Q VGND VGND VPWR VPWR _6116_/X sky130_fd_sc_hd__mux2_2
XFILLER_112_293 VGND VGND VPWR VPWR sky130_fd_sc_hd__fill_2
XFILLER_37_15 VGND VGND VPWR VPWR sky130_fd_sc_hd__decap_3
XFILLER_58_336 VGND VGND VPWR VPWR sky130_fd_sc_hd__decap_3
XFILLER_85_122 VGND VGND VPWR VPWR sky130_fd_sc_hd__decap_3
XFILLER_86_645 VGND VGND VPWR VPWR sky130_fd_sc_hd__decap_3
X_7096_ _7166_/C VGND VGND VPWR VPWR _7102_/C sky130_fd_sc_hd__inv_2
XFILLER_37_48 VGND VGND VPWR VPWR sky130_fd_sc_hd__decap_3
X_6047_ _6027_/A _6027_/B _6497_/B _6944_/A _6097_/A _8177_/Q VGND VGND VPWR VPWR
+ _6074_/A sky130_fd_sc_hd__mux4_2
XFILLER_39_572 VGND VGND VPWR VPWR sky130_fd_sc_hd__decap_3
XFILLER_39_594 VGND VGND VPWR VPWR sky130_fd_sc_hd__decap_3
XFILLER_66_380 VGND VGND VPWR VPWR sky130_fd_sc_hd__fill_1
XFILLER_85_188 VGND VGND VPWR VPWR sky130_fd_sc_hd__decap_3
XFILLER_54_564 VGND VGND VPWR VPWR sky130_fd_sc_hd__decap_3
XPHY_EDGE_ROW_53_Left_173 VGND VGND VPWR VPWR sky130_fd_sc_hd__decap_3
XTAP_TAPCELL_ROW_107_1646 VGND VPWR sky130_fd_sc_hd__tapvpwrvgnd_1
XTAP_TAPCELL_ROW_37_740 VGND VPWR sky130_fd_sc_hd__tapvpwrvgnd_1
XFILLER_26_277 VGND VGND VPWR VPWR sky130_fd_sc_hd__decap_3
XFILLER_41_203 VGND VGND VPWR VPWR sky130_fd_sc_hd__decap_3
XFILLER_42_715 VGND VGND VPWR VPWR sky130_fd_sc_hd__fill_2
XFILLER_53_25 VGND VGND VPWR VPWR sky130_fd_sc_hd__fill_2
XFILLER_54_586 VGND VGND VPWR VPWR sky130_fd_sc_hd__fill_2
XFILLER_81_361 VGND VGND VPWR VPWR sky130_fd_sc_hd__decap_3
X_7998_ _8269_/CLK _7998_/D VGND VGND VPWR VPWR _7998_/Q sky130_fd_sc_hd__dfxtp_2
XFILLER_41_225 VGND VGND VPWR VPWR sky130_fd_sc_hd__decap_3
XFILLER_53_69 VGND VGND VPWR VPWR sky130_fd_sc_hd__decap_3
X_6949_ _8202_/Q _8201_/Q _7796_/A VGND VGND VPWR VPWR _6949_/X sky130_fd_sc_hd__mux2_2
XFILLER_22_461 VGND VGND VPWR VPWR sky130_fd_sc_hd__decap_3
XFILLER_10_645 VGND VGND VPWR VPWR sky130_fd_sc_hd__decap_3
XPHY_EDGE_ROW_62_Left_182 VGND VGND VPWR VPWR sky130_fd_sc_hd__decap_3
XTAP_TAPCELL_ROW_118_1797 VGND VPWR sky130_fd_sc_hd__tapvpwrvgnd_1
Xrebuffer286 _8169_/Q VGND VGND VPWR VPWR _5026_/A_N sky130_fd_sc_hd__buf_2
XFILLER_1_343 VGND VGND VPWR VPWR sky130_fd_sc_hd__fill_2
XFILLER_78_88 VGND VGND VPWR VPWR sky130_fd_sc_hd__decap_3
XFILLER_76_122 VGND VGND VPWR VPWR sky130_fd_sc_hd__decap_3
XFILLER_18_701 VGND VGND VPWR VPWR sky130_fd_sc_hd__decap_3
XFILLER_49_358 VGND VGND VPWR VPWR sky130_fd_sc_hd__decap_3
XFILLER_64_306 VGND VGND VPWR VPWR sky130_fd_sc_hd__fill_2
XFILLER_76_144 VGND VGND VPWR VPWR sky130_fd_sc_hd__decap_3
XFILLER_92_626 VGND VGND VPWR VPWR sky130_fd_sc_hd__fill_2
XFILLER_94_32 VGND VGND VPWR VPWR sky130_fd_sc_hd__decap_3
XFILLER_45_520 VGND VGND VPWR VPWR sky130_fd_sc_hd__decap_3
XFILLER_64_339 VGND VGND VPWR VPWR sky130_fd_sc_hd__decap_3
XFILLER_91_125 VGND VGND VPWR VPWR sky130_fd_sc_hd__decap_3
XFILLER_92_648 VGND VGND VPWR VPWR sky130_fd_sc_hd__fill_1
XFILLER_92_659 VGND VGND VPWR VPWR sky130_fd_sc_hd__decap_3
XPHY_EDGE_ROW_71_Left_191 VGND VGND VPWR VPWR sky130_fd_sc_hd__decap_3
XFILLER_27_70 VGND VGND VPWR VPWR sky130_fd_sc_hd__decap_3
XFILLER_45_553 VGND VGND VPWR VPWR sky130_fd_sc_hd__decap_3
XFILLER_45_564 VGND VGND VPWR VPWR sky130_fd_sc_hd__decap_3
XFILLER_91_147 VGND VGND VPWR VPWR sky130_fd_sc_hd__decap_3
XFILLER_32_203 VGND VGND VPWR VPWR sky130_fd_sc_hd__fill_1
XTAP_TAPCELL_ROW_82_1329 VGND VPWR sky130_fd_sc_hd__tapvpwrvgnd_1
XFILLER_72_394 VGND VGND VPWR VPWR sky130_fd_sc_hd__decap_3
XFILLER_13_461 VGND VGND VPWR VPWR sky130_fd_sc_hd__fill_2
XFILLER_60_589 VGND VGND VPWR VPWR sky130_fd_sc_hd__decap_3
XTAP_TAPCELL_ROW_15_456 VGND VPWR sky130_fd_sc_hd__tapvpwrvgnd_1
XFILLER_114_536 VGND VGND VPWR VPWR sky130_fd_sc_hd__decap_3
XFILLER_5_682 VGND VGND VPWR VPWR sky130_fd_sc_hd__fill_1
XFILLER_99_203 VGND VGND VPWR VPWR sky130_fd_sc_hd__decap_3
XFILLER_99_236 VGND VGND VPWR VPWR sky130_fd_sc_hd__decap_3
X_5280_ _5333_/A VGND VGND VPWR VPWR _6462_/A sky130_fd_sc_hd__buf_1
X_4300_ _7898_/B _4300_/B VGND VGND VPWR VPWR _4301_/A sky130_fd_sc_hd__and2_2
XFILLER_114_547 VGND VGND VPWR VPWR sky130_fd_sc_hd__decap_3
XFILLER_99_269 VGND VGND VPWR VPWR sky130_fd_sc_hd__decap_3
X_4231_ _4231_/A VGND VGND VPWR VPWR _8053_/D sky130_fd_sc_hd__buf_1
XTAP_TAPCELL_ROW_93_1469 VGND VPWR sky130_fd_sc_hd__tapvpwrvgnd_1
XFILLER_4_85 VGND VGND VPWR VPWR sky130_fd_sc_hd__decap_3
XFILLER_67_122 VGND VGND VPWR VPWR sky130_fd_sc_hd__decap_3
XFILLER_68_645 VGND VGND VPWR VPWR sky130_fd_sc_hd__fill_1
XFILLER_68_656 VGND VGND VPWR VPWR sky130_fd_sc_hd__decap_3
XFILLER_95_420 VGND VGND VPWR VPWR sky130_fd_sc_hd__decap_3
X_4162_ _7930_/B _7951_/Q VGND VGND VPWR VPWR _4163_/A sky130_fd_sc_hd__and2_2
XFILLER_67_155 VGND VGND VPWR VPWR sky130_fd_sc_hd__fill_2
XFILLER_67_166 VGND VGND VPWR VPWR sky130_fd_sc_hd__fill_2
XFILLER_83_604 VGND VGND VPWR VPWR sky130_fd_sc_hd__decap_3
X_4093_ _4093_/A VGND VGND VPWR VPWR _7984_/D sky130_fd_sc_hd__buf_1
XFILLER_83_637 VGND VGND VPWR VPWR sky130_fd_sc_hd__decap_3
XFILLER_95_497 VGND VGND VPWR VPWR sky130_fd_sc_hd__decap_3
X_7921_ _7921_/A VGND VGND VPWR VPWR _8397_/D sky130_fd_sc_hd__buf_1
XFILLER_36_531 VGND VGND VPWR VPWR sky130_fd_sc_hd__fill_1
XFILLER_70_309 VGND VGND VPWR VPWR sky130_fd_sc_hd__decap_3
XFILLER_82_147 VGND VGND VPWR VPWR sky130_fd_sc_hd__fill_1
XFILLER_63_361 VGND VGND VPWR VPWR sky130_fd_sc_hd__decap_3
X_7852_ _8296_/Q _7930_/B VGND VGND VPWR VPWR _7853_/A sky130_fd_sc_hd__and2_2
XFILLER_23_225 VGND VGND VPWR VPWR sky130_fd_sc_hd__decap_3
XFILLER_51_556 VGND VGND VPWR VPWR sky130_fd_sc_hd__decap_3
X_7783_ _7783_/A _7783_/B _7812_/C VGND VGND VPWR VPWR _7783_/X sky130_fd_sc_hd__and3_2
X_6803_ _6811_/B _6802_/C _6874_/A VGND VGND VPWR VPWR _6804_/C sky130_fd_sc_hd__a21oi_2
X_4995_ _4993_/X _4994_/X _7588_/A VGND VGND VPWR VPWR _4997_/B sky130_fd_sc_hd__a21o_2
XFILLER_23_269 VGND VGND VPWR VPWR sky130_fd_sc_hd__fill_2
XFILLER_51_567 VGND VGND VPWR VPWR sky130_fd_sc_hd__decap_3
X_6734_ _8194_/Q _6698_/X _6728_/X _6729_/X _6697_/X VGND VGND VPWR VPWR _6735_/B
+ sky130_fd_sc_hd__o41a_4
XTAP_TAPCELL_ROW_102_1587 VGND VPWR sky130_fd_sc_hd__tapvpwrvgnd_1
X_6665_ _8193_/Q _8257_/Q VGND VGND VPWR VPWR _6727_/C sky130_fd_sc_hd__or2_2
X_6596_ _6596_/A1 _6596_/A2 _8254_/Q _8190_/Q _6595_/X VGND VGND VPWR VPWR _6596_/X
+ sky130_fd_sc_hd__a221o_2
X_5616_ _5614_/X _5690_/C _6494_/A _5592_/B VGND VGND VPWR VPWR _5616_/X sky130_fd_sc_hd__a2bb2o_2
XFILLER_105_503 VGND VGND VPWR VPWR sky130_fd_sc_hd__fill_1
XFILLER_117_330 VGND VGND VPWR VPWR sky130_fd_sc_hd__decap_3
X_8335_ _8402_/CLK _8335_/D VGND VGND VPWR VPWR _8335_/Q sky130_fd_sc_hd__dfxtp_2
X_5547_ _5651_/A _5481_/B _5017_/B VGND VGND VPWR VPWR _5548_/B sky130_fd_sc_hd__a21o_2
XTAP_TAPCELL_ROW_57_1000 VGND VPWR sky130_fd_sc_hd__tapvpwrvgnd_1
XFILLER_117_396 VGND VGND VPWR VPWR sky130_fd_sc_hd__fill_1
XFILLER_2_118 VGND VGND VPWR VPWR sky130_fd_sc_hd__decap_3
X_8266_ _8269_/CLK _8266_/D VGND VGND VPWR VPWR _8266_/Q sky130_fd_sc_hd__dfxtp_2
X_5478_ _6648_/A _5579_/S _8223_/Q _5475_/B VGND VGND VPWR VPWR _5478_/X sky130_fd_sc_hd__a31o_2
X_7217_ _8208_/Q _8272_/Q _7190_/Y _7189_/X VGND VGND VPWR VPWR _7218_/B sky130_fd_sc_hd__o31a_2
X_4429_ _4429_/A VGND VGND VPWR VPWR _8152_/D sky130_fd_sc_hd__buf_1
X_8197_ _8199_/CLK _8197_/D VGND VGND VPWR VPWR _8197_/Q sky130_fd_sc_hd__dfxtp_2
XFILLER_113_580 VGND VGND VPWR VPWR sky130_fd_sc_hd__decap_3
XFILLER_58_122 VGND VGND VPWR VPWR sky130_fd_sc_hd__decap_3
XFILLER_59_656 VGND VGND VPWR VPWR sky130_fd_sc_hd__decap_3
XFILLER_86_442 VGND VGND VPWR VPWR sky130_fd_sc_hd__decap_3
X_7148_ _7159_/A _7146_/B _7166_/C VGND VGND VPWR VPWR _7148_/Y sky130_fd_sc_hd__o21ai_2
XFILLER_100_230 VGND VGND VPWR VPWR sky130_fd_sc_hd__decap_3
XFILLER_58_144 VGND VGND VPWR VPWR sky130_fd_sc_hd__decap_3
XFILLER_74_615 VGND VGND VPWR VPWR sky130_fd_sc_hd__fill_2
X_7079_ _8200_/Q _8264_/Q _7167_/B _7078_/Y VGND VGND VPWR VPWR _7079_/X sky130_fd_sc_hd__o211a_2
XFILLER_100_274 VGND VGND VPWR VPWR sky130_fd_sc_hd__decap_3
XFILLER_46_339 VGND VGND VPWR VPWR sky130_fd_sc_hd__fill_1
XFILLER_73_125 VGND VGND VPWR VPWR sky130_fd_sc_hd__decap_3
XFILLER_74_637 VGND VGND VPWR VPWR sky130_fd_sc_hd__decap_3
XFILLER_74_648 VGND VGND VPWR VPWR sky130_fd_sc_hd__decap_3
XFILLER_100_296 VGND VGND VPWR VPWR sky130_fd_sc_hd__decap_3
XFILLER_104_97 VGND VGND VPWR VPWR sky130_fd_sc_hd__decap_3
XFILLER_27_553 VGND VGND VPWR VPWR sky130_fd_sc_hd__decap_3
XFILLER_39_391 VGND VGND VPWR VPWR sky130_fd_sc_hd__fill_1
XFILLER_64_35 VGND VGND VPWR VPWR sky130_fd_sc_hd__decap_3
XFILLER_73_158 VGND VGND VPWR VPWR sky130_fd_sc_hd__decap_3
XTAP_TAPCELL_ROW_68_1140 VGND VPWR sky130_fd_sc_hd__tapvpwrvgnd_1
XFILLER_27_564 VGND VGND VPWR VPWR sky130_fd_sc_hd__decap_3
XFILLER_42_512 VGND VGND VPWR VPWR sky130_fd_sc_hd__decap_3
XFILLER_54_350 VGND VGND VPWR VPWR sky130_fd_sc_hd__decap_3
XFILLER_73_169 VGND VGND VPWR VPWR sky130_fd_sc_hd__decap_3
XFILLER_54_394 VGND VGND VPWR VPWR sky130_fd_sc_hd__decap_3
XTAP_TAPCELL_ROW_12_415 VGND VPWR sky130_fd_sc_hd__tapvpwrvgnd_1
XFILLER_10_453 VGND VGND VPWR VPWR sky130_fd_sc_hd__decap_3
XFILLER_80_67 VGND VGND VPWR VPWR sky130_fd_sc_hd__decap_3
XFILLER_80_78 VGND VGND VPWR VPWR sky130_fd_sc_hd__decap_3
XFILLER_10_486 VGND VGND VPWR VPWR sky130_fd_sc_hd__decap_3
XFILLER_13_72 VGND VGND VPWR VPWR sky130_fd_sc_hd__decap_3
XFILLER_6_413 VGND VGND VPWR VPWR sky130_fd_sc_hd__decap_3
XFILLER_6_424 VGND VGND VPWR VPWR sky130_fd_sc_hd__decap_3
XTAP_TAPCELL_ROW_40_779 VGND VPWR sky130_fd_sc_hd__tapvpwrvgnd_1
XFILLER_108_330 VGND VGND VPWR VPWR sky130_fd_sc_hd__decap_3
XFILLER_13_94 VGND VGND VPWR VPWR sky130_fd_sc_hd__decap_3
XFILLER_89_76 VGND VGND VPWR VPWR sky130_fd_sc_hd__fill_2
XTAP_TAPCELL_ROW_79_1291 VGND VPWR sky130_fd_sc_hd__tapvpwrvgnd_1
XTAP_TAPCELL_ROW_79_1280 VGND VPWR sky130_fd_sc_hd__tapvpwrvgnd_1
XFILLER_2_641 VGND VGND VPWR VPWR sky130_fd_sc_hd__decap_3
XFILLER_69_409 VGND VGND VPWR VPWR sky130_fd_sc_hd__decap_3
XFILLER_89_87 VGND VGND VPWR VPWR sky130_fd_sc_hd__decap_3
XFILLER_97_718 VGND VGND VPWR VPWR sky130_fd_sc_hd__fill_2
XFILLER_111_528 VGND VGND VPWR VPWR sky130_fd_sc_hd__fill_2
XFILLER_36_9 VGND VGND VPWR VPWR sky130_fd_sc_hd__decap_3
XFILLER_96_206 VGND VGND VPWR VPWR sky130_fd_sc_hd__decap_3
XFILLER_97_729 VGND VGND VPWR VPWR sky130_fd_sc_hd__decap_3
XFILLER_2_696 VGND VGND VPWR VPWR sky130_fd_sc_hd__decap_3
XFILLER_49_122 VGND VGND VPWR VPWR sky130_fd_sc_hd__decap_3
XFILLER_96_239 VGND VGND VPWR VPWR sky130_fd_sc_hd__decap_3
XFILLER_49_199 VGND VGND VPWR VPWR sky130_fd_sc_hd__decap_3
XFILLER_64_125 VGND VGND VPWR VPWR sky130_fd_sc_hd__decap_3
XFILLER_77_486 VGND VGND VPWR VPWR sky130_fd_sc_hd__decap_3
XFILLER_92_401 VGND VGND VPWR VPWR sky130_fd_sc_hd__decap_3
XFILLER_18_542 VGND VGND VPWR VPWR sky130_fd_sc_hd__decap_3
XFILLER_18_553 VGND VGND VPWR VPWR sky130_fd_sc_hd__decap_3
XFILLER_38_91 VGND VGND VPWR VPWR sky130_fd_sc_hd__decap_3
XTAP_TAPCELL_ROW_48_879 VGND VPWR sky130_fd_sc_hd__tapvpwrvgnd_1
XFILLER_18_575 VGND VGND VPWR VPWR sky130_fd_sc_hd__fill_2
XFILLER_45_361 VGND VGND VPWR VPWR sky130_fd_sc_hd__fill_2
XFILLER_52_309 VGND VGND VPWR VPWR sky130_fd_sc_hd__decap_3
XFILLER_73_670 VGND VGND VPWR VPWR sky130_fd_sc_hd__fill_2
XFILLER_33_523 VGND VGND VPWR VPWR sky130_fd_sc_hd__decap_3
XFILLER_45_383 VGND VGND VPWR VPWR sky130_fd_sc_hd__decap_3
XFILLER_60_320 VGND VGND VPWR VPWR sky130_fd_sc_hd__decap_3
XFILLER_60_331 VGND VGND VPWR VPWR sky130_fd_sc_hd__decap_3
XFILLER_21_729 VGND VGND VPWR VPWR sky130_fd_sc_hd__decap_3
XFILLER_60_353 VGND VGND VPWR VPWR sky130_fd_sc_hd__decap_3
X_4780_ _4780_/A VGND VGND VPWR VPWR _4781_/B sky130_fd_sc_hd__inv_2
XFILLER_20_206 VGND VGND VPWR VPWR sky130_fd_sc_hd__decap_3
XFILLER_20_239 VGND VGND VPWR VPWR sky130_fd_sc_hd__decap_3
XFILLER_60_397 VGND VGND VPWR VPWR sky130_fd_sc_hd__decap_3
XFILLER_119_639 VGND VGND VPWR VPWR sky130_fd_sc_hd__decap_3
XFILLER_9_284 VGND VGND VPWR VPWR sky130_fd_sc_hd__decap_3
Xclkload10 _8224_/CLK VGND VGND VPWR VPWR clkload10/X sky130_fd_sc_hd__clkbuf_4
X_6450_ _6592_/B _6450_/B VGND VGND VPWR VPWR _6450_/X sky130_fd_sc_hd__xor2_2
Xclkload21 _8365_/CLK VGND VGND VPWR VPWR clkload21/X sky130_fd_sc_hd__clkbuf_8
Xclkload32 _8390_/CLK VGND VGND VPWR VPWR clkload32/X sky130_fd_sc_hd__clkbuf_8
X_6381_ _6380_/X _6322_/X _6239_/X _6165_/X _7812_/A _7670_/A VGND VGND VPWR VPWR
+ _6381_/X sky130_fd_sc_hd__mux4_2
X_5401_ _6648_/A _5399_/X wire225/X VGND VGND VPWR VPWR _5401_/Y sky130_fd_sc_hd__o21ai_2
X_8120_ _8322_/CLK _8120_/D VGND VGND VPWR VPWR _8120_/Q sky130_fd_sc_hd__dfxtp_2
X_5332_ _5332_/A VGND VGND VPWR VPWR _5332_/X sky130_fd_sc_hd__clkbuf_1
XFILLER_114_377 VGND VGND VPWR VPWR sky130_fd_sc_hd__fill_1
XFILLER_87_217 VGND VGND VPWR VPWR sky130_fd_sc_hd__decap_3
X_8051_ clkload8/A _8051_/D VGND VGND VPWR VPWR _8051_/Q sky130_fd_sc_hd__dfxtp_2
X_5263_ _5828_/A2 _5943_/B _7805_/A VGND VGND VPWR VPWR _5263_/X sky130_fd_sc_hd__mux2_2
XFILLER_87_228 VGND VGND VPWR VPWR sky130_fd_sc_hd__decap_3
X_7002_ _5333_/A _8204_/Q _7001_/Y _5332_/A _6992_/A VGND VGND VPWR VPWR _7002_/X
+ sky130_fd_sc_hd__a32o_2
X_5194_ _5194_/A _5194_/B VGND VGND VPWR VPWR _5289_/A sky130_fd_sc_hd__nor2_2
X_4214_ _7898_/B _4214_/B VGND VGND VPWR VPWR _4215_/A sky130_fd_sc_hd__and2_2
X_4145_ _4145_/A VGND VGND VPWR VPWR _8010_/D sky130_fd_sc_hd__buf_1
XFILLER_28_328 VGND VGND VPWR VPWR sky130_fd_sc_hd__decap_3
XFILLER_55_103 VGND VGND VPWR VPWR sky130_fd_sc_hd__decap_3
XFILLER_55_125 VGND VGND VPWR VPWR sky130_fd_sc_hd__decap_3
XFILLER_56_648 VGND VGND VPWR VPWR sky130_fd_sc_hd__decap_3
XFILLER_68_486 VGND VGND VPWR VPWR sky130_fd_sc_hd__decap_3
XFILLER_95_272 VGND VGND VPWR VPWR sky130_fd_sc_hd__decap_3
XFILLER_71_607 VGND VGND VPWR VPWR sky130_fd_sc_hd__fill_2
XFILLER_83_467 VGND VGND VPWR VPWR sky130_fd_sc_hd__decap_3
X_4076_ _7898_/B _8379_/Q VGND VGND VPWR VPWR _4077_/A sky130_fd_sc_hd__and2_2
XFILLER_24_501 VGND VGND VPWR VPWR sky130_fd_sc_hd__fill_2
XFILLER_24_512 VGND VGND VPWR VPWR sky130_fd_sc_hd__decap_3
XFILLER_55_169 VGND VGND VPWR VPWR sky130_fd_sc_hd__decap_3
XFILLER_64_681 VGND VGND VPWR VPWR sky130_fd_sc_hd__decap_3
XTAP_TAPCELL_ROW_104_1605 VGND VPWR sky130_fd_sc_hd__tapvpwrvgnd_1
XTAP_TAPCELL_ROW_104_1616 VGND VPWR sky130_fd_sc_hd__tapvpwrvgnd_1
X_7904_ _8322_/Q _7930_/B VGND VGND VPWR VPWR _7905_/A sky130_fd_sc_hd__and2_2
XFILLER_36_394 VGND VGND VPWR VPWR sky130_fd_sc_hd__decap_3
XFILLER_51_331 VGND VGND VPWR VPWR sky130_fd_sc_hd__decap_3
X_7835_ _7834_/X _7831_/Y _7844_/A VGND VGND VPWR VPWR _8358_/D sky130_fd_sc_hd__a21oi_2
XFILLER_24_556 VGND VGND VPWR VPWR sky130_fd_sc_hd__decap_3
XFILLER_24_578 VGND VGND VPWR VPWR sky130_fd_sc_hd__decap_3
XFILLER_11_228 VGND VGND VPWR VPWR sky130_fd_sc_hd__decap_3
X_7766_ _7653_/X _8204_/Q _7655_/X _7764_/Y _7765_/X VGND VGND VPWR VPWR _7766_/X
+ sky130_fd_sc_hd__a311o_2
X_4978_ _4783_/B _7225_/A _4977_/Y VGND VGND VPWR VPWR _4978_/X sky130_fd_sc_hd__a21o_2
XFILLER_109_105 VGND VGND VPWR VPWR sky130_fd_sc_hd__decap_3
X_7697_ _7805_/A _8186_/Q _7656_/B _5596_/S VGND VGND VPWR VPWR _7697_/Y sky130_fd_sc_hd__a211oi_2
Xclkload4 clkload4/A VGND VGND VPWR VPWR clkload4/Y sky130_fd_sc_hd__clkinv_2
X_6717_ _6717_/A _6771_/C VGND VGND VPWR VPWR _6717_/X sky130_fd_sc_hd__or2_2
XTAP_TAPCELL_ROW_63_1081 VGND VPWR sky130_fd_sc_hd__tapvpwrvgnd_1
X_6648_ _6648_/A _6647_/X VGND VGND VPWR VPWR _6648_/X sky130_fd_sc_hd__or2b_2
XFILLER_105_311 VGND VGND VPWR VPWR sky130_fd_sc_hd__decap_3
XFILLER_118_694 VGND VGND VPWR VPWR sky130_fd_sc_hd__decap_3
XFILLER_3_427 VGND VGND VPWR VPWR sky130_fd_sc_hd__decap_3
X_8318_ _8365_/CLK _8318_/D VGND VGND VPWR VPWR _8318_/Q sky130_fd_sc_hd__dfxtp_2
X_6579_ _8190_/Q _6578_/C _8191_/Q VGND VGND VPWR VPWR _6579_/Y sky130_fd_sc_hd__o21ai_2
XFILLER_1_6 VGND VGND VPWR VPWR sky130_fd_sc_hd__fill_2
XFILLER_3_449 VGND VGND VPWR VPWR sky130_fd_sc_hd__decap_3
XTAP_TAPCELL_ROW_115_1756 VGND VPWR sky130_fd_sc_hd__tapvpwrvgnd_1
XFILLER_59_46 VGND VGND VPWR VPWR sky130_fd_sc_hd__decap_3
XFILLER_59_57 VGND VGND VPWR VPWR sky130_fd_sc_hd__fill_1
XFILLER_78_206 VGND VGND VPWR VPWR sky130_fd_sc_hd__decap_3
XFILLER_79_729 VGND VGND VPWR VPWR sky130_fd_sc_hd__decap_3
X_8249_ _8382_/CLK _8249_/D VGND VGND VPWR VPWR _8249_/Q sky130_fd_sc_hd__dfxtp_2
XFILLER_115_30 VGND VGND VPWR VPWR sky130_fd_sc_hd__decap_3
XFILLER_59_420 VGND VGND VPWR VPWR sky130_fd_sc_hd__decap_3
XFILLER_78_239 VGND VGND VPWR VPWR sky130_fd_sc_hd__decap_3
XFILLER_115_63 VGND VGND VPWR VPWR sky130_fd_sc_hd__decap_3
XFILLER_93_209 VGND VGND VPWR VPWR sky130_fd_sc_hd__decap_3
XFILLER_101_583 VGND VGND VPWR VPWR sky130_fd_sc_hd__decap_3
XFILLER_47_615 VGND VGND VPWR VPWR sky130_fd_sc_hd__fill_1
XFILLER_47_626 VGND VGND VPWR VPWR sky130_fd_sc_hd__decap_3
XFILLER_47_648 VGND VGND VPWR VPWR sky130_fd_sc_hd__decap_3
XFILLER_74_401 VGND VGND VPWR VPWR sky130_fd_sc_hd__decap_3
XFILLER_46_147 VGND VGND VPWR VPWR sky130_fd_sc_hd__decap_3
XFILLER_62_607 VGND VGND VPWR VPWR sky130_fd_sc_hd__fill_1
XFILLER_74_445 VGND VGND VPWR VPWR sky130_fd_sc_hd__decap_3
XFILLER_75_78 VGND VGND VPWR VPWR sky130_fd_sc_hd__decap_3
XFILLER_86_294 VGND VGND VPWR VPWR sky130_fd_sc_hd__decap_3
XFILLER_27_361 VGND VGND VPWR VPWR sky130_fd_sc_hd__decap_3
XFILLER_34_309 VGND VGND VPWR VPWR sky130_fd_sc_hd__decap_3
XFILLER_42_320 VGND VGND VPWR VPWR sky130_fd_sc_hd__fill_2
XFILLER_54_180 VGND VGND VPWR VPWR sky130_fd_sc_hd__decap_3
XFILLER_55_692 VGND VGND VPWR VPWR sky130_fd_sc_hd__decap_3
XFILLER_91_11 VGND VGND VPWR VPWR sky130_fd_sc_hd__fill_2
XFILLER_91_22 VGND VGND VPWR VPWR sky130_fd_sc_hd__decap_3
XTAP_TAPCELL_ROW_45_849 VGND VPWR sky130_fd_sc_hd__tapvpwrvgnd_1
XTAP_TAPCELL_ROW_45_838 VGND VPWR sky130_fd_sc_hd__tapvpwrvgnd_1
XFILLER_15_567 VGND VGND VPWR VPWR sky130_fd_sc_hd__decap_3
XFILLER_30_504 VGND VGND VPWR VPWR sky130_fd_sc_hd__decap_3
XFILLER_70_662 VGND VGND VPWR VPWR sky130_fd_sc_hd__decap_3
XFILLER_91_55 VGND VGND VPWR VPWR sky130_fd_sc_hd__fill_1
XFILLER_42_397 VGND VGND VPWR VPWR sky130_fd_sc_hd__decap_3
XTAP_TAPCELL_ROW_25_584 VGND VPWR sky130_fd_sc_hd__tapvpwrvgnd_1
XFILLER_6_210 VGND VGND VPWR VPWR sky130_fd_sc_hd__decap_3
XFILLER_10_283 VGND VGND VPWR VPWR sky130_fd_sc_hd__decap_3
XFILLER_6_232 VGND VGND VPWR VPWR sky130_fd_sc_hd__decap_3
XFILLER_109_683 VGND VGND VPWR VPWR sky130_fd_sc_hd__fill_1
XFILLER_115_119 VGND VGND VPWR VPWR sky130_fd_sc_hd__decap_3
XFILLER_6_265 VGND VGND VPWR VPWR sky130_fd_sc_hd__fill_2
XFILLER_108_171 VGND VGND VPWR VPWR sky130_fd_sc_hd__fill_2
XFILLER_111_303 VGND VGND VPWR VPWR sky130_fd_sc_hd__decap_3
XFILLER_69_217 VGND VGND VPWR VPWR sky130_fd_sc_hd__decap_3
XTAP_TAPCELL_ROW_90_1428 VGND VPWR sky130_fd_sc_hd__tapvpwrvgnd_1
XFILLER_69_228 VGND VGND VPWR VPWR sky130_fd_sc_hd__decap_3
XFILLER_111_369 VGND VGND VPWR VPWR sky130_fd_sc_hd__decap_3
XFILLER_84_209 VGND VGND VPWR VPWR sky130_fd_sc_hd__decap_3
XFILLER_65_423 VGND VGND VPWR VPWR sky130_fd_sc_hd__decap_3
XFILLER_77_261 VGND VGND VPWR VPWR sky130_fd_sc_hd__decap_3
XFILLER_93_732 VGND VGND VPWR VPWR sky130_fd_sc_hd__fill_1
XFILLER_38_648 VGND VGND VPWR VPWR sky130_fd_sc_hd__fill_2
XFILLER_92_231 VGND VGND VPWR VPWR sky130_fd_sc_hd__decap_3
XFILLER_18_361 VGND VGND VPWR VPWR sky130_fd_sc_hd__decap_3
XFILLER_37_169 VGND VGND VPWR VPWR sky130_fd_sc_hd__decap_3
XFILLER_52_106 VGND VGND VPWR VPWR sky130_fd_sc_hd__decap_3
XFILLER_53_629 VGND VGND VPWR VPWR sky130_fd_sc_hd__decap_3
XFILLER_65_478 VGND VGND VPWR VPWR sky130_fd_sc_hd__decap_3
XFILLER_92_253 VGND VGND VPWR VPWR sky130_fd_sc_hd__decap_3
XFILLER_92_264 VGND VGND VPWR VPWR sky130_fd_sc_hd__decap_3
XPHY_EDGE_ROW_9_Left_129 VGND VGND VPWR VPWR sky130_fd_sc_hd__decap_3
X_5950_ _5950_/A _6130_/B VGND VGND VPWR VPWR _7825_/B sky130_fd_sc_hd__nand2_2
XFILLER_52_139 VGND VGND VPWR VPWR sky130_fd_sc_hd__fill_1
X_4901_ _6297_/A _6297_/B _6297_/C _6297_/D VGND VGND VPWR VPWR _4917_/B sky130_fd_sc_hd__or4_2
XFILLER_33_364 VGND VGND VPWR VPWR sky130_fd_sc_hd__decap_3
XFILLER_45_191 VGND VGND VPWR VPWR sky130_fd_sc_hd__fill_2
X_7620_ _5333_/A _8223_/Q _5076_/Y _6767_/Y _7619_/X VGND VGND VPWR VPWR _7621_/B
+ sky130_fd_sc_hd__a41o_2
X_5881_ _8236_/Q _5876_/B _5880_/X VGND VGND VPWR VPWR _5882_/B sky130_fd_sc_hd__a21o_2
XFILLER_21_515 VGND VGND VPWR VPWR sky130_fd_sc_hd__decap_3
XFILLER_60_150 VGND VGND VPWR VPWR sky130_fd_sc_hd__decap_3
XFILLER_60_183 VGND VGND VPWR VPWR sky130_fd_sc_hd__decap_3
X_4832_ _8262_/Q VGND VGND VPWR VPWR _4834_/B sky130_fd_sc_hd__inv_2
X_7551_ _7551_/A _7551_/B VGND VGND VPWR VPWR _7551_/Y sky130_fd_sc_hd__nor2_2
X_4763_ _8276_/Q VGND VGND VPWR VPWR _4764_/B sky130_fd_sc_hd__inv_2
X_7482_ _5528_/A _6384_/X _6388_/X _7481_/Y VGND VGND VPWR VPWR _7482_/X sky130_fd_sc_hd__a22o_2
X_6502_ _6999_/A1 _6499_/X _6501_/X VGND VGND VPWR VPWR _6502_/X sky130_fd_sc_hd__a21o_2
X_4694_ _7843_/A _8151_/Q VGND VGND VPWR VPWR _4695_/A sky130_fd_sc_hd__and2_2
XFILLER_107_609 VGND VGND VPWR VPWR sky130_fd_sc_hd__decap_3
XFILLER_119_447 VGND VGND VPWR VPWR sky130_fd_sc_hd__fill_1
XFILLER_119_458 VGND VGND VPWR VPWR sky130_fd_sc_hd__fill_1
X_6433_ _8185_/Q _8186_/Q _6433_/C VGND VGND VPWR VPWR _6434_/B sky130_fd_sc_hd__nand3_2
XFILLER_115_620 VGND VGND VPWR VPWR sky130_fd_sc_hd__fill_1
X_6364_ _6359_/X _6360_/X _6445_/A1 VGND VGND VPWR VPWR _6364_/X sky130_fd_sc_hd__a21o_2
XFILLER_88_515 VGND VGND VPWR VPWR sky130_fd_sc_hd__decap_3
X_8103_ clkload5/A _8103_/D VGND VGND VPWR VPWR _8103_/Q sky130_fd_sc_hd__dfxtp_2
X_6295_ _8183_/Q _8247_/Q _6229_/X _6294_/X VGND VGND VPWR VPWR _6295_/X sky130_fd_sc_hd__o211a_2
X_5315_ _4963_/X _5288_/A _5288_/B _5314_/X VGND VGND VPWR VPWR _5315_/X sky130_fd_sc_hd__o31a_4
XFILLER_114_174 VGND VGND VPWR VPWR sky130_fd_sc_hd__fill_1
X_8034_ _8187_/CLK _8034_/D VGND VGND VPWR VPWR _8034_/Q sky130_fd_sc_hd__dfxtp_2
X_5246_ _8177_/Q _8178_/Q _7805_/A VGND VGND VPWR VPWR _5246_/X sky130_fd_sc_hd__mux2_2
XFILLER_102_347 VGND VGND VPWR VPWR sky130_fd_sc_hd__decap_3
XFILLER_29_604 VGND VGND VPWR VPWR sky130_fd_sc_hd__decap_3
XPHY_EDGE_ROW_89_Right_89 VGND VGND VPWR VPWR sky130_fd_sc_hd__decap_3
XFILLER_28_103 VGND VGND VPWR VPWR sky130_fd_sc_hd__decap_3
XFILLER_56_401 VGND VGND VPWR VPWR sky130_fd_sc_hd__decap_3
XFILLER_68_272 VGND VGND VPWR VPWR sky130_fd_sc_hd__decap_3
XTAP_TAPCELL_ROW_110_1686 VGND VPWR sky130_fd_sc_hd__tapvpwrvgnd_1
X_5177_ _6095_/A _5943_/A _5943_/B _5943_/C _7805_/A _7783_/A VGND VGND VPWR VPWR
+ _5177_/X sky130_fd_sc_hd__mux4_2
XFILLER_110_391 VGND VGND VPWR VPWR sky130_fd_sc_hd__fill_2
XFILLER_29_659 VGND VGND VPWR VPWR sky130_fd_sc_hd__decap_3
XFILLER_56_445 VGND VGND VPWR VPWR sky130_fd_sc_hd__fill_1
XFILLER_83_231 VGND VGND VPWR VPWR sky130_fd_sc_hd__fill_2
X_4128_ _7930_/B _7934_/Q VGND VGND VPWR VPWR _4129_/A sky130_fd_sc_hd__and2_2
XFILLER_16_309 VGND VGND VPWR VPWR sky130_fd_sc_hd__decap_3
XFILLER_43_106 VGND VGND VPWR VPWR sky130_fd_sc_hd__decap_3
XFILLER_44_629 VGND VGND VPWR VPWR sky130_fd_sc_hd__fill_2
XFILLER_56_489 VGND VGND VPWR VPWR sky130_fd_sc_hd__fill_2
XFILLER_83_253 VGND VGND VPWR VPWR sky130_fd_sc_hd__decap_3
X_4059_ _4059_/A VGND VGND VPWR VPWR _7967_/D sky130_fd_sc_hd__buf_1
XFILLER_71_437 VGND VGND VPWR VPWR sky130_fd_sc_hd__decap_3
XTAP_TAPCELL_ROW_65_1110 VGND VPWR sky130_fd_sc_hd__tapvpwrvgnd_1
XFILLER_101_21 VGND VGND VPWR VPWR sky130_fd_sc_hd__decap_3
XFILLER_24_331 VGND VGND VPWR VPWR sky130_fd_sc_hd__decap_3
XFILLER_24_353 VGND VGND VPWR VPWR sky130_fd_sc_hd__decap_3
XTAP_TAPCELL_ROW_42_808 VGND VPWR sky130_fd_sc_hd__tapvpwrvgnd_1
XFILLER_12_504 VGND VGND VPWR VPWR sky130_fd_sc_hd__decap_3
XFILLER_24_386 VGND VGND VPWR VPWR sky130_fd_sc_hd__decap_3
XFILLER_51_161 VGND VGND VPWR VPWR sky130_fd_sc_hd__decap_3
XPHY_EDGE_ROW_98_Right_98 VGND VGND VPWR VPWR sky130_fd_sc_hd__decap_3
X_7818_ _5950_/A _7816_/Y _7817_/Y _7796_/A VGND VGND VPWR VPWR _7818_/X sky130_fd_sc_hd__a22o_2
XFILLER_12_559 VGND VGND VPWR VPWR sky130_fd_sc_hd__decap_3
XFILLER_61_36 VGND VGND VPWR VPWR sky130_fd_sc_hd__decap_3
XFILLER_8_519 VGND VGND VPWR VPWR sky130_fd_sc_hd__decap_3
X_7749_ _8203_/Q _7660_/X _7664_/X VGND VGND VPWR VPWR _7749_/X sky130_fd_sc_hd__o21a_2
XTAP_TAPCELL_ROW_22_543 VGND VPWR sky130_fd_sc_hd__tapvpwrvgnd_1
XFILLER_61_69 VGND VGND VPWR VPWR sky130_fd_sc_hd__decap_3
XFILLER_20_592 VGND VGND VPWR VPWR sky130_fd_sc_hd__decap_3
XFILLER_117_3 VGND VGND VPWR VPWR sky130_fd_sc_hd__decap_3
XFILLER_3_202 VGND VGND VPWR VPWR sky130_fd_sc_hd__fill_1
XFILLER_106_620 VGND VGND VPWR VPWR sky130_fd_sc_hd__decap_3
XTAP_TAPCELL_ROW_76_1250 VGND VPWR sky130_fd_sc_hd__tapvpwrvgnd_1
XFILLER_10_62 VGND VGND VPWR VPWR sky130_fd_sc_hd__decap_3
XFILLER_3_246 VGND VGND VPWR VPWR sky130_fd_sc_hd__fill_1
XFILLER_105_163 VGND VGND VPWR VPWR sky130_fd_sc_hd__decap_3
XFILLER_105_196 VGND VGND VPWR VPWR sky130_fd_sc_hd__decap_3
XFILLER_79_526 VGND VGND VPWR VPWR sky130_fd_sc_hd__decap_3
XFILLER_66_209 VGND VGND VPWR VPWR sky130_fd_sc_hd__decap_3
XFILLER_94_507 VGND VGND VPWR VPWR sky130_fd_sc_hd__fill_1
XFILLER_19_103 VGND VGND VPWR VPWR sky130_fd_sc_hd__decap_3
XFILLER_47_423 VGND VGND VPWR VPWR sky130_fd_sc_hd__decap_3
XFILLER_75_732 VGND VGND VPWR VPWR sky130_fd_sc_hd__fill_1
XFILLER_86_77 VGND VGND VPWR VPWR sky130_fd_sc_hd__decap_3
XFILLER_86_88 VGND VGND VPWR VPWR sky130_fd_sc_hd__decap_3
XFILLER_19_125 VGND VGND VPWR VPWR sky130_fd_sc_hd__decap_3
XFILLER_19_60 VGND VGND VPWR VPWR sky130_fd_sc_hd__decap_3
XFILLER_87_592 VGND VGND VPWR VPWR sky130_fd_sc_hd__decap_3
XFILLER_19_158 VGND VGND VPWR VPWR sky130_fd_sc_hd__decap_3
XFILLER_19_169 VGND VGND VPWR VPWR sky130_fd_sc_hd__decap_3
XFILLER_34_106 VGND VGND VPWR VPWR sky130_fd_sc_hd__decap_3
XFILLER_47_489 VGND VGND VPWR VPWR sky130_fd_sc_hd__decap_3
XFILLER_62_415 VGND VGND VPWR VPWR sky130_fd_sc_hd__decap_3
XFILLER_74_242 VGND VGND VPWR VPWR sky130_fd_sc_hd__decap_3
XFILLER_74_253 VGND VGND VPWR VPWR sky130_fd_sc_hd__decap_3
XFILLER_90_713 VGND VGND VPWR VPWR sky130_fd_sc_hd__decap_3
XFILLER_62_448 VGND VGND VPWR VPWR sky130_fd_sc_hd__fill_1
XFILLER_74_286 VGND VGND VPWR VPWR sky130_fd_sc_hd__decap_3
XFILLER_74_297 VGND VGND VPWR VPWR sky130_fd_sc_hd__decap_3
XTAP_TAPCELL_ROW_87_1390 VGND VPWR sky130_fd_sc_hd__tapvpwrvgnd_1
XTAP_TAPCELL_ROW_2_290 VGND VPWR sky130_fd_sc_hd__tapvpwrvgnd_1
XFILLER_35_70 VGND VGND VPWR VPWR sky130_fd_sc_hd__decap_3
XFILLER_43_640 VGND VGND VPWR VPWR sky130_fd_sc_hd__fill_2
XFILLER_30_312 VGND VGND VPWR VPWR sky130_fd_sc_hd__decap_3
XFILLER_43_673 VGND VGND VPWR VPWR sky130_fd_sc_hd__fill_1
XFILLER_70_470 VGND VGND VPWR VPWR sky130_fd_sc_hd__decap_3
XFILLER_30_378 VGND VGND VPWR VPWR sky130_fd_sc_hd__decap_3
XFILLER_11_581 VGND VGND VPWR VPWR sky130_fd_sc_hd__decap_3
Xmax_cap216 _5627_/X VGND VGND VPWR VPWR _5812_/A sky130_fd_sc_hd__buf_6
Xmax_cap205 _5508_/X VGND VGND VPWR VPWR _7305_/A1 sky130_fd_sc_hd__buf_6
XFILLER_109_491 VGND VGND VPWR VPWR sky130_fd_sc_hd__decap_3
Xmax_cap249 _8226_/Q VGND VGND VPWR VPWR _5596_/S sky130_fd_sc_hd__buf_12
Xmax_cap238 _6462_/B VGND VGND VPWR VPWR _7631_/C sky130_fd_sc_hd__buf_4
Xmax_cap227 _5313_/A VGND VGND VPWR VPWR _5433_/A sky130_fd_sc_hd__buf_4
XFILLER_112_601 VGND VGND VPWR VPWR sky130_fd_sc_hd__decap_3
X_6080_ _6084_/A _6081_/B VGND VGND VPWR VPWR _6080_/Y sky130_fd_sc_hd__nor2_2
X_5100_ _5100_/A VGND VGND VPWR VPWR _6070_/A sky130_fd_sc_hd__buf_1
XFILLER_112_645 VGND VGND VPWR VPWR sky130_fd_sc_hd__decap_3
XFILLER_97_356 VGND VGND VPWR VPWR sky130_fd_sc_hd__decap_3
X_5031_ _4921_/A _4928_/A _5928_/A VGND VGND VPWR VPWR _5031_/Y sky130_fd_sc_hd__a21boi_2
XFILLER_111_188 VGND VGND VPWR VPWR sky130_fd_sc_hd__decap_3
XFILLER_112_689 VGND VGND VPWR VPWR sky130_fd_sc_hd__decap_3
XFILLER_66_710 VGND VGND VPWR VPWR sky130_fd_sc_hd__decap_3
XFILLER_97_378 VGND VGND VPWR VPWR sky130_fd_sc_hd__decap_3
XFILLER_38_456 VGND VGND VPWR VPWR sky130_fd_sc_hd__decap_3
XFILLER_65_231 VGND VGND VPWR VPWR sky130_fd_sc_hd__decap_3
XFILLER_25_106 VGND VGND VPWR VPWR sky130_fd_sc_hd__decap_3
XFILLER_26_629 VGND VGND VPWR VPWR sky130_fd_sc_hd__decap_3
XFILLER_81_713 VGND VGND VPWR VPWR sky130_fd_sc_hd__decap_3
XFILLER_81_724 VGND VGND VPWR VPWR sky130_fd_sc_hd__decap_3
XFILLER_93_573 VGND VGND VPWR VPWR sky130_fd_sc_hd__decap_3
XFILLER_53_426 VGND VGND VPWR VPWR sky130_fd_sc_hd__decap_3
XFILLER_80_223 VGND VGND VPWR VPWR sky130_fd_sc_hd__fill_2
XTAP_TAPCELL_ROW_0_249 VGND VPWR sky130_fd_sc_hd__tapvpwrvgnd_1
Xclone395 _6353_/A VGND VGND VPWR VPWR _6130_/A sky130_fd_sc_hd__clkbuf_16
X_6982_ _5614_/X _6976_/Y _6981_/X VGND VGND VPWR VPWR _6982_/Y sky130_fd_sc_hd__o21ai_2
XFILLER_80_256 VGND VGND VPWR VPWR sky130_fd_sc_hd__decap_3
X_5933_ _5933_/A _6302_/C VGND VGND VPWR VPWR _5933_/Y sky130_fd_sc_hd__nand2_2
XFILLER_61_470 VGND VGND VPWR VPWR sky130_fd_sc_hd__decap_3
XFILLER_80_289 VGND VGND VPWR VPWR sky130_fd_sc_hd__decap_3
X_5864_ _5460_/X _5461_/X _5465_/X _5458_/X _5182_/A _7745_/A VGND VGND VPWR VPWR
+ _5864_/X sky130_fd_sc_hd__mux4_2
XFILLER_21_334 VGND VGND VPWR VPWR sky130_fd_sc_hd__fill_2
X_7603_ _6538_/A _7135_/Y _7599_/X _8290_/Q _7602_/X VGND VGND VPWR VPWR _7603_/X
+ sky130_fd_sc_hd__a221o_2
X_4815_ _6873_/A _6958_/A _7076_/A VGND VGND VPWR VPWR _4824_/B sky130_fd_sc_hd__or3_2
XFILLER_31_17 VGND VGND VPWR VPWR sky130_fd_sc_hd__decap_3
X_7534_ _7612_/B _7612_/C VGND VGND VPWR VPWR _7561_/B sky130_fd_sc_hd__nor2_2
X_5795_ _5435_/A _5793_/X _5791_/A _5788_/X VGND VGND VPWR VPWR _5795_/X sky130_fd_sc_hd__a2bb2o_2
XTAP_TAPCELL_ROW_60_1040 VGND VPWR sky130_fd_sc_hd__tapvpwrvgnd_1
XFILLER_119_233 VGND VGND VPWR VPWR sky130_fd_sc_hd__decap_3
X_4746_ _8282_/Q VGND VGND VPWR VPWR _4747_/B sky130_fd_sc_hd__inv_2
XFILLER_107_417 VGND VGND VPWR VPWR sky130_fd_sc_hd__decap_3
XFILLER_119_277 VGND VGND VPWR VPWR sky130_fd_sc_hd__decap_3
X_7465_ _8218_/Q _8282_/Q _7464_/X VGND VGND VPWR VPWR _7465_/X sky130_fd_sc_hd__a21o_2
X_4677_ _4677_/A VGND VGND VPWR VPWR _8276_/D sky130_fd_sc_hd__buf_1
XFILLER_103_9 VGND VGND VPWR VPWR sky130_fd_sc_hd__fill_1
X_7396_ _7396_/A _7396_/B _7392_/X _7395_/X VGND VGND VPWR VPWR _7396_/X sky130_fd_sc_hd__or4bb_4
X_6416_ _6999_/A1 _6413_/X _6415_/X VGND VGND VPWR VPWR _6416_/X sky130_fd_sc_hd__a21o_2
XTAP_TAPCELL_ROW_112_1715 VGND VPWR sky130_fd_sc_hd__tapvpwrvgnd_1
X_6347_ _6346_/X _6199_/X _6706_/S VGND VGND VPWR VPWR _6645_/B sky130_fd_sc_hd__mux2_2
XFILLER_102_111 VGND VGND VPWR VPWR sky130_fd_sc_hd__decap_3
XFILLER_103_623 VGND VGND VPWR VPWR sky130_fd_sc_hd__decap_3
XFILLER_115_494 VGND VGND VPWR VPWR sky130_fd_sc_hd__decap_3
XFILLER_102_144 VGND VGND VPWR VPWR sky130_fd_sc_hd__decap_3
Xinput106 operand_b[42] VGND VGND VPWR VPWR _4388_/B sky130_fd_sc_hd__clkdlybuf4s25_1
Xinput117 operand_b[52] VGND VGND VPWR VPWR _4408_/B sky130_fd_sc_hd__clkdlybuf4s25_1
X_6278_ _6353_/A _5633_/B _6277_/Y _6650_/B VGND VGND VPWR VPWR _6278_/X sky130_fd_sc_hd__a211o_2
XFILLER_102_177 VGND VGND VPWR VPWR sky130_fd_sc_hd__decap_3
XFILLER_69_570 VGND VGND VPWR VPWR sky130_fd_sc_hd__decap_3
X_8017_ _8352_/CLK _8017_/D VGND VGND VPWR VPWR _8017_/Q sky130_fd_sc_hd__dfxtp_2
Xinput128 operand_b[62] VGND VGND VPWR VPWR _4428_/B sky130_fd_sc_hd__clkdlybuf4s25_1
X_5229_ _8203_/Q _8204_/Q _6380_/S VGND VGND VPWR VPWR _5229_/X sky130_fd_sc_hd__mux2_2
XTAP_TAPCELL_ROW_71_1180 VGND VPWR sky130_fd_sc_hd__tapvpwrvgnd_1
XFILLER_29_423 VGND VGND VPWR VPWR sky130_fd_sc_hd__decap_3
XFILLER_57_732 VGND VGND VPWR VPWR sky130_fd_sc_hd__fill_1
XFILLER_69_592 VGND VGND VPWR VPWR sky130_fd_sc_hd__decap_3
XFILLER_29_467 VGND VGND VPWR VPWR sky130_fd_sc_hd__decap_3
XFILLER_44_404 VGND VGND VPWR VPWR sky130_fd_sc_hd__decap_3
XFILLER_56_242 VGND VGND VPWR VPWR sky130_fd_sc_hd__decap_3
XFILLER_56_58 VGND VGND VPWR VPWR sky130_fd_sc_hd__decap_3
XFILLER_71_223 VGND VGND VPWR VPWR sky130_fd_sc_hd__fill_1
XTAP_TAPCELL_ROW_27_613 VGND VPWR sky130_fd_sc_hd__tapvpwrvgnd_1
XFILLER_71_234 VGND VGND VPWR VPWR sky130_fd_sc_hd__fill_2
XFILLER_71_256 VGND VGND VPWR VPWR sky130_fd_sc_hd__decap_3
XTAP_TAPCELL_ROW_55_977 VGND VPWR sky130_fd_sc_hd__tapvpwrvgnd_1
XFILLER_24_150 VGND VGND VPWR VPWR sky130_fd_sc_hd__decap_3
XFILLER_25_673 VGND VGND VPWR VPWR sky130_fd_sc_hd__fill_1
XFILLER_12_334 VGND VGND VPWR VPWR sky130_fd_sc_hd__decap_3
XFILLER_24_183 VGND VGND VPWR VPWR sky130_fd_sc_hd__decap_3
XFILLER_40_632 VGND VGND VPWR VPWR sky130_fd_sc_hd__decap_3
XFILLER_40_665 VGND VGND VPWR VPWR sky130_fd_sc_hd__decap_3
XFILLER_8_305 VGND VGND VPWR VPWR sky130_fd_sc_hd__decap_3
XPHY_EDGE_ROW_117_Right_117 VGND VGND VPWR VPWR sky130_fd_sc_hd__decap_3
XFILLER_4_522 VGND VGND VPWR VPWR sky130_fd_sc_hd__decap_3
XFILLER_106_450 VGND VGND VPWR VPWR sky130_fd_sc_hd__fill_1
XFILLER_21_94 VGND VGND VPWR VPWR sky130_fd_sc_hd__fill_1
XFILLER_4_544 VGND VGND VPWR VPWR sky130_fd_sc_hd__decap_3
XFILLER_97_32 VGND VGND VPWR VPWR sky130_fd_sc_hd__decap_3
XFILLER_39_209 VGND VGND VPWR VPWR sky130_fd_sc_hd__decap_3
XFILLER_67_518 VGND VGND VPWR VPWR sky130_fd_sc_hd__decap_3
XFILLER_79_378 VGND VGND VPWR VPWR sky130_fd_sc_hd__decap_3
XFILLER_94_304 VGND VGND VPWR VPWR sky130_fd_sc_hd__decap_3
XFILLER_35_426 VGND VGND VPWR VPWR sky130_fd_sc_hd__decap_3
XFILLER_75_584 VGND VGND VPWR VPWR sky130_fd_sc_hd__decap_3
XFILLER_75_595 VGND VGND VPWR VPWR sky130_fd_sc_hd__fill_1
XFILLER_16_651 VGND VGND VPWR VPWR sky130_fd_sc_hd__decap_3
XFILLER_46_80 VGND VGND VPWR VPWR sky130_fd_sc_hd__decap_3
XFILLER_50_407 VGND VGND VPWR VPWR sky130_fd_sc_hd__decap_3
XFILLER_62_256 VGND VGND VPWR VPWR sky130_fd_sc_hd__fill_1
XFILLER_90_565 VGND VGND VPWR VPWR sky130_fd_sc_hd__decap_3
XFILLER_15_161 VGND VGND VPWR VPWR sky130_fd_sc_hd__decap_3
XFILLER_16_684 VGND VGND VPWR VPWR sky130_fd_sc_hd__fill_2
XFILLER_16_695 VGND VGND VPWR VPWR sky130_fd_sc_hd__decap_3
XFILLER_22_109 VGND VGND VPWR VPWR sky130_fd_sc_hd__decap_3
XFILLER_62_289 VGND VGND VPWR VPWR sky130_fd_sc_hd__decap_3
XFILLER_90_587 VGND VGND VPWR VPWR sky130_fd_sc_hd__fill_1
XFILLER_90_598 VGND VGND VPWR VPWR sky130_fd_sc_hd__decap_3
XFILLER_30_120 VGND VGND VPWR VPWR sky130_fd_sc_hd__decap_3
XPHY_EDGE_ROW_99_Left_219 VGND VGND VPWR VPWR sky130_fd_sc_hd__decap_3
XFILLER_30_153 VGND VGND VPWR VPWR sky130_fd_sc_hd__decap_3
XFILLER_31_676 VGND VGND VPWR VPWR sky130_fd_sc_hd__fill_1
XFILLER_31_687 VGND VGND VPWR VPWR sky130_fd_sc_hd__fill_1
X_4600_ _7898_/B _8104_/Q VGND VGND VPWR VPWR _4601_/A sky130_fd_sc_hd__and2_2
XFILLER_30_197 VGND VGND VPWR VPWR sky130_fd_sc_hd__decap_3
X_5580_ _5578_/X _5579_/X _6507_/S VGND VGND VPWR VPWR _5581_/B sky130_fd_sc_hd__mux2_2
XFILLER_117_726 VGND VGND VPWR VPWR sky130_fd_sc_hd__fill_2
XFILLER_7_41 VGND VGND VPWR VPWR sky130_fd_sc_hd__decap_3
XFILLER_7_63 VGND VGND VPWR VPWR sky130_fd_sc_hd__decap_3
X_4531_ _4531_/A VGND VGND VPWR VPWR _8203_/D sky130_fd_sc_hd__buf_1
XFILLER_116_214 VGND VGND VPWR VPWR sky130_fd_sc_hd__decap_3
XFILLER_7_371 VGND VGND VPWR VPWR sky130_fd_sc_hd__decap_3
XFILLER_7_393 VGND VGND VPWR VPWR sky130_fd_sc_hd__decap_3
X_7250_ _8274_/Q _7226_/B _7249_/X VGND VGND VPWR VPWR _7251_/B sky130_fd_sc_hd__a21oi_2
X_4462_ _7898_/B _8035_/Q VGND VGND VPWR VPWR _4463_/A sky130_fd_sc_hd__and2_2
XFILLER_104_409 VGND VGND VPWR VPWR sky130_fd_sc_hd__decap_3
X_6201_ _6200_/X _5917_/X _6707_/S VGND VGND VPWR VPWR _6784_/B sky130_fd_sc_hd__mux2_2
XFILLER_98_610 VGND VGND VPWR VPWR sky130_fd_sc_hd__decap_3
X_7181_ _7142_/X _7165_/Y _7180_/X _7305_/A1 _7930_/B VGND VGND VPWR VPWR _8342_/D
+ sky130_fd_sc_hd__o221a_2
X_4393_ _4393_/A VGND VGND VPWR VPWR _8134_/D sky130_fd_sc_hd__buf_1
X_6132_ _6132_/A _6132_/B VGND VGND VPWR VPWR _6132_/X sky130_fd_sc_hd__or2_2
XTAP_TAPCELL_ROW_5_319 VGND VPWR sky130_fd_sc_hd__tapvpwrvgnd_1
XFILLER_112_486 VGND VGND VPWR VPWR sky130_fd_sc_hd__decap_3
XFILLER_58_529 VGND VGND VPWR VPWR sky130_fd_sc_hd__decap_3
XFILLER_97_175 VGND VGND VPWR VPWR sky130_fd_sc_hd__decap_3
XFILLER_98_698 VGND VGND VPWR VPWR sky130_fd_sc_hd__fill_2
X_6063_ _7825_/A _6650_/C _6062_/Y _5745_/X VGND VGND VPWR VPWR _6064_/B sky130_fd_sc_hd__o22a_2
XFILLER_100_648 VGND VGND VPWR VPWR sky130_fd_sc_hd__decap_3
XFILLER_39_732 VGND VGND VPWR VPWR sky130_fd_sc_hd__fill_1
XFILLER_85_337 VGND VGND VPWR VPWR sky130_fd_sc_hd__decap_3
X_5014_ _8163_/Q _5012_/Y _5013_/X VGND VGND VPWR VPWR _5014_/Y sky130_fd_sc_hd__a21oi_2
XFILLER_26_404 VGND VGND VPWR VPWR sky130_fd_sc_hd__decap_3
XFILLER_26_17 VGND VGND VPWR VPWR sky130_fd_sc_hd__decap_3
XFILLER_53_223 VGND VGND VPWR VPWR sky130_fd_sc_hd__fill_1
XFILLER_66_595 VGND VGND VPWR VPWR sky130_fd_sc_hd__decap_3
XFILLER_93_370 VGND VGND VPWR VPWR sky130_fd_sc_hd__decap_3
XFILLER_53_234 VGND VGND VPWR VPWR sky130_fd_sc_hd__decap_3
X_6965_ _7606_/A1 _6935_/Y _6955_/X _6964_/X _7930_/B VGND VGND VPWR VPWR _8336_/D
+ sky130_fd_sc_hd__o221a_2
XFILLER_81_587 VGND VGND VPWR VPWR sky130_fd_sc_hd__decap_3
X_5916_ _8173_/Q _8172_/Q _5943_/C _5943_/B _5780_/S _6199_/S1 VGND VGND VPWR VPWR
+ _5916_/X sky130_fd_sc_hd__mux4_2
XTAP_TAPCELL_ROW_52_936 VGND VPWR sky130_fd_sc_hd__tapvpwrvgnd_1
XFILLER_34_492 VGND VGND VPWR VPWR sky130_fd_sc_hd__fill_1
X_6896_ _7631_/B _6895_/X _6687_/X VGND VGND VPWR VPWR _6896_/Y sky130_fd_sc_hd__a21oi_2
XFILLER_21_142 VGND VGND VPWR VPWR sky130_fd_sc_hd__decap_3
XFILLER_22_654 VGND VGND VPWR VPWR sky130_fd_sc_hd__decap_3
XFILLER_22_687 VGND VGND VPWR VPWR sky130_fd_sc_hd__fill_2
XFILLER_42_38 VGND VGND VPWR VPWR sky130_fd_sc_hd__decap_3
X_5847_ _5587_/X _5845_/X _5846_/X _5108_/X VGND VGND VPWR VPWR _5848_/B sky130_fd_sc_hd__a22o_2
XFILLER_21_197 VGND VGND VPWR VPWR sky130_fd_sc_hd__decap_3
XFILLER_22_698 VGND VGND VPWR VPWR sky130_fd_sc_hd__fill_2
X_5778_ _6353_/A _5775_/X _5777_/Y _5854_/B VGND VGND VPWR VPWR _5778_/X sky130_fd_sc_hd__a211o_2
XTAP_TAPCELL_ROW_32_671 VGND VPWR sky130_fd_sc_hd__tapvpwrvgnd_1
XFILLER_5_319 VGND VGND VPWR VPWR sky130_fd_sc_hd__decap_3
X_7517_ _7522_/A _7517_/B VGND VGND VPWR VPWR _7517_/X sky130_fd_sc_hd__xor2_2
Xrebuffer457 _8292_/Q VGND VGND VPWR VPWR _7648_/A sky130_fd_sc_hd__buf_2
Xrebuffer446 _8233_/Q VGND VGND VPWR VPWR _5725_/B sky130_fd_sc_hd__buf_2
X_4729_ _7588_/A _7541_/A _7541_/B VGND VGND VPWR VPWR _4738_/A sky130_fd_sc_hd__or3_2
XFILLER_107_214 VGND VGND VPWR VPWR sky130_fd_sc_hd__decap_3
XFILLER_107_225 VGND VGND VPWR VPWR sky130_fd_sc_hd__decap_3
X_7448_ _8217_/Q _8216_/Q _8215_/Q _8214_/Q _7796_/A _7765_/A VGND VGND VPWR VPWR
+ _7448_/X sky130_fd_sc_hd__mux4_2
XFILLER_107_247 VGND VGND VPWR VPWR sky130_fd_sc_hd__decap_3
XFILLER_107_31 VGND VGND VPWR VPWR sky130_fd_sc_hd__decap_3
XFILLER_89_632 VGND VGND VPWR VPWR sky130_fd_sc_hd__decap_3
X_7379_ _7394_/C _7551_/B _7378_/Y _5076_/Y VGND VGND VPWR VPWR _7380_/B sky130_fd_sc_hd__o22a_2
XFILLER_103_420 VGND VGND VPWR VPWR sky130_fd_sc_hd__decap_3
XFILLER_89_654 VGND VGND VPWR VPWR sky130_fd_sc_hd__decap_3
XFILLER_103_464 VGND VGND VPWR VPWR sky130_fd_sc_hd__decap_3
XFILLER_67_57 VGND VGND VPWR VPWR sky130_fd_sc_hd__decap_3
XFILLER_89_676 VGND VGND VPWR VPWR sky130_fd_sc_hd__decap_3
XFILLER_103_497 VGND VGND VPWR VPWR sky130_fd_sc_hd__decap_3
XFILLER_76_348 VGND VGND VPWR VPWR sky130_fd_sc_hd__fill_2
XFILLER_29_231 VGND VGND VPWR VPWR sky130_fd_sc_hd__fill_2
XFILLER_29_253 VGND VGND VPWR VPWR sky130_fd_sc_hd__fill_1
XFILLER_57_540 VGND VGND VPWR VPWR sky130_fd_sc_hd__decap_3
XFILLER_57_573 VGND VGND VPWR VPWR sky130_fd_sc_hd__decap_3
XFILLER_91_318 VGND VGND VPWR VPWR sky130_fd_sc_hd__fill_1
XFILLER_17_415 VGND VGND VPWR VPWR sky130_fd_sc_hd__decap_3
XFILLER_44_212 VGND VGND VPWR VPWR sky130_fd_sc_hd__decap_3
XFILLER_72_521 VGND VGND VPWR VPWR sky130_fd_sc_hd__decap_3
XFILLER_44_256 VGND VGND VPWR VPWR sky130_fd_sc_hd__decap_3
XFILLER_13_610 VGND VGND VPWR VPWR sky130_fd_sc_hd__fill_2
XFILLER_12_120 VGND VGND VPWR VPWR sky130_fd_sc_hd__decap_3
XFILLER_12_153 VGND VGND VPWR VPWR sky130_fd_sc_hd__decap_3
XFILLER_13_654 VGND VGND VPWR VPWR sky130_fd_sc_hd__fill_1
XFILLER_13_676 VGND VGND VPWR VPWR sky130_fd_sc_hd__decap_3
XFILLER_40_451 VGND VGND VPWR VPWR sky130_fd_sc_hd__decap_3
XFILLER_40_495 VGND VGND VPWR VPWR sky130_fd_sc_hd__fill_1
XFILLER_32_82 VGND VGND VPWR VPWR sky130_fd_sc_hd__fill_2
XFILLER_114_707 VGND VGND VPWR VPWR sky130_fd_sc_hd__fill_1
XFILLER_4_330 VGND VGND VPWR VPWR sky130_fd_sc_hd__decap_3
XTAP_TAPCELL_ROW_10_387 VGND VPWR sky130_fd_sc_hd__tapvpwrvgnd_1
XFILLER_4_374 VGND VGND VPWR VPWR sky130_fd_sc_hd__fill_1
XFILLER_106_280 VGND VGND VPWR VPWR sky130_fd_sc_hd__decap_3
XFILLER_95_602 VGND VGND VPWR VPWR sky130_fd_sc_hd__fill_2
XFILLER_67_337 VGND VGND VPWR VPWR sky130_fd_sc_hd__decap_3
XFILLER_94_112 VGND VGND VPWR VPWR sky130_fd_sc_hd__decap_3
XFILLER_94_134 VGND VGND VPWR VPWR sky130_fd_sc_hd__decap_3
XFILLER_48_551 VGND VGND VPWR VPWR sky130_fd_sc_hd__decap_3
XFILLER_82_307 VGND VGND VPWR VPWR sky130_fd_sc_hd__fill_1
XFILLER_95_679 VGND VGND VPWR VPWR sky130_fd_sc_hd__decap_3
XFILLER_57_90 VGND VGND VPWR VPWR sky130_fd_sc_hd__decap_3
XFILLER_63_521 VGND VGND VPWR VPWR sky130_fd_sc_hd__decap_3
XFILLER_82_329 VGND VGND VPWR VPWR sky130_fd_sc_hd__decap_3
XFILLER_94_189 VGND VGND VPWR VPWR sky130_fd_sc_hd__fill_2
XFILLER_35_245 VGND VGND VPWR VPWR sky130_fd_sc_hd__decap_3
XFILLER_63_543 VGND VGND VPWR VPWR sky130_fd_sc_hd__decap_3
XFILLER_35_278 VGND VGND VPWR VPWR sky130_fd_sc_hd__fill_2
XFILLER_63_598 VGND VGND VPWR VPWR sky130_fd_sc_hd__decap_3
X_6750_ _6462_/A _8196_/Q _6749_/Y _5332_/A _4838_/B VGND VGND VPWR VPWR _6750_/X
+ sky130_fd_sc_hd__a32o_2
XFILLER_50_237 VGND VGND VPWR VPWR sky130_fd_sc_hd__decap_3
X_5701_ _5701_/A VGND VGND VPWR VPWR _5701_/X sky130_fd_sc_hd__buf_1
XTAP_TAPCELL_ROW_18_498 VGND VPWR sky130_fd_sc_hd__tapvpwrvgnd_1
XTAP_TAPCELL_ROW_18_487 VGND VPWR sky130_fd_sc_hd__tapvpwrvgnd_1
XFILLER_31_440 VGND VGND VPWR VPWR sky130_fd_sc_hd__decap_3
X_6681_ _8258_/Q _5337_/X _6936_/A2 VGND VGND VPWR VPWR _6681_/Y sky130_fd_sc_hd__o21ai_2
X_5632_ _6353_/B _5631_/X VGND VGND VPWR VPWR _5633_/B sky130_fd_sc_hd__or2b_2
XTAP_TAPCELL_ROW_98_1529 VGND VPWR sky130_fd_sc_hd__tapvpwrvgnd_1
XFILLER_117_501 VGND VGND VPWR VPWR sky130_fd_sc_hd__decap_3
X_8351_ _8353_/CLK _8351_/D VGND VGND VPWR VPWR _8351_/Q sky130_fd_sc_hd__dfxtp_2
X_5563_ _6220_/A VGND VGND VPWR VPWR _5563_/X sky130_fd_sc_hd__clkbuf_1
X_7302_ _8276_/Q _5422_/X _6687_/A _7301_/X VGND VGND VPWR VPWR _7302_/X sky130_fd_sc_hd__a211o_2
X_4514_ _7898_/B _8061_/Q VGND VGND VPWR VPWR _4515_/A sky130_fd_sc_hd__and2_2
XFILLER_117_567 VGND VGND VPWR VPWR sky130_fd_sc_hd__fill_1
X_8282_ _8287_/CLK _8282_/D VGND VGND VPWR VPWR _8282_/Q sky130_fd_sc_hd__dfxtp_2
X_5494_ _7264_/A _5532_/B _7825_/A _5292_/A VGND VGND VPWR VPWR _5494_/X sky130_fd_sc_hd__a2bb2o_2
XFILLER_104_206 VGND VGND VPWR VPWR sky130_fd_sc_hd__decap_3
XFILLER_105_729 VGND VGND VPWR VPWR sky130_fd_sc_hd__decap_3
X_7233_ _7230_/X _7232_/Y _7233_/S VGND VGND VPWR VPWR _7233_/X sky130_fd_sc_hd__mux2_2
X_4445_ _4445_/A VGND VGND VPWR VPWR _8160_/D sky130_fd_sc_hd__buf_1
XFILLER_104_239 VGND VGND VPWR VPWR sky130_fd_sc_hd__decap_3
X_7164_ _7180_/A _7164_/B VGND VGND VPWR VPWR _7165_/B sky130_fd_sc_hd__xnor2_2
X_4376_ _7930_/B _4376_/B VGND VGND VPWR VPWR _4377_/A sky130_fd_sc_hd__and2_2
XFILLER_100_401 VGND VGND VPWR VPWR sky130_fd_sc_hd__decap_3
XFILLER_112_261 VGND VGND VPWR VPWR sky130_fd_sc_hd__fill_1
XFILLER_58_304 VGND VGND VPWR VPWR sky130_fd_sc_hd__decap_3
XFILLER_58_315 VGND VGND VPWR VPWR sky130_fd_sc_hd__decap_3
X_6115_ _8179_/Q _5732_/X _6944_/A _6150_/B VGND VGND VPWR VPWR _6115_/Y sky130_fd_sc_hd__o2bb2ai_2
XFILLER_58_348 VGND VGND VPWR VPWR sky130_fd_sc_hd__decap_3
XFILLER_86_635 VGND VGND VPWR VPWR sky130_fd_sc_hd__decap_3
XFILLER_86_657 VGND VGND VPWR VPWR sky130_fd_sc_hd__decap_3
X_7095_ _7166_/C _7095_/B VGND VGND VPWR VPWR _7095_/Y sky130_fd_sc_hd__nand2_2
XFILLER_39_540 VGND VGND VPWR VPWR sky130_fd_sc_hd__decap_3
XFILLER_85_167 VGND VGND VPWR VPWR sky130_fd_sc_hd__fill_1
X_6046_ _6046_/A _6046_/B VGND VGND VPWR VPWR _6046_/Y sky130_fd_sc_hd__xnor2_2
XFILLER_26_212 VGND VGND VPWR VPWR sky130_fd_sc_hd__decap_3
XFILLER_54_510 VGND VGND VPWR VPWR sky130_fd_sc_hd__decap_3
XFILLER_54_521 VGND VGND VPWR VPWR sky130_fd_sc_hd__decap_3
XFILLER_73_318 VGND VGND VPWR VPWR sky130_fd_sc_hd__decap_3
XFILLER_26_245 VGND VGND VPWR VPWR sky130_fd_sc_hd__decap_3
XFILLER_81_340 VGND VGND VPWR VPWR sky130_fd_sc_hd__decap_3
XTAP_TAPCELL_ROW_107_1647 VGND VPWR sky130_fd_sc_hd__tapvpwrvgnd_1
XTAP_TAPCELL_ROW_37_741 VGND VPWR sky130_fd_sc_hd__tapvpwrvgnd_1
XFILLER_26_256 VGND VGND VPWR VPWR sky130_fd_sc_hd__decap_3
XFILLER_26_289 VGND VGND VPWR VPWR sky130_fd_sc_hd__decap_3
XFILLER_81_373 VGND VGND VPWR VPWR sky130_fd_sc_hd__decap_3
X_7997_ _8400_/CLK _7997_/D VGND VGND VPWR VPWR _7997_/Q sky130_fd_sc_hd__dfxtp_2
XFILLER_53_37 VGND VGND VPWR VPWR sky130_fd_sc_hd__fill_1
X_6948_ _8202_/Q _6944_/Y _7006_/C _6947_/X VGND VGND VPWR VPWR _6955_/B sky130_fd_sc_hd__o31a_2
XFILLER_10_602 VGND VGND VPWR VPWR sky130_fd_sc_hd__decap_3
XFILLER_41_259 VGND VGND VPWR VPWR sky130_fd_sc_hd__fill_2
X_6879_ _8199_/Q _8263_/Q _6878_/X VGND VGND VPWR VPWR _6879_/X sky130_fd_sc_hd__o21a_2
XFILLER_10_635 VGND VGND VPWR VPWR sky130_fd_sc_hd__decap_3
XFILLER_22_473 VGND VGND VPWR VPWR sky130_fd_sc_hd__decap_3
XFILLER_5_116 VGND VGND VPWR VPWR sky130_fd_sc_hd__decap_3
Xrebuffer265 _8174_/Q VGND VGND VPWR VPWR _6024_/A sky130_fd_sc_hd__buf_2
XFILLER_118_41 VGND VGND VPWR VPWR sky130_fd_sc_hd__decap_3
XTAP_TAPCELL_ROW_118_1787 VGND VPWR sky130_fd_sc_hd__tapvpwrvgnd_1
Xrebuffer287 _8162_/Q VGND VGND VPWR VPWR _5491_/C sky130_fd_sc_hd__clkbuf_4
Xrebuffer276 _5688_/B VGND VGND VPWR VPWR _5592_/B sky130_fd_sc_hd__buf_2
XFILLER_108_589 VGND VGND VPWR VPWR sky130_fd_sc_hd__decap_3
XFILLER_78_23 VGND VGND VPWR VPWR sky130_fd_sc_hd__decap_3
XTAP_TAPCELL_ROW_118_1798 VGND VPWR sky130_fd_sc_hd__tapvpwrvgnd_1
XFILLER_103_261 VGND VGND VPWR VPWR sky130_fd_sc_hd__decap_3
XFILLER_110_209 VGND VGND VPWR VPWR sky130_fd_sc_hd__decap_3
XFILLER_49_315 VGND VGND VPWR VPWR sky130_fd_sc_hd__decap_3
XFILLER_89_473 VGND VGND VPWR VPWR sky130_fd_sc_hd__decap_3
XFILLER_1_388 VGND VGND VPWR VPWR sky130_fd_sc_hd__decap_3
XFILLER_77_635 VGND VGND VPWR VPWR sky130_fd_sc_hd__decap_3
XFILLER_76_156 VGND VGND VPWR VPWR sky130_fd_sc_hd__decap_3
XFILLER_92_605 VGND VGND VPWR VPWR sky130_fd_sc_hd__decap_3
XFILLER_17_212 VGND VGND VPWR VPWR sky130_fd_sc_hd__decap_3
XFILLER_18_724 VGND VGND VPWR VPWR sky130_fd_sc_hd__fill_1
XFILLER_57_370 VGND VGND VPWR VPWR sky130_fd_sc_hd__decap_3
XFILLER_57_381 VGND VGND VPWR VPWR sky130_fd_sc_hd__decap_3
XFILLER_64_318 VGND VGND VPWR VPWR sky130_fd_sc_hd__decap_3
XFILLER_94_66 VGND VGND VPWR VPWR sky130_fd_sc_hd__decap_3
XFILLER_17_223 VGND VGND VPWR VPWR sky130_fd_sc_hd__fill_1
XFILLER_17_234 VGND VGND VPWR VPWR sky130_fd_sc_hd__decap_3
XFILLER_45_532 VGND VGND VPWR VPWR sky130_fd_sc_hd__decap_3
XFILLER_91_137 VGND VGND VPWR VPWR sky130_fd_sc_hd__decap_3
XFILLER_91_159 VGND VGND VPWR VPWR sky130_fd_sc_hd__decap_3
XFILLER_17_278 VGND VGND VPWR VPWR sky130_fd_sc_hd__fill_2
XFILLER_27_82 VGND VGND VPWR VPWR sky130_fd_sc_hd__decap_3
XFILLER_60_502 VGND VGND VPWR VPWR sky130_fd_sc_hd__decap_3
XFILLER_72_351 VGND VGND VPWR VPWR sky130_fd_sc_hd__decap_3
Xclkbuf_2_0__f_clk clkbuf_0_clk/X VGND VGND VPWR VPWR clkload0/A sky130_fd_sc_hd__clkbuf_16
XTAP_TAPCELL_ROW_82_1319 VGND VPWR sky130_fd_sc_hd__tapvpwrvgnd_1
XFILLER_60_546 VGND VGND VPWR VPWR sky130_fd_sc_hd__decap_3
XFILLER_60_568 VGND VGND VPWR VPWR sky130_fd_sc_hd__fill_1
XFILLER_60_579 VGND VGND VPWR VPWR sky130_fd_sc_hd__decap_3
XTAP_TAPCELL_ROW_15_457 VGND VPWR sky130_fd_sc_hd__tapvpwrvgnd_1
XFILLER_13_484 VGND VGND VPWR VPWR sky130_fd_sc_hd__decap_3
XFILLER_9_422 VGND VGND VPWR VPWR sky130_fd_sc_hd__decap_3
XFILLER_5_650 VGND VGND VPWR VPWR sky130_fd_sc_hd__decap_3
XFILLER_114_515 VGND VGND VPWR VPWR sky130_fd_sc_hd__fill_2
XFILLER_5_661 VGND VGND VPWR VPWR sky130_fd_sc_hd__decap_3
XFILLER_99_215 VGND VGND VPWR VPWR sky130_fd_sc_hd__decap_3
XFILLER_99_248 VGND VGND VPWR VPWR sky130_fd_sc_hd__decap_3
X_4230_ _7898_/B _4230_/B VGND VGND VPWR VPWR _4231_/A sky130_fd_sc_hd__and2_2
XFILLER_68_613 VGND VGND VPWR VPWR sky130_fd_sc_hd__decap_3
X_4161_ _4161_/A VGND VGND VPWR VPWR _8018_/D sky130_fd_sc_hd__buf_1
XFILLER_4_97 VGND VGND VPWR VPWR sky130_fd_sc_hd__decap_3
XFILLER_95_432 VGND VGND VPWR VPWR sky130_fd_sc_hd__decap_3
XFILLER_68_679 VGND VGND VPWR VPWR sky130_fd_sc_hd__decap_3
X_4092_ _7930_/B _8387_/Q VGND VGND VPWR VPWR _4093_/A sky130_fd_sc_hd__and2_2
XFILLER_83_649 VGND VGND VPWR VPWR sky130_fd_sc_hd__decap_3
X_7920_ _8330_/Q _7930_/B VGND VGND VPWR VPWR _7921_/A sky130_fd_sc_hd__and2_2
XFILLER_36_543 VGND VGND VPWR VPWR sky130_fd_sc_hd__decap_3
XFILLER_48_381 VGND VGND VPWR VPWR sky130_fd_sc_hd__decap_3
XFILLER_63_340 VGND VGND VPWR VPWR sky130_fd_sc_hd__decap_3
XFILLER_76_690 VGND VGND VPWR VPWR sky130_fd_sc_hd__decap_3
XFILLER_82_137 VGND VGND VPWR VPWR sky130_fd_sc_hd__decap_3
X_7851_ _7851_/A VGND VGND VPWR VPWR _8362_/D sky130_fd_sc_hd__buf_1
XFILLER_23_204 VGND VGND VPWR VPWR sky130_fd_sc_hd__decap_3
XFILLER_63_373 VGND VGND VPWR VPWR sky130_fd_sc_hd__decap_3
X_6802_ _6874_/A _6811_/B _6802_/C VGND VGND VPWR VPWR _6804_/B sky130_fd_sc_hd__and3_2
XTAP_TAPCELL_ROW_34_700 VGND VPWR sky130_fd_sc_hd__tapvpwrvgnd_1
XFILLER_36_598 VGND VGND VPWR VPWR sky130_fd_sc_hd__decap_3
XFILLER_90_192 VGND VGND VPWR VPWR sky130_fd_sc_hd__decap_3
X_7782_ _7783_/A _7778_/X _7781_/X VGND VGND VPWR VPWR _7782_/Y sky130_fd_sc_hd__a21oi_2
X_4994_ _8285_/Q _4994_/B VGND VGND VPWR VPWR _4994_/X sky130_fd_sc_hd__or2_2
X_6733_ _6726_/B _6726_/A _6726_/C _6698_/X VGND VGND VPWR VPWR _6733_/X sky130_fd_sc_hd__a31o_4
XTAP_TAPCELL_ROW_102_1588 VGND VPWR sky130_fd_sc_hd__tapvpwrvgnd_1
X_6664_ _7121_/A _6664_/B VGND VGND VPWR VPWR _8327_/D sky130_fd_sc_hd__nor2_2
XFILLER_31_281 VGND VGND VPWR VPWR sky130_fd_sc_hd__decap_3
X_8403_ _8403_/A VGND VGND VPWR VPWR _8403_/X sky130_fd_sc_hd__buf_2
X_5615_ _5615_/A VGND VGND VPWR VPWR _6494_/A sky130_fd_sc_hd__buf_1
X_6595_ _4857_/B _6596_/A2 _8252_/Q _8188_/Q VGND VGND VPWR VPWR _6595_/X sky130_fd_sc_hd__o211a_2
X_8334_ _8401_/CLK _8334_/D VGND VGND VPWR VPWR _8334_/Q sky130_fd_sc_hd__dfxtp_2
X_5546_ _8290_/Q _5543_/X _5545_/X _5488_/X VGND VGND VPWR VPWR _5556_/B sky130_fd_sc_hd__a22o_2
XTAP_TAPCELL_ROW_57_1001 VGND VPWR sky130_fd_sc_hd__tapvpwrvgnd_1
X_8265_ _8401_/CLK _8265_/D VGND VGND VPWR VPWR _8265_/Q sky130_fd_sc_hd__dfxtp_2
X_5477_ _5477_/A VGND VGND VPWR VPWR _5477_/X sky130_fd_sc_hd__buf_1
X_7216_ _8208_/Q _8272_/Q _7190_/Y _7179_/X VGND VGND VPWR VPWR _7216_/X sky130_fd_sc_hd__a211o_4
X_4428_ _7843_/A _4428_/B VGND VGND VPWR VPWR _4429_/A sky130_fd_sc_hd__and2_2
XFILLER_59_602 VGND VGND VPWR VPWR sky130_fd_sc_hd__fill_1
X_8196_ _8199_/CLK _8196_/D VGND VGND VPWR VPWR _8196_/Q sky130_fd_sc_hd__dfxtp_2
XFILLER_101_732 VGND VGND VPWR VPWR sky130_fd_sc_hd__fill_1
XFILLER_48_26 VGND VGND VPWR VPWR sky130_fd_sc_hd__fill_2
XFILLER_86_410 VGND VGND VPWR VPWR sky130_fd_sc_hd__fill_1
XFILLER_86_421 VGND VGND VPWR VPWR sky130_fd_sc_hd__decap_3
XFILLER_98_281 VGND VGND VPWR VPWR sky130_fd_sc_hd__decap_3
X_7147_ _8270_/Q _7145_/Y _7146_/Y VGND VGND VPWR VPWR _7147_/X sky130_fd_sc_hd__a21o_2
X_4359_ _4359_/A VGND VGND VPWR VPWR _8117_/D sky130_fd_sc_hd__buf_1
XFILLER_100_242 VGND VGND VPWR VPWR sky130_fd_sc_hd__decap_3
XFILLER_100_253 VGND VGND VPWR VPWR sky130_fd_sc_hd__decap_3
XFILLER_58_134 VGND VGND VPWR VPWR sky130_fd_sc_hd__decap_3
XFILLER_59_668 VGND VGND VPWR VPWR sky130_fd_sc_hd__decap_3
XFILLER_59_679 VGND VGND VPWR VPWR sky130_fd_sc_hd__decap_3
XFILLER_86_454 VGND VGND VPWR VPWR sky130_fd_sc_hd__fill_1
X_7078_ _7078_/A _7078_/B VGND VGND VPWR VPWR _7078_/Y sky130_fd_sc_hd__nand2_2
XFILLER_27_510 VGND VGND VPWR VPWR sky130_fd_sc_hd__decap_3
XFILLER_46_318 VGND VGND VPWR VPWR sky130_fd_sc_hd__decap_3
XFILLER_58_167 VGND VGND VPWR VPWR sky130_fd_sc_hd__fill_2
XFILLER_58_178 VGND VGND VPWR VPWR sky130_fd_sc_hd__decap_3
X_6029_ _6027_/Y _6028_/X _6097_/A VGND VGND VPWR VPWR _6029_/X sky130_fd_sc_hd__mux2_2
XFILLER_27_532 VGND VGND VPWR VPWR sky130_fd_sc_hd__decap_3
XFILLER_73_137 VGND VGND VPWR VPWR sky130_fd_sc_hd__decap_3
XTAP_TAPCELL_ROW_68_1141 VGND VPWR sky130_fd_sc_hd__tapvpwrvgnd_1
XFILLER_27_576 VGND VGND VPWR VPWR sky130_fd_sc_hd__fill_2
XFILLER_54_362 VGND VGND VPWR VPWR sky130_fd_sc_hd__fill_2
XFILLER_64_47 VGND VGND VPWR VPWR sky130_fd_sc_hd__decap_3
XFILLER_82_660 VGND VGND VPWR VPWR sky130_fd_sc_hd__fill_2
XFILLER_82_682 VGND VGND VPWR VPWR sky130_fd_sc_hd__decap_3
XFILLER_14_237 VGND VGND VPWR VPWR sky130_fd_sc_hd__decap_3
XFILLER_27_598 VGND VGND VPWR VPWR sky130_fd_sc_hd__decap_3
XFILLER_42_524 VGND VGND VPWR VPWR sky130_fd_sc_hd__decap_3
XFILLER_42_546 VGND VGND VPWR VPWR sky130_fd_sc_hd__decap_3
XFILLER_81_181 VGND VGND VPWR VPWR sky130_fd_sc_hd__decap_3
XFILLER_80_35 VGND VGND VPWR VPWR sky130_fd_sc_hd__decap_3
XTAP_TAPCELL_ROW_12_416 VGND VPWR sky130_fd_sc_hd__tapvpwrvgnd_1
XFILLER_10_421 VGND VGND VPWR VPWR sky130_fd_sc_hd__decap_3
XFILLER_22_281 VGND VGND VPWR VPWR sky130_fd_sc_hd__decap_3
XFILLER_6_436 VGND VGND VPWR VPWR sky130_fd_sc_hd__decap_3
XFILLER_6_458 VGND VGND VPWR VPWR sky130_fd_sc_hd__fill_2
XFILLER_108_375 VGND VGND VPWR VPWR sky130_fd_sc_hd__decap_3
XTAP_TAPCELL_ROW_79_1292 VGND VPWR sky130_fd_sc_hd__tapvpwrvgnd_1
XTAP_TAPCELL_ROW_79_1281 VGND VPWR sky130_fd_sc_hd__tapvpwrvgnd_1
XFILLER_1_130 VGND VGND VPWR VPWR sky130_fd_sc_hd__decap_3
XFILLER_96_218 VGND VGND VPWR VPWR sky130_fd_sc_hd__decap_3
XFILLER_29_9 VGND VGND VPWR VPWR sky130_fd_sc_hd__decap_3
XFILLER_49_101 VGND VGND VPWR VPWR sky130_fd_sc_hd__decap_3
XFILLER_77_410 VGND VGND VPWR VPWR sky130_fd_sc_hd__decap_3
XFILLER_18_510 VGND VGND VPWR VPWR sky130_fd_sc_hd__decap_3
XFILLER_37_318 VGND VGND VPWR VPWR sky130_fd_sc_hd__decap_3
XFILLER_38_70 VGND VGND VPWR VPWR sky130_fd_sc_hd__decap_3
XFILLER_49_178 VGND VGND VPWR VPWR sky130_fd_sc_hd__decap_3
XFILLER_65_638 VGND VGND VPWR VPWR sky130_fd_sc_hd__decap_3
XFILLER_77_498 VGND VGND VPWR VPWR sky130_fd_sc_hd__decap_3
XFILLER_92_413 VGND VGND VPWR VPWR sky130_fd_sc_hd__decap_3
XFILLER_92_424 VGND VGND VPWR VPWR sky130_fd_sc_hd__decap_3
XFILLER_64_137 VGND VGND VPWR VPWR sky130_fd_sc_hd__decap_3
XFILLER_64_159 VGND VGND VPWR VPWR sky130_fd_sc_hd__decap_3
XFILLER_18_598 VGND VGND VPWR VPWR sky130_fd_sc_hd__decap_3
XFILLER_72_181 VGND VGND VPWR VPWR sky130_fd_sc_hd__decap_3
XFILLER_73_682 VGND VGND VPWR VPWR sky130_fd_sc_hd__decap_3
XFILLER_73_693 VGND VGND VPWR VPWR sky130_fd_sc_hd__fill_1
XFILLER_54_80 VGND VGND VPWR VPWR sky130_fd_sc_hd__decap_3
XFILLER_60_343 VGND VGND VPWR VPWR sky130_fd_sc_hd__fill_2
XFILLER_20_218 VGND VGND VPWR VPWR sky130_fd_sc_hd__decap_3
XFILLER_13_281 VGND VGND VPWR VPWR sky130_fd_sc_hd__fill_2
XFILLER_9_241 VGND VGND VPWR VPWR sky130_fd_sc_hd__decap_3
XFILLER_9_263 VGND VGND VPWR VPWR sky130_fd_sc_hd__decap_3
Xclkload11 _8199_/CLK VGND VGND VPWR VPWR clkload11/X sky130_fd_sc_hd__clkbuf_8
Xclkload22 _8388_/CLK VGND VGND VPWR VPWR clkload22/X sky130_fd_sc_hd__clkbuf_8
Xclkload33 _8401_/CLK VGND VGND VPWR VPWR clkload33/X sky130_fd_sc_hd__clkbuf_8
X_6380_ _8186_/Q _8185_/Q _6380_/S VGND VGND VPWR VPWR _6380_/X sky130_fd_sc_hd__mux2_2
X_5400_ _5400_/A VGND VGND VPWR VPWR _5400_/X sky130_fd_sc_hd__clkbuf_1
X_5331_ _5402_/A VGND VGND VPWR VPWR _5332_/A sky130_fd_sc_hd__buf_1
XFILLER_5_480 VGND VGND VPWR VPWR sky130_fd_sc_hd__decap_3
X_8050_ _8224_/CLK _8050_/D VGND VGND VPWR VPWR _8050_/Q sky130_fd_sc_hd__dfxtp_2
X_7001_ _8268_/Q _5398_/A _5338_/A VGND VGND VPWR VPWR _7001_/Y sky130_fd_sc_hd__o21ai_2
X_5262_ _5258_/X _5261_/X _6706_/S VGND VGND VPWR VPWR _5262_/X sky130_fd_sc_hd__mux2_2
XFILLER_102_529 VGND VGND VPWR VPWR sky130_fd_sc_hd__decap_3
XFILLER_68_421 VGND VGND VPWR VPWR sky130_fd_sc_hd__decap_3
X_5193_ _5966_/A VGND VGND VPWR VPWR _5193_/X sky130_fd_sc_hd__clkbuf_1
X_4213_ _4213_/A VGND VGND VPWR VPWR _8044_/D sky130_fd_sc_hd__buf_1
XFILLER_110_551 VGND VGND VPWR VPWR sky130_fd_sc_hd__decap_3
XFILLER_68_454 VGND VGND VPWR VPWR sky130_fd_sc_hd__decap_3
XFILLER_95_251 VGND VGND VPWR VPWR sky130_fd_sc_hd__decap_3
X_4144_ _7930_/B _7942_/Q VGND VGND VPWR VPWR _4145_/A sky130_fd_sc_hd__and2_2
XFILLER_110_562 VGND VGND VPWR VPWR sky130_fd_sc_hd__decap_3
XFILLER_68_498 VGND VGND VPWR VPWR sky130_fd_sc_hd__decap_3
XFILLER_110_595 VGND VGND VPWR VPWR sky130_fd_sc_hd__fill_1
X_4075_ _4075_/A VGND VGND VPWR VPWR _7975_/D sky130_fd_sc_hd__buf_1
XFILLER_36_351 VGND VGND VPWR VPWR sky130_fd_sc_hd__decap_3
XFILLER_64_660 VGND VGND VPWR VPWR sky130_fd_sc_hd__decap_3
XFILLER_83_479 VGND VGND VPWR VPWR sky130_fd_sc_hd__decap_3
XTAP_TAPCELL_ROW_104_1606 VGND VPWR sky130_fd_sc_hd__tapvpwrvgnd_1
X_7903_ _7903_/A VGND VGND VPWR VPWR _8388_/D sky130_fd_sc_hd__buf_1
XFILLER_34_17 VGND VGND VPWR VPWR sky130_fd_sc_hd__decap_3
XFILLER_70_129 VGND VGND VPWR VPWR sky130_fd_sc_hd__fill_2
XTAP_TAPCELL_ROW_104_1617 VGND VPWR sky130_fd_sc_hd__tapvpwrvgnd_1
X_7834_ _7834_/A1 _7638_/Y _7838_/C _7833_/Y _5507_/X VGND VGND VPWR VPWR _7834_/X
+ sky130_fd_sc_hd__a311o_2
XFILLER_51_343 VGND VGND VPWR VPWR sky130_fd_sc_hd__fill_1
X_7765_ _7765_/A _8205_/Q _7820_/B VGND VGND VPWR VPWR _7765_/X sky130_fd_sc_hd__and3_2
XFILLER_11_218 VGND VGND VPWR VPWR sky130_fd_sc_hd__decap_3
X_6716_ _5615_/A _6771_/C _7067_/A _5319_/A VGND VGND VPWR VPWR _6716_/X sky130_fd_sc_hd__a22o_2
X_4977_ _8274_/Q _4976_/A _7233_/S VGND VGND VPWR VPWR _4977_/Y sky130_fd_sc_hd__a21oi_2
X_7696_ _7776_/A _8186_/Q VGND VGND VPWR VPWR _7696_/Y sky130_fd_sc_hd__nand2_2
Xclkload5 clkload5/A VGND VGND VPWR VPWR clkload5/X sky130_fd_sc_hd__clkbuf_8
XTAP_TAPCELL_ROW_63_1082 VGND VPWR sky130_fd_sc_hd__tapvpwrvgnd_1
XFILLER_109_128 VGND VGND VPWR VPWR sky130_fd_sc_hd__decap_3
X_6647_ _6646_/X _6505_/X _7670_/A VGND VGND VPWR VPWR _6647_/X sky130_fd_sc_hd__mux2_2
X_6578_ _8190_/Q _8191_/Q _6578_/C VGND VGND VPWR VPWR _6578_/X sky130_fd_sc_hd__or3_4
X_8317_ _8386_/CLK _8317_/D VGND VGND VPWR VPWR _8317_/Q sky130_fd_sc_hd__dfxtp_2
X_5529_ _8165_/Q VGND VGND VPWR VPWR _5584_/A sky130_fd_sc_hd__inv_2
XFILLER_105_323 VGND VGND VPWR VPWR sky130_fd_sc_hd__decap_3
XFILLER_3_439 VGND VGND VPWR VPWR sky130_fd_sc_hd__decap_3
XTAP_TAPCELL_ROW_115_1757 VGND VPWR sky130_fd_sc_hd__tapvpwrvgnd_1
XFILLER_78_218 VGND VGND VPWR VPWR sky130_fd_sc_hd__decap_3
X_8248_ _8386_/CLK _8248_/D VGND VGND VPWR VPWR _8248_/Q sky130_fd_sc_hd__dfxtp_2
X_8179_ _8187_/CLK _8179_/D VGND VGND VPWR VPWR _8179_/Q sky130_fd_sc_hd__dfxtp_2
XFILLER_115_42 VGND VGND VPWR VPWR sky130_fd_sc_hd__decap_3
XFILLER_59_432 VGND VGND VPWR VPWR sky130_fd_sc_hd__decap_3
XFILLER_19_307 VGND VGND VPWR VPWR sky130_fd_sc_hd__decap_3
XFILLER_19_329 VGND VGND VPWR VPWR sky130_fd_sc_hd__decap_3
XFILLER_46_104 VGND VGND VPWR VPWR sky130_fd_sc_hd__decap_3
XFILLER_59_487 VGND VGND VPWR VPWR sky130_fd_sc_hd__decap_3
XFILLER_59_498 VGND VGND VPWR VPWR sky130_fd_sc_hd__decap_3
XFILLER_74_424 VGND VGND VPWR VPWR sky130_fd_sc_hd__decap_3
XFILLER_75_46 VGND VGND VPWR VPWR sky130_fd_sc_hd__decap_3
XFILLER_86_251 VGND VGND VPWR VPWR sky130_fd_sc_hd__fill_1
XFILLER_46_126 VGND VGND VPWR VPWR sky130_fd_sc_hd__decap_3
XFILLER_27_340 VGND VGND VPWR VPWR sky130_fd_sc_hd__decap_3
XFILLER_46_159 VGND VGND VPWR VPWR sky130_fd_sc_hd__decap_3
XFILLER_55_671 VGND VGND VPWR VPWR sky130_fd_sc_hd__fill_1
XFILLER_15_535 VGND VGND VPWR VPWR sky130_fd_sc_hd__decap_3
XFILLER_27_373 VGND VGND VPWR VPWR sky130_fd_sc_hd__decap_3
XTAP_TAPCELL_ROW_45_839 VGND VPWR sky130_fd_sc_hd__tapvpwrvgnd_1
XFILLER_42_354 VGND VGND VPWR VPWR sky130_fd_sc_hd__decap_3
XFILLER_54_192 VGND VGND VPWR VPWR sky130_fd_sc_hd__decap_3
XFILLER_30_516 VGND VGND VPWR VPWR sky130_fd_sc_hd__decap_3
XFILLER_42_376 VGND VGND VPWR VPWR sky130_fd_sc_hd__decap_3
XFILLER_91_89 VGND VGND VPWR VPWR sky130_fd_sc_hd__decap_3
XTAP_TAPCELL_ROW_25_585 VGND VPWR sky130_fd_sc_hd__tapvpwrvgnd_1
XFILLER_6_244 VGND VGND VPWR VPWR sky130_fd_sc_hd__decap_3
XFILLER_108_150 VGND VGND VPWR VPWR sky130_fd_sc_hd__decap_3
XFILLER_109_673 VGND VGND VPWR VPWR sky130_fd_sc_hd__decap_3
XFILLER_6_299 VGND VGND VPWR VPWR sky130_fd_sc_hd__decap_3
XFILLER_97_505 VGND VGND VPWR VPWR sky130_fd_sc_hd__decap_3
XTAP_TAPCELL_ROW_90_1429 VGND VPWR sky130_fd_sc_hd__tapvpwrvgnd_1
XFILLER_111_315 VGND VGND VPWR VPWR sky130_fd_sc_hd__decap_3
XFILLER_97_549 VGND VGND VPWR VPWR sky130_fd_sc_hd__decap_3
Xsplit1067 _8288_/Q VGND VGND VPWR VPWR _6999_/A1 sky130_fd_sc_hd__buf_12
XFILLER_27_6 VGND VGND VPWR VPWR sky130_fd_sc_hd__fill_1
XFILLER_65_402 VGND VGND VPWR VPWR sky130_fd_sc_hd__decap_3
XFILLER_77_273 VGND VGND VPWR VPWR sky130_fd_sc_hd__decap_3
XFILLER_65_435 VGND VGND VPWR VPWR sky130_fd_sc_hd__decap_3
XFILLER_65_457 VGND VGND VPWR VPWR sky130_fd_sc_hd__decap_3
XFILLER_77_284 VGND VGND VPWR VPWR sky130_fd_sc_hd__decap_3
XFILLER_92_243 VGND VGND VPWR VPWR sky130_fd_sc_hd__decap_3
XFILLER_18_395 VGND VGND VPWR VPWR sky130_fd_sc_hd__fill_1
XFILLER_33_321 VGND VGND VPWR VPWR sky130_fd_sc_hd__decap_3
XFILLER_46_693 VGND VGND VPWR VPWR sky130_fd_sc_hd__decap_3
XFILLER_52_118 VGND VGND VPWR VPWR sky130_fd_sc_hd__decap_3
XFILLER_65_90 VGND VGND VPWR VPWR sky130_fd_sc_hd__decap_3
XFILLER_80_427 VGND VGND VPWR VPWR sky130_fd_sc_hd__decap_3
XFILLER_80_449 VGND VGND VPWR VPWR sky130_fd_sc_hd__decap_3
XFILLER_92_298 VGND VGND VPWR VPWR sky130_fd_sc_hd__decap_3
X_5880_ _8236_/Q _5876_/B _8172_/Q VGND VGND VPWR VPWR _5880_/X sky130_fd_sc_hd__o21a_2
X_4900_ _6400_/C _4900_/B VGND VGND VPWR VPWR _6297_/D sky130_fd_sc_hd__nand2_2
XFILLER_33_343 VGND VGND VPWR VPWR sky130_fd_sc_hd__decap_3
XFILLER_61_641 VGND VGND VPWR VPWR sky130_fd_sc_hd__decap_3
XFILLER_61_663 VGND VGND VPWR VPWR sky130_fd_sc_hd__decap_3
X_4831_ _6956_/D _6846_/B VGND VGND VPWR VPWR _6874_/B sky130_fd_sc_hd__or2_2
XFILLER_21_505 VGND VGND VPWR VPWR sky130_fd_sc_hd__decap_3
XFILLER_21_527 VGND VGND VPWR VPWR sky130_fd_sc_hd__decap_3
XFILLER_33_376 VGND VGND VPWR VPWR sky130_fd_sc_hd__decap_3
XFILLER_60_162 VGND VGND VPWR VPWR sky130_fd_sc_hd__decap_3
XFILLER_61_685 VGND VGND VPWR VPWR sky130_fd_sc_hd__decap_3
XFILLER_60_195 VGND VGND VPWR VPWR sky130_fd_sc_hd__fill_1
X_7550_ _8221_/Q _8285_/Q VGND VGND VPWR VPWR _7579_/C sky130_fd_sc_hd__or2_2
X_4762_ _4762_/A _8276_/Q VGND VGND VPWR VPWR _4980_/B sky130_fd_sc_hd__nor2_2
XFILLER_119_415 VGND VGND VPWR VPWR sky130_fd_sc_hd__decap_3
X_7481_ _8229_/Q _7480_/X _6011_/X VGND VGND VPWR VPWR _7481_/Y sky130_fd_sc_hd__o21ai_2
X_6501_ _6462_/A _7694_/B _6500_/Y _5332_/A _6561_/B VGND VGND VPWR VPWR _6501_/X
+ sky130_fd_sc_hd__a32o_2
X_4693_ _4693_/A VGND VGND VPWR VPWR _8284_/D sky130_fd_sc_hd__buf_1
X_6432_ _7475_/A _6550_/A VGND VGND VPWR VPWR _6434_/A sky130_fd_sc_hd__or2_4
XFILLER_106_109 VGND VGND VPWR VPWR sky130_fd_sc_hd__decap_3
X_8102_ clkload5/A _8102_/D VGND VGND VPWR VPWR _8102_/Q sky130_fd_sc_hd__dfxtp_2
X_6363_ _6624_/A _6359_/X _6360_/X _6362_/X _5433_/A VGND VGND VPWR VPWR _6363_/X
+ sky130_fd_sc_hd__a32o_2
XFILLER_114_153 VGND VGND VPWR VPWR sky130_fd_sc_hd__decap_3
XFILLER_115_676 VGND VGND VPWR VPWR sky130_fd_sc_hd__decap_3
X_6294_ _4890_/B _8246_/Q _8245_/Q _8181_/Q VGND VGND VPWR VPWR _6294_/X sky130_fd_sc_hd__a211o_2
X_5314_ _5430_/B _5310_/A VGND VGND VPWR VPWR _5314_/X sky130_fd_sc_hd__or2b_4
XFILLER_102_315 VGND VGND VPWR VPWR sky130_fd_sc_hd__decap_3
X_8033_ clkload9/A _8033_/D VGND VGND VPWR VPWR _8033_/Q sky130_fd_sc_hd__dfxtp_2
X_5245_ _5528_/A _7747_/A VGND VGND VPWR VPWR _5245_/Y sky130_fd_sc_hd__nor2_2
XFILLER_102_359 VGND VGND VPWR VPWR sky130_fd_sc_hd__decap_3
XFILLER_114_197 VGND VGND VPWR VPWR sky130_fd_sc_hd__decap_3
XFILLER_29_39 VGND VGND VPWR VPWR sky130_fd_sc_hd__fill_2
XFILLER_56_413 VGND VGND VPWR VPWR sky130_fd_sc_hd__decap_3
XFILLER_68_251 VGND VGND VPWR VPWR sky130_fd_sc_hd__fill_1
XFILLER_96_571 VGND VGND VPWR VPWR sky130_fd_sc_hd__fill_1
XFILLER_96_582 VGND VGND VPWR VPWR sky130_fd_sc_hd__decap_3
XTAP_TAPCELL_ROW_110_1687 VGND VPWR sky130_fd_sc_hd__tapvpwrvgnd_1
X_5176_ _8164_/Q _8165_/Q _8166_/Q _7809_/A1 _7805_/A _7783_/A VGND VGND VPWR VPWR
+ _5176_/X sky130_fd_sc_hd__mux4_2
XFILLER_28_115 VGND VGND VPWR VPWR sky130_fd_sc_hd__decap_3
XFILLER_56_424 VGND VGND VPWR VPWR sky130_fd_sc_hd__decap_3
XFILLER_68_284 VGND VGND VPWR VPWR sky130_fd_sc_hd__decap_3
X_4127_ _4127_/A VGND VGND VPWR VPWR _8001_/D sky130_fd_sc_hd__buf_1
XFILLER_71_405 VGND VGND VPWR VPWR sky130_fd_sc_hd__decap_3
XFILLER_83_265 VGND VGND VPWR VPWR sky130_fd_sc_hd__decap_3
XPHY_EDGE_ROW_119_Left_239 VGND VGND VPWR VPWR sky130_fd_sc_hd__decap_3
X_4058_ _7930_/B _8370_/Q VGND VGND VPWR VPWR _4059_/A sky130_fd_sc_hd__and2_2
XFILLER_37_682 VGND VGND VPWR VPWR sky130_fd_sc_hd__decap_3
XFILLER_71_449 VGND VGND VPWR VPWR sky130_fd_sc_hd__decap_3
XTAP_TAPCELL_ROW_65_1100 VGND VPWR sky130_fd_sc_hd__tapvpwrvgnd_1
XFILLER_101_11 VGND VGND VPWR VPWR sky130_fd_sc_hd__decap_3
XFILLER_101_33 VGND VGND VPWR VPWR sky130_fd_sc_hd__fill_2
XFILLER_36_181 VGND VGND VPWR VPWR sky130_fd_sc_hd__decap_3
XFILLER_52_652 VGND VGND VPWR VPWR sky130_fd_sc_hd__decap_3
XTAP_TAPCELL_ROW_42_809 VGND VPWR sky130_fd_sc_hd__tapvpwrvgnd_1
XFILLER_101_66 VGND VGND VPWR VPWR sky130_fd_sc_hd__decap_3
XFILLER_12_516 VGND VGND VPWR VPWR sky130_fd_sc_hd__decap_3
XFILLER_24_365 VGND VGND VPWR VPWR sky130_fd_sc_hd__decap_3
XFILLER_51_140 VGND VGND VPWR VPWR sky130_fd_sc_hd__decap_3
XFILLER_52_696 VGND VGND VPWR VPWR sky130_fd_sc_hd__decap_3
X_7817_ _8163_/Q _7660_/A _7664_/X VGND VGND VPWR VPWR _7817_/Y sky130_fd_sc_hd__o21ai_2
XFILLER_101_99 VGND VGND VPWR VPWR sky130_fd_sc_hd__fill_1
X_7748_ _7706_/X _7744_/X _7824_/S VGND VGND VPWR VPWR _7748_/X sky130_fd_sc_hd__mux2_2
X_7679_ _8223_/Q _7663_/B _7660_/X VGND VGND VPWR VPWR _7679_/Y sky130_fd_sc_hd__o21ai_2
XTAP_TAPCELL_ROW_22_544 VGND VPWR sky130_fd_sc_hd__tapvpwrvgnd_1
XFILLER_20_582 VGND VGND VPWR VPWR sky130_fd_sc_hd__decap_3
XFILLER_3_225 VGND VGND VPWR VPWR sky130_fd_sc_hd__fill_2
XTAP_TAPCELL_ROW_76_1251 VGND VPWR sky130_fd_sc_hd__tapvpwrvgnd_1
XFILLER_10_52 VGND VGND VPWR VPWR sky130_fd_sc_hd__fill_1
XFILLER_105_175 VGND VGND VPWR VPWR sky130_fd_sc_hd__decap_3
XFILLER_10_74 VGND VGND VPWR VPWR sky130_fd_sc_hd__decap_3
XFILLER_10_85 VGND VGND VPWR VPWR sky130_fd_sc_hd__fill_2
XFILLER_10_96 VGND VGND VPWR VPWR sky130_fd_sc_hd__decap_3
XFILLER_79_549 VGND VGND VPWR VPWR sky130_fd_sc_hd__decap_3
XFILLER_86_23 VGND VGND VPWR VPWR sky130_fd_sc_hd__decap_3
XFILLER_86_45 VGND VGND VPWR VPWR sky130_fd_sc_hd__decap_3
XFILLER_47_402 VGND VGND VPWR VPWR sky130_fd_sc_hd__decap_3
XFILLER_59_251 VGND VGND VPWR VPWR sky130_fd_sc_hd__decap_3
XFILLER_59_262 VGND VGND VPWR VPWR sky130_fd_sc_hd__decap_3
XFILLER_94_519 VGND VGND VPWR VPWR sky130_fd_sc_hd__decap_3
XFILLER_19_137 VGND VGND VPWR VPWR sky130_fd_sc_hd__decap_3
XFILLER_59_284 VGND VGND VPWR VPWR sky130_fd_sc_hd__decap_3
XFILLER_74_221 VGND VGND VPWR VPWR sky130_fd_sc_hd__decap_3
XFILLER_47_479 VGND VGND VPWR VPWR sky130_fd_sc_hd__fill_1
XFILLER_74_265 VGND VGND VPWR VPWR sky130_fd_sc_hd__decap_3
XFILLER_62_427 VGND VGND VPWR VPWR sky130_fd_sc_hd__decap_3
XFILLER_90_725 VGND VGND VPWR VPWR sky130_fd_sc_hd__decap_3
XTAP_TAPCELL_ROW_2_291 VGND VPWR sky130_fd_sc_hd__tapvpwrvgnd_1
XTAP_TAPCELL_ROW_2_280 VGND VPWR sky130_fd_sc_hd__tapvpwrvgnd_1
XFILLER_15_321 VGND VGND VPWR VPWR sky130_fd_sc_hd__decap_3
XFILLER_35_60 VGND VGND VPWR VPWR sky130_fd_sc_hd__decap_3
XFILLER_43_663 VGND VGND VPWR VPWR sky130_fd_sc_hd__fill_1
XTAP_TAPCELL_ROW_87_1391 VGND VPWR sky130_fd_sc_hd__tapvpwrvgnd_1
XFILLER_15_365 VGND VGND VPWR VPWR sky130_fd_sc_hd__decap_3
XFILLER_35_82 VGND VGND VPWR VPWR sky130_fd_sc_hd__decap_3
XFILLER_30_335 VGND VGND VPWR VPWR sky130_fd_sc_hd__decap_3
XFILLER_7_520 VGND VGND VPWR VPWR sky130_fd_sc_hd__decap_3
XFILLER_116_407 VGND VGND VPWR VPWR sky130_fd_sc_hd__decap_3
XFILLER_7_553 VGND VGND VPWR VPWR sky130_fd_sc_hd__decap_3
XFILLER_7_564 VGND VGND VPWR VPWR sky130_fd_sc_hd__decap_3
Xmax_cap217 _5433_/X VGND VGND VPWR VPWR _6220_/A sky130_fd_sc_hd__buf_4
Xmax_cap206 _6220_/X VGND VGND VPWR VPWR _7209_/A sky130_fd_sc_hd__buf_6
XFILLER_7_597 VGND VGND VPWR VPWR sky130_fd_sc_hd__decap_3
Xmax_cap228 _5268_/X VGND VGND VPWR VPWR _6708_/A sky130_fd_sc_hd__clkbuf_8
XFILLER_112_624 VGND VGND VPWR VPWR sky130_fd_sc_hd__fill_2
XFILLER_97_324 VGND VGND VPWR VPWR sky130_fd_sc_hd__decap_3
XFILLER_111_123 VGND VGND VPWR VPWR sky130_fd_sc_hd__decap_3
XFILLER_112_657 VGND VGND VPWR VPWR sky130_fd_sc_hd__decap_3
XFILLER_85_508 VGND VGND VPWR VPWR sky130_fd_sc_hd__decap_3
XFILLER_97_335 VGND VGND VPWR VPWR sky130_fd_sc_hd__fill_1
X_5030_ _5884_/B _5028_/Y _5891_/B1 VGND VGND VPWR VPWR _5030_/X sky130_fd_sc_hd__o21a_2
XFILLER_25_3 VGND VGND VPWR VPWR sky130_fd_sc_hd__decap_3
XFILLER_38_435 VGND VGND VPWR VPWR sky130_fd_sc_hd__decap_3
XFILLER_93_541 VGND VGND VPWR VPWR sky130_fd_sc_hd__decap_3
XFILLER_19_660 VGND VGND VPWR VPWR sky130_fd_sc_hd__decap_3
XFILLER_26_608 VGND VGND VPWR VPWR sky130_fd_sc_hd__decap_3
XFILLER_38_468 VGND VGND VPWR VPWR sky130_fd_sc_hd__decap_3
XFILLER_53_405 VGND VGND VPWR VPWR sky130_fd_sc_hd__decap_3
XFILLER_65_243 VGND VGND VPWR VPWR sky130_fd_sc_hd__decap_3
X_6981_ _5528_/A _5832_/X _6980_/Y _5827_/Y VGND VGND VPWR VPWR _6981_/X sky130_fd_sc_hd__a22o_2
XFILLER_19_682 VGND VGND VPWR VPWR sky130_fd_sc_hd__decap_3
XFILLER_53_438 VGND VGND VPWR VPWR sky130_fd_sc_hd__decap_3
XFILLER_65_287 VGND VGND VPWR VPWR sky130_fd_sc_hd__decap_3
XFILLER_93_585 VGND VGND VPWR VPWR sky130_fd_sc_hd__decap_3
X_5932_ _5846_/X _5906_/X _5905_/X VGND VGND VPWR VPWR _6302_/C sky130_fd_sc_hd__o21a_2
XFILLER_53_449 VGND VGND VPWR VPWR sky130_fd_sc_hd__decap_3
XFILLER_80_246 VGND VGND VPWR VPWR sky130_fd_sc_hd__decap_3
XFILLER_33_140 VGND VGND VPWR VPWR sky130_fd_sc_hd__decap_3
XFILLER_33_162 VGND VGND VPWR VPWR sky130_fd_sc_hd__decap_3
XFILLER_34_696 VGND VGND VPWR VPWR sky130_fd_sc_hd__decap_3
X_5863_ _7202_/A _5863_/B VGND VGND VPWR VPWR _5863_/Y sky130_fd_sc_hd__nand2_2
XFILLER_21_346 VGND VGND VPWR VPWR sky130_fd_sc_hd__decap_3
XFILLER_61_482 VGND VGND VPWR VPWR sky130_fd_sc_hd__decap_3
X_7602_ _8286_/Q _5296_/X _5626_/A _7601_/X _6687_/A VGND VGND VPWR VPWR _7602_/X
+ sky130_fd_sc_hd__a221o_2
X_5794_ _5788_/X _5791_/Y _5793_/X _5433_/A VGND VGND VPWR VPWR _5794_/X sky130_fd_sc_hd__a22o_2
X_4814_ _4814_/A _4814_/B VGND VGND VPWR VPWR _7076_/A sky130_fd_sc_hd__nand2_2
XFILLER_21_368 VGND VGND VPWR VPWR sky130_fd_sc_hd__decap_3
X_7533_ _8218_/Q _8219_/Q VGND VGND VPWR VPWR _7612_/C sky130_fd_sc_hd__nand2_2
X_4745_ _4745_/A VGND VGND VPWR VPWR _7437_/A sky130_fd_sc_hd__inv_2
XTAP_TAPCELL_ROW_60_1041 VGND VPWR sky130_fd_sc_hd__tapvpwrvgnd_1
XFILLER_107_429 VGND VGND VPWR VPWR sky130_fd_sc_hd__decap_3
X_7464_ _8218_/Q _8282_/Q _7619_/A VGND VGND VPWR VPWR _7464_/X sky130_fd_sc_hd__o21a_2
X_4676_ _7930_/B _8142_/Q VGND VGND VPWR VPWR _4677_/A sky130_fd_sc_hd__and2_2
X_7395_ _7393_/Y _7394_/X _5192_/A VGND VGND VPWR VPWR _7395_/X sky130_fd_sc_hd__a21o_2
X_6415_ _6769_/A _8187_/Q _6414_/Y _6121_/B _6563_/A VGND VGND VPWR VPWR _6415_/X
+ sky130_fd_sc_hd__a32o_2
XTAP_TAPCELL_ROW_112_1716 VGND VPWR sky130_fd_sc_hd__tapvpwrvgnd_1
X_6346_ _8185_/Q _8184_/Q _8183_/Q _7725_/B _5484_/S _7812_/A VGND VGND VPWR VPWR
+ _6346_/X sky130_fd_sc_hd__mux4_2
XFILLER_103_602 VGND VGND VPWR VPWR sky130_fd_sc_hd__decap_3
XFILLER_1_729 VGND VGND VPWR VPWR sky130_fd_sc_hd__decap_3
XFILLER_88_302 VGND VGND VPWR VPWR sky130_fd_sc_hd__decap_3
XFILLER_102_123 VGND VGND VPWR VPWR sky130_fd_sc_hd__fill_1
XFILLER_103_646 VGND VGND VPWR VPWR sky130_fd_sc_hd__fill_2
XFILLER_103_668 VGND VGND VPWR VPWR sky130_fd_sc_hd__decap_3
XFILLER_88_368 VGND VGND VPWR VPWR sky130_fd_sc_hd__fill_2
X_8016_ _8390_/CLK _8016_/D VGND VGND VPWR VPWR _8016_/Q sky130_fd_sc_hd__dfxtp_2
Xinput107 operand_b[43] VGND VGND VPWR VPWR _4390_/B sky130_fd_sc_hd__clkdlybuf4s25_1
Xinput118 operand_b[53] VGND VGND VPWR VPWR _4410_/B sky130_fd_sc_hd__clkdlybuf4s25_1
X_6277_ _6277_/A _6277_/B VGND VGND VPWR VPWR _6277_/Y sky130_fd_sc_hd__nor2_2
XFILLER_102_156 VGND VGND VPWR VPWR sky130_fd_sc_hd__decap_3
XFILLER_29_402 VGND VGND VPWR VPWR sky130_fd_sc_hd__decap_3
XFILLER_76_519 VGND VGND VPWR VPWR sky130_fd_sc_hd__decap_3
Xinput129 operand_b[63] VGND VGND VPWR VPWR _4430_/B sky130_fd_sc_hd__clkdlybuf4s25_1
X_5228_ _5224_/X _5227_/X _6706_/S VGND VGND VPWR VPWR _5228_/X sky130_fd_sc_hd__mux2_2
XTAP_TAPCELL_ROW_71_1181 VGND VPWR sky130_fd_sc_hd__tapvpwrvgnd_1
XFILLER_102_189 VGND VGND VPWR VPWR sky130_fd_sc_hd__decap_3
XFILLER_56_221 VGND VGND VPWR VPWR sky130_fd_sc_hd__decap_3
XFILLER_56_37 VGND VGND VPWR VPWR sky130_fd_sc_hd__decap_3
XFILLER_84_530 VGND VGND VPWR VPWR sky130_fd_sc_hd__fill_2
X_5159_ _5151_/X _5158_/X _6507_/S VGND VGND VPWR VPWR _5159_/X sky130_fd_sc_hd__mux2_2
XFILLER_29_479 VGND VGND VPWR VPWR sky130_fd_sc_hd__decap_3
XFILLER_84_563 VGND VGND VPWR VPWR sky130_fd_sc_hd__decap_3
XFILLER_44_416 VGND VGND VPWR VPWR sky130_fd_sc_hd__decap_3
XFILLER_44_427 VGND VGND VPWR VPWR sky130_fd_sc_hd__decap_3
XFILLER_56_276 VGND VGND VPWR VPWR sky130_fd_sc_hd__decap_3
XFILLER_56_298 VGND VGND VPWR VPWR sky130_fd_sc_hd__decap_3
XTAP_TAPCELL_ROW_27_614 VGND VPWR sky130_fd_sc_hd__tapvpwrvgnd_1
XFILLER_25_630 VGND VGND VPWR VPWR sky130_fd_sc_hd__decap_3
Xclkbuf_leaf_36_clk clkbuf_2_2__f_clk/X VGND VGND VPWR VPWR _8379_/CLK sky130_fd_sc_hd__clkbuf_8
XTAP_TAPCELL_ROW_55_978 VGND VPWR sky130_fd_sc_hd__tapvpwrvgnd_1
XFILLER_24_162 VGND VGND VPWR VPWR sky130_fd_sc_hd__decap_3
XFILLER_71_268 VGND VGND VPWR VPWR sky130_fd_sc_hd__decap_3
XFILLER_24_195 VGND VGND VPWR VPWR sky130_fd_sc_hd__fill_1
XFILLER_12_368 VGND VGND VPWR VPWR sky130_fd_sc_hd__decap_3
XFILLER_12_379 VGND VGND VPWR VPWR sky130_fd_sc_hd__decap_3
XFILLER_40_677 VGND VGND VPWR VPWR sky130_fd_sc_hd__fill_1
XFILLER_40_699 VGND VGND VPWR VPWR sky130_fd_sc_hd__fill_1
XFILLER_21_51 VGND VGND VPWR VPWR sky130_fd_sc_hd__decap_3
XFILLER_106_484 VGND VGND VPWR VPWR sky130_fd_sc_hd__decap_3
XFILLER_4_589 VGND VGND VPWR VPWR sky130_fd_sc_hd__fill_2
XFILLER_79_302 VGND VGND VPWR VPWR sky130_fd_sc_hd__decap_3
XFILLER_97_44 VGND VGND VPWR VPWR sky130_fd_sc_hd__decap_3
XFILLER_79_357 VGND VGND VPWR VPWR sky130_fd_sc_hd__decap_3
XTAP_TAPCELL_ROW_7_350 VGND VPWR sky130_fd_sc_hd__tapvpwrvgnd_1
XFILLER_94_338 VGND VGND VPWR VPWR sky130_fd_sc_hd__decap_3
XTAP_TAPCELL_ROW_89_1420 VGND VPWR sky130_fd_sc_hd__tapvpwrvgnd_1
XFILLER_35_405 VGND VGND VPWR VPWR sky130_fd_sc_hd__decap_3
XFILLER_75_541 VGND VGND VPWR VPWR sky130_fd_sc_hd__decap_3
XFILLER_35_438 VGND VGND VPWR VPWR sky130_fd_sc_hd__decap_3
XFILLER_90_511 VGND VGND VPWR VPWR sky130_fd_sc_hd__decap_3
XFILLER_90_533 VGND VGND VPWR VPWR sky130_fd_sc_hd__decap_3
XFILLER_16_630 VGND VGND VPWR VPWR sky130_fd_sc_hd__fill_1
XFILLER_28_490 VGND VGND VPWR VPWR sky130_fd_sc_hd__decap_3
XFILLER_35_449 VGND VGND VPWR VPWR sky130_fd_sc_hd__decap_3
XFILLER_46_92 VGND VGND VPWR VPWR sky130_fd_sc_hd__decap_3
XFILLER_62_246 VGND VGND VPWR VPWR sky130_fd_sc_hd__decap_3
Xclkbuf_leaf_27_clk clkbuf_2_2__f_clk/X VGND VGND VPWR VPWR _8322_/CLK sky130_fd_sc_hd__clkbuf_8
XFILLER_15_140 VGND VGND VPWR VPWR sky130_fd_sc_hd__decap_3
XFILLER_16_663 VGND VGND VPWR VPWR sky130_fd_sc_hd__decap_3
XFILLER_31_600 VGND VGND VPWR VPWR sky130_fd_sc_hd__decap_3
XFILLER_62_268 VGND VGND VPWR VPWR sky130_fd_sc_hd__decap_3
XFILLER_90_577 VGND VGND VPWR VPWR sky130_fd_sc_hd__fill_2
XFILLER_15_195 VGND VGND VPWR VPWR sky130_fd_sc_hd__decap_3
XFILLER_31_633 VGND VGND VPWR VPWR sky130_fd_sc_hd__fill_2
XFILLER_43_493 VGND VGND VPWR VPWR sky130_fd_sc_hd__decap_3
XFILLER_30_132 VGND VGND VPWR VPWR sky130_fd_sc_hd__decap_3
XFILLER_62_91 VGND VGND VPWR VPWR sky130_fd_sc_hd__decap_3
XFILLER_30_187 VGND VGND VPWR VPWR sky130_fd_sc_hd__decap_3
XFILLER_7_20 VGND VGND VPWR VPWR sky130_fd_sc_hd__decap_3
Xsplit split/A VGND VGND VPWR VPWR split/X sky130_fd_sc_hd__buf_6
XFILLER_11_390 VGND VGND VPWR VPWR sky130_fd_sc_hd__fill_2
XFILLER_7_53 VGND VGND VPWR VPWR sky130_fd_sc_hd__decap_3
X_4530_ _7898_/B _8069_/Q VGND VGND VPWR VPWR _4531_/A sky130_fd_sc_hd__and2_2
XFILLER_7_383 VGND VGND VPWR VPWR sky130_fd_sc_hd__decap_3
XFILLER_7_75 VGND VGND VPWR VPWR sky130_fd_sc_hd__decap_3
X_4461_ _4461_/A VGND VGND VPWR VPWR _8168_/D sky130_fd_sc_hd__buf_1
XFILLER_116_259 VGND VGND VPWR VPWR sky130_fd_sc_hd__decap_3
X_7180_ _7180_/A _7180_/B VGND VGND VPWR VPWR _7180_/X sky130_fd_sc_hd__xor2_2
X_6200_ _6199_/X _6058_/X _6706_/S VGND VGND VPWR VPWR _6200_/X sky130_fd_sc_hd__mux2_2
XFILLER_112_410 VGND VGND VPWR VPWR sky130_fd_sc_hd__decap_3
XFILLER_98_622 VGND VGND VPWR VPWR sky130_fd_sc_hd__decap_3
X_6131_ _7298_/S0 _6708_/B _6130_/X VGND VGND VPWR VPWR _6132_/B sky130_fd_sc_hd__a21oi_2
X_4392_ _7930_/B _4392_/B VGND VGND VPWR VPWR _4393_/A sky130_fd_sc_hd__and2_2
XFILLER_112_421 VGND VGND VPWR VPWR sky130_fd_sc_hd__decap_3
XFILLER_97_121 VGND VGND VPWR VPWR sky130_fd_sc_hd__decap_3
XFILLER_100_605 VGND VGND VPWR VPWR sky130_fd_sc_hd__decap_3
XFILLER_39_700 VGND VGND VPWR VPWR sky130_fd_sc_hd__decap_3
XFILLER_98_677 VGND VGND VPWR VPWR sky130_fd_sc_hd__decap_3
X_6062_ _6130_/A _6130_/B VGND VGND VPWR VPWR _6062_/Y sky130_fd_sc_hd__nand2_2
XFILLER_38_221 VGND VGND VPWR VPWR sky130_fd_sc_hd__decap_3
XFILLER_85_349 VGND VGND VPWR VPWR sky130_fd_sc_hd__decap_3
XFILLER_97_187 VGND VGND VPWR VPWR sky130_fd_sc_hd__decap_3
X_5013_ _8163_/Q _5012_/Y _6707_/S VGND VGND VPWR VPWR _5013_/X sky130_fd_sc_hd__o21ba_2
XFILLER_26_29 VGND VGND VPWR VPWR sky130_fd_sc_hd__decap_3
XFILLER_26_416 VGND VGND VPWR VPWR sky130_fd_sc_hd__decap_3
XFILLER_26_427 VGND VGND VPWR VPWR sky130_fd_sc_hd__decap_3
XFILLER_53_202 VGND VGND VPWR VPWR sky130_fd_sc_hd__decap_3
XFILLER_66_585 VGND VGND VPWR VPWR sky130_fd_sc_hd__decap_3
XFILLER_93_382 VGND VGND VPWR VPWR sky130_fd_sc_hd__decap_3
XFILLER_19_490 VGND VGND VPWR VPWR sky130_fd_sc_hd__decap_3
XFILLER_81_533 VGND VGND VPWR VPWR sky130_fd_sc_hd__fill_1
XFILLER_81_544 VGND VGND VPWR VPWR sky130_fd_sc_hd__decap_3
XFILLER_93_393 VGND VGND VPWR VPWR sky130_fd_sc_hd__decap_3
XPHY_EDGE_ROW_5_Right_5 VGND VGND VPWR VPWR sky130_fd_sc_hd__decap_3
Xclkbuf_leaf_18_clk clkload2/A VGND VGND VPWR VPWR _8269_/CLK sky130_fd_sc_hd__clkbuf_8
X_6964_ _6964_/A _6964_/B _6964_/C VGND VGND VPWR VPWR _6964_/X sky130_fd_sc_hd__and3_2
XFILLER_41_408 VGND VGND VPWR VPWR sky130_fd_sc_hd__decap_3
XFILLER_81_599 VGND VGND VPWR VPWR sky130_fd_sc_hd__fill_1
X_6895_ _7619_/A _8264_/Q _5597_/X _5110_/Y _8200_/Q VGND VGND VPWR VPWR _6895_/X
+ sky130_fd_sc_hd__a32o_2
X_5915_ _7825_/A _5910_/X _5912_/X _5914_/X VGND VGND VPWR VPWR _5915_/X sky130_fd_sc_hd__a2bb2o_2
XFILLER_22_622 VGND VGND VPWR VPWR sky130_fd_sc_hd__fill_2
XFILLER_42_17 VGND VGND VPWR VPWR sky130_fd_sc_hd__decap_3
X_5846_ _8172_/Q _8236_/Q VGND VGND VPWR VPWR _5846_/X sky130_fd_sc_hd__or2_2
XTAP_TAPCELL_ROW_52_937 VGND VPWR sky130_fd_sc_hd__tapvpwrvgnd_1
XFILLER_21_154 VGND VGND VPWR VPWR sky130_fd_sc_hd__decap_3
XFILLER_22_666 VGND VGND VPWR VPWR sky130_fd_sc_hd__decap_3
X_5777_ _6130_/A _5777_/B VGND VGND VPWR VPWR _5777_/Y sky130_fd_sc_hd__nor2_2
XTAP_TAPCELL_ROW_32_672 VGND VPWR sky130_fd_sc_hd__tapvpwrvgnd_1
X_7516_ _7494_/B _7514_/Y _7515_/X VGND VGND VPWR VPWR _7517_/B sky130_fd_sc_hd__a21boi_2
Xrebuffer447 _8233_/Q VGND VGND VPWR VPWR _5026_/B sky130_fd_sc_hd__buf_2
X_4728_ _8221_/Q _7585_/B VGND VGND VPWR VPWR _7541_/B sky130_fd_sc_hd__and2_2
X_7447_ _5492_/Y _7445_/X _8217_/Q VGND VGND VPWR VPWR _7453_/C sky130_fd_sc_hd__mux2_2
X_4659_ _4659_/A VGND VGND VPWR VPWR _8267_/D sky130_fd_sc_hd__buf_1
XFILLER_107_259 VGND VGND VPWR VPWR sky130_fd_sc_hd__decap_3
X_7378_ _8215_/Q _8279_/Q _7377_/X VGND VGND VPWR VPWR _7378_/Y sky130_fd_sc_hd__a21oi_2
XTAP_TAPCELL_ROW_73_1210 VGND VPWR sky130_fd_sc_hd__tapvpwrvgnd_1
XFILLER_115_270 VGND VGND VPWR VPWR sky130_fd_sc_hd__decap_3
XFILLER_115_281 VGND VGND VPWR VPWR sky130_fd_sc_hd__decap_3
XFILLER_67_14 VGND VGND VPWR VPWR sky130_fd_sc_hd__decap_3
XFILLER_88_121 VGND VGND VPWR VPWR sky130_fd_sc_hd__decap_3
XFILLER_89_666 VGND VGND VPWR VPWR sky130_fd_sc_hd__decap_3
X_6329_ _7193_/A _6320_/Y _6321_/X _6326_/X _6328_/Y VGND VGND VPWR VPWR _6330_/A
+ sky130_fd_sc_hd__a32o_2
XFILLER_49_508 VGND VGND VPWR VPWR sky130_fd_sc_hd__decap_3
XFILLER_67_47 VGND VGND VPWR VPWR sky130_fd_sc_hd__decap_3
XFILLER_67_69 VGND VGND VPWR VPWR sky130_fd_sc_hd__decap_3
XFILLER_69_390 VGND VGND VPWR VPWR sky130_fd_sc_hd__fill_2
XFILLER_45_703 VGND VGND VPWR VPWR sky130_fd_sc_hd__decap_3
XFILLER_57_552 VGND VGND VPWR VPWR sky130_fd_sc_hd__decap_3
XFILLER_29_265 VGND VGND VPWR VPWR sky130_fd_sc_hd__decap_3
XFILLER_57_585 VGND VGND VPWR VPWR sky130_fd_sc_hd__decap_3
XFILLER_84_360 VGND VGND VPWR VPWR sky130_fd_sc_hd__decap_3
XFILLER_17_449 VGND VGND VPWR VPWR sky130_fd_sc_hd__decap_3
XFILLER_44_246 VGND VGND VPWR VPWR sky130_fd_sc_hd__decap_3
XFILLER_72_533 VGND VGND VPWR VPWR sky130_fd_sc_hd__decap_3
XFILLER_83_57 VGND VGND VPWR VPWR sky130_fd_sc_hd__decap_3
XFILLER_32_408 VGND VGND VPWR VPWR sky130_fd_sc_hd__decap_3
XFILLER_44_268 VGND VGND VPWR VPWR sky130_fd_sc_hd__decap_3
XFILLER_72_566 VGND VGND VPWR VPWR sky130_fd_sc_hd__decap_3
XTAP_TAPCELL_ROW_84_1350 VGND VPWR sky130_fd_sc_hd__tapvpwrvgnd_1
XFILLER_13_633 VGND VGND VPWR VPWR sky130_fd_sc_hd__decap_3
XFILLER_25_471 VGND VGND VPWR VPWR sky130_fd_sc_hd__fill_1
XFILLER_40_430 VGND VGND VPWR VPWR sky130_fd_sc_hd__decap_3
XFILLER_40_463 VGND VGND VPWR VPWR sky130_fd_sc_hd__decap_3
XFILLER_9_626 VGND VGND VPWR VPWR sky130_fd_sc_hd__decap_3
XFILLER_12_165 VGND VGND VPWR VPWR sky130_fd_sc_hd__decap_3
XFILLER_13_688 VGND VGND VPWR VPWR sky130_fd_sc_hd__decap_3
XFILLER_8_147 VGND VGND VPWR VPWR sky130_fd_sc_hd__decap_3
XFILLER_32_94 VGND VGND VPWR VPWR sky130_fd_sc_hd__decap_3
XFILLER_4_342 VGND VGND VPWR VPWR sky130_fd_sc_hd__decap_3
XFILLER_59_9 VGND VGND VPWR VPWR sky130_fd_sc_hd__decap_3
XFILLER_99_408 VGND VGND VPWR VPWR sky130_fd_sc_hd__decap_3
XTAP_TAPCELL_ROW_10_388 VGND VPWR sky130_fd_sc_hd__tapvpwrvgnd_1
XFILLER_113_207 VGND VGND VPWR VPWR sky130_fd_sc_hd__decap_3
XFILLER_113_218 VGND VGND VPWR VPWR sky130_fd_sc_hd__decap_3
XTAP_TAPCELL_ROW_95_1490 VGND VPWR sky130_fd_sc_hd__tapvpwrvgnd_1
XFILLER_106_292 VGND VGND VPWR VPWR sky130_fd_sc_hd__decap_3
XFILLER_67_305 VGND VGND VPWR VPWR sky130_fd_sc_hd__decap_3
XFILLER_67_349 VGND VGND VPWR VPWR sky130_fd_sc_hd__decap_3
XFILLER_94_124 VGND VGND VPWR VPWR sky130_fd_sc_hd__fill_1
XFILLER_48_563 VGND VGND VPWR VPWR sky130_fd_sc_hd__decap_3
XFILLER_57_80 VGND VGND VPWR VPWR sky130_fd_sc_hd__decap_3
XFILLER_63_500 VGND VGND VPWR VPWR sky130_fd_sc_hd__decap_3
XFILLER_63_533 VGND VGND VPWR VPWR sky130_fd_sc_hd__decap_3
XFILLER_75_393 VGND VGND VPWR VPWR sky130_fd_sc_hd__decap_3
XFILLER_23_408 VGND VGND VPWR VPWR sky130_fd_sc_hd__decap_3
XFILLER_23_419 VGND VGND VPWR VPWR sky130_fd_sc_hd__fill_2
XFILLER_35_257 VGND VGND VPWR VPWR sky130_fd_sc_hd__decap_3
XFILLER_90_363 VGND VGND VPWR VPWR sky130_fd_sc_hd__fill_1
XFILLER_50_216 VGND VGND VPWR VPWR sky130_fd_sc_hd__decap_3
XFILLER_90_385 VGND VGND VPWR VPWR sky130_fd_sc_hd__decap_3
X_5700_ _6763_/A _5700_/B VGND VGND VPWR VPWR _5701_/A sky130_fd_sc_hd__or2_2
XTAP_TAPCELL_ROW_18_499 VGND VPWR sky130_fd_sc_hd__tapvpwrvgnd_1
XTAP_TAPCELL_ROW_18_488 VGND VPWR sky130_fd_sc_hd__tapvpwrvgnd_1
XFILLER_31_430 VGND VGND VPWR VPWR sky130_fd_sc_hd__decap_3
XFILLER_43_290 VGND VGND VPWR VPWR sky130_fd_sc_hd__decap_3
X_6680_ _8194_/Q _5601_/A _5718_/X _8258_/Q VGND VGND VPWR VPWR _6680_/X sky130_fd_sc_hd__a2bb2o_2
X_5631_ _5630_/X _6130_/C _6706_/S VGND VGND VPWR VPWR _5631_/X sky130_fd_sc_hd__mux2_2
X_8350_ _8352_/CLK _8350_/D VGND VGND VPWR VPWR _8350_/Q sky130_fd_sc_hd__dfxtp_2
X_5562_ _5562_/A _5562_/B VGND VGND VPWR VPWR _5562_/Y sky130_fd_sc_hd__xnor2_2
X_8281_ _8287_/CLK _8281_/D VGND VGND VPWR VPWR _8281_/Q sky130_fd_sc_hd__dfxtp_2
X_7301_ _7619_/A _8276_/Q _5323_/Y _7631_/B _8212_/Q VGND VGND VPWR VPWR _7301_/X
+ sky130_fd_sc_hd__o2111a_2
X_4513_ _4513_/A VGND VGND VPWR VPWR _8194_/D sky130_fd_sc_hd__buf_1
XFILLER_7_191 VGND VGND VPWR VPWR sky130_fd_sc_hd__decap_3
X_7232_ _5614_/X _7283_/A _7231_/X VGND VGND VPWR VPWR _7232_/Y sky130_fd_sc_hd__o21ai_2
X_5493_ _7560_/A _5490_/Y _5532_/B _7562_/A _5492_/Y VGND VGND VPWR VPWR _5493_/X
+ sky130_fd_sc_hd__a221o_2
XFILLER_104_218 VGND VGND VPWR VPWR sky130_fd_sc_hd__decap_3
Xclkbuf_leaf_7_clk clkload1/A VGND VGND VPWR VPWR _8218_/CLK sky130_fd_sc_hd__clkbuf_8
X_4444_ _7898_/B _8026_/Q VGND VGND VPWR VPWR _4445_/A sky130_fd_sc_hd__and2_2
X_7163_ _7163_/A _7223_/C VGND VGND VPWR VPWR _7164_/B sky130_fd_sc_hd__nand2_2
X_4375_ _4375_/A VGND VGND VPWR VPWR _8125_/D sky130_fd_sc_hd__buf_1
XFILLER_112_251 VGND VGND VPWR VPWR sky130_fd_sc_hd__fill_1
XFILLER_86_603 VGND VGND VPWR VPWR sky130_fd_sc_hd__decap_3
XFILLER_98_452 VGND VGND VPWR VPWR sky130_fd_sc_hd__decap_3
X_7094_ _8206_/Q _8270_/Q VGND VGND VPWR VPWR _7095_/B sky130_fd_sc_hd__nand2_2
X_6114_ _8179_/Q _6114_/B VGND VGND VPWR VPWR _6150_/B sky130_fd_sc_hd__or2_2
XFILLER_100_424 VGND VGND VPWR VPWR sky130_fd_sc_hd__decap_3
XFILLER_112_284 VGND VGND VPWR VPWR sky130_fd_sc_hd__decap_3
XFILLER_58_327 VGND VGND VPWR VPWR sky130_fd_sc_hd__decap_3
XFILLER_85_102 VGND VGND VPWR VPWR sky130_fd_sc_hd__fill_1
XFILLER_85_113 VGND VGND VPWR VPWR sky130_fd_sc_hd__decap_3
XFILLER_98_496 VGND VGND VPWR VPWR sky130_fd_sc_hd__decap_3
X_6045_ _6045_/A _6045_/B VGND VGND VPWR VPWR _6077_/B sky130_fd_sc_hd__and2_4
XFILLER_100_446 VGND VGND VPWR VPWR sky130_fd_sc_hd__fill_2
XFILLER_39_552 VGND VGND VPWR VPWR sky130_fd_sc_hd__decap_3
XFILLER_85_135 VGND VGND VPWR VPWR sky130_fd_sc_hd__decap_3
XFILLER_66_371 VGND VGND VPWR VPWR sky130_fd_sc_hd__decap_3
XFILLER_85_179 VGND VGND VPWR VPWR sky130_fd_sc_hd__decap_3
XFILLER_94_680 VGND VGND VPWR VPWR sky130_fd_sc_hd__decap_3
XFILLER_54_533 VGND VGND VPWR VPWR sky130_fd_sc_hd__decap_3
XFILLER_54_555 VGND VGND VPWR VPWR sky130_fd_sc_hd__decap_3
XFILLER_66_393 VGND VGND VPWR VPWR sky130_fd_sc_hd__decap_3
XFILLER_93_190 VGND VGND VPWR VPWR sky130_fd_sc_hd__decap_3
XFILLER_94_691 VGND VGND VPWR VPWR sky130_fd_sc_hd__decap_3
XTAP_TAPCELL_ROW_107_1648 VGND VPWR sky130_fd_sc_hd__tapvpwrvgnd_1
XTAP_TAPCELL_ROW_37_742 VGND VPWR sky130_fd_sc_hd__tapvpwrvgnd_1
XFILLER_14_408 VGND VGND VPWR VPWR sky130_fd_sc_hd__decap_3
XFILLER_26_268 VGND VGND VPWR VPWR sky130_fd_sc_hd__decap_3
XFILLER_54_577 VGND VGND VPWR VPWR sky130_fd_sc_hd__decap_3
XFILLER_81_352 VGND VGND VPWR VPWR sky130_fd_sc_hd__decap_3
X_7996_ _8402_/CLK _7996_/D VGND VGND VPWR VPWR _7996_/Q sky130_fd_sc_hd__dfxtp_2
XFILLER_81_385 VGND VGND VPWR VPWR sky130_fd_sc_hd__decap_3
XFILLER_81_396 VGND VGND VPWR VPWR sky130_fd_sc_hd__decap_3
X_6947_ _5407_/X _6988_/B _6946_/B _6368_/B _4817_/A VGND VGND VPWR VPWR _6947_/X
+ sky130_fd_sc_hd__a221o_2
X_6878_ _8199_/Q _8263_/Q _6876_/X _8262_/Q _6877_/X VGND VGND VPWR VPWR _6878_/X
+ sky130_fd_sc_hd__a221o_2
X_5829_ _5828_/X _5630_/X _6706_/S VGND VGND VPWR VPWR _5830_/A sky130_fd_sc_hd__mux2_2
XFILLER_108_524 VGND VGND VPWR VPWR sky130_fd_sc_hd__fill_1
XFILLER_5_106 VGND VGND VPWR VPWR sky130_fd_sc_hd__decap_3
XTAP_TAPCELL_ROW_118_1788 VGND VPWR sky130_fd_sc_hd__tapvpwrvgnd_1
Xrebuffer288 _8224_/Q VGND VGND VPWR VPWR _5780_/S sky130_fd_sc_hd__buf_2
Xrebuffer277 rebuffer827/X VGND VGND VPWR VPWR _5310_/A sky130_fd_sc_hd__buf_6
Xrebuffer266 _7579_/X VGND VGND VPWR VPWR _7836_/B sky130_fd_sc_hd__buf_4
XTAP_TAPCELL_ROW_118_1799 VGND VPWR sky130_fd_sc_hd__tapvpwrvgnd_1
XFILLER_78_57 VGND VGND VPWR VPWR sky130_fd_sc_hd__decap_3
XFILLER_103_240 VGND VGND VPWR VPWR sky130_fd_sc_hd__decap_3
XFILLER_77_603 VGND VGND VPWR VPWR sky130_fd_sc_hd__decap_3
XFILLER_89_452 VGND VGND VPWR VPWR sky130_fd_sc_hd__decap_3
XFILLER_103_273 VGND VGND VPWR VPWR sky130_fd_sc_hd__fill_2
XFILLER_76_102 VGND VGND VPWR VPWR sky130_fd_sc_hd__fill_2
XFILLER_77_647 VGND VGND VPWR VPWR sky130_fd_sc_hd__decap_3
XFILLER_89_485 VGND VGND VPWR VPWR sky130_fd_sc_hd__decap_3
XFILLER_49_349 VGND VGND VPWR VPWR sky130_fd_sc_hd__decap_3
XFILLER_92_617 VGND VGND VPWR VPWR sky130_fd_sc_hd__decap_3
XFILLER_94_23 VGND VGND VPWR VPWR sky130_fd_sc_hd__decap_3
XFILLER_45_511 VGND VGND VPWR VPWR sky130_fd_sc_hd__decap_3
XFILLER_85_680 VGND VGND VPWR VPWR sky130_fd_sc_hd__decap_3
XFILLER_91_116 VGND VGND VPWR VPWR sky130_fd_sc_hd__decap_3
XFILLER_45_544 VGND VGND VPWR VPWR sky130_fd_sc_hd__decap_3
XFILLER_57_393 VGND VGND VPWR VPWR sky130_fd_sc_hd__decap_3
XFILLER_72_330 VGND VGND VPWR VPWR sky130_fd_sc_hd__decap_3
XFILLER_17_257 VGND VGND VPWR VPWR sky130_fd_sc_hd__decap_3
XFILLER_72_363 VGND VGND VPWR VPWR sky130_fd_sc_hd__fill_1
XFILLER_45_599 VGND VGND VPWR VPWR sky130_fd_sc_hd__decap_3
XFILLER_60_525 VGND VGND VPWR VPWR sky130_fd_sc_hd__decap_3
XFILLER_60_536 VGND VGND VPWR VPWR sky130_fd_sc_hd__decap_3
XFILLER_13_441 VGND VGND VPWR VPWR sky130_fd_sc_hd__decap_3
XFILLER_13_452 VGND VGND VPWR VPWR sky130_fd_sc_hd__decap_3
XFILLER_32_249 VGND VGND VPWR VPWR sky130_fd_sc_hd__decap_3
XFILLER_60_558 VGND VGND VPWR VPWR sky130_fd_sc_hd__decap_3
XTAP_TAPCELL_ROW_15_458 VGND VPWR sky130_fd_sc_hd__tapvpwrvgnd_1
XFILLER_13_474 VGND VGND VPWR VPWR sky130_fd_sc_hd__decap_3
XFILLER_43_60 VGND VGND VPWR VPWR sky130_fd_sc_hd__decap_3
XFILLER_43_93 VGND VGND VPWR VPWR sky130_fd_sc_hd__decap_3
XFILLER_9_434 VGND VGND VPWR VPWR sky130_fd_sc_hd__decap_3
XFILLER_40_282 VGND VGND VPWR VPWR sky130_fd_sc_hd__fill_1
XFILLER_5_673 VGND VGND VPWR VPWR sky130_fd_sc_hd__decap_3
X_4160_ _7930_/B _7950_/Q VGND VGND VPWR VPWR _4161_/A sky130_fd_sc_hd__and2_2
XFILLER_67_113 VGND VGND VPWR VPWR sky130_fd_sc_hd__decap_3
XFILLER_95_411 VGND VGND VPWR VPWR sky130_fd_sc_hd__decap_3
X_4091_ _4091_/A VGND VGND VPWR VPWR _7983_/D sky130_fd_sc_hd__buf_1
XFILLER_83_628 VGND VGND VPWR VPWR sky130_fd_sc_hd__decap_3
XFILLER_36_522 VGND VGND VPWR VPWR sky130_fd_sc_hd__decap_3
X_7850_ _8295_/Q _7930_/B VGND VGND VPWR VPWR _7851_/A sky130_fd_sc_hd__and2_2
XFILLER_36_566 VGND VGND VPWR VPWR sky130_fd_sc_hd__fill_1
XFILLER_36_577 VGND VGND VPWR VPWR sky130_fd_sc_hd__fill_2
XFILLER_51_503 VGND VGND VPWR VPWR sky130_fd_sc_hd__fill_1
XFILLER_51_514 VGND VGND VPWR VPWR sky130_fd_sc_hd__fill_1
XFILLER_63_352 VGND VGND VPWR VPWR sky130_fd_sc_hd__decap_3
X_6801_ _6481_/X _6483_/B _6793_/X _6800_/Y VGND VGND VPWR VPWR _6801_/X sky130_fd_sc_hd__a31o_4
XTAP_TAPCELL_ROW_34_701 VGND VPWR sky130_fd_sc_hd__tapvpwrvgnd_1
XFILLER_23_216 VGND VGND VPWR VPWR sky130_fd_sc_hd__decap_3
XFILLER_23_238 VGND VGND VPWR VPWR sky130_fd_sc_hd__decap_3
XFILLER_51_536 VGND VGND VPWR VPWR sky130_fd_sc_hd__decap_3
XFILLER_51_547 VGND VGND VPWR VPWR sky130_fd_sc_hd__fill_2
XFILLER_63_385 VGND VGND VPWR VPWR sky130_fd_sc_hd__decap_3
XFILLER_63_396 VGND VGND VPWR VPWR sky130_fd_sc_hd__decap_3
X_7781_ _5950_/A _7779_/Y _7780_/Y _7796_/A VGND VGND VPWR VPWR _7781_/X sky130_fd_sc_hd__a22o_2
X_4993_ _8285_/Q _4994_/B _8221_/Q VGND VGND VPWR VPWR _4993_/X sky130_fd_sc_hd__a21bo_2
X_6732_ _6722_/X _6696_/Y _6731_/Y _7305_/A1 _7930_/B VGND VGND VPWR VPWR _8329_/D
+ sky130_fd_sc_hd__o221a_4
XFILLER_31_260 VGND VGND VPWR VPWR sky130_fd_sc_hd__decap_3
XTAP_TAPCELL_ROW_102_1589 VGND VPWR sky130_fd_sc_hd__tapvpwrvgnd_1
X_6663_ _5508_/A _6633_/Y _6636_/Y _7844_/C _6662_/X VGND VGND VPWR VPWR _6664_/B
+ sky130_fd_sc_hd__o221a_4
XFILLER_31_293 VGND VGND VPWR VPWR sky130_fd_sc_hd__decap_3
X_8402_ _8402_/CLK _8402_/D VGND VGND VPWR VPWR _8402_/Q sky130_fd_sc_hd__dfxtp_2
X_5614_ _6099_/A VGND VGND VPWR VPWR _5614_/X sky130_fd_sc_hd__buf_1
X_6594_ _8186_/Q _8250_/Q _8251_/Q _8187_/Q VGND VGND VPWR VPWR _6594_/X sky130_fd_sc_hd__a22o_2
X_8333_ _8400_/CLK _8333_/D VGND VGND VPWR VPWR _8333_/Q sky130_fd_sc_hd__dfxtp_2
X_5545_ _5544_/X _5273_/Y _6706_/S VGND VGND VPWR VPWR _5545_/X sky130_fd_sc_hd__mux2_2
XTAP_TAPCELL_ROW_57_1002 VGND VPWR sky130_fd_sc_hd__tapvpwrvgnd_1
XFILLER_105_505 VGND VGND VPWR VPWR sky130_fd_sc_hd__fill_1
XFILLER_2_109 VGND VGND VPWR VPWR sky130_fd_sc_hd__decap_3
X_8264_ _8402_/CLK _8264_/D VGND VGND VPWR VPWR _8264_/Q sky130_fd_sc_hd__dfxtp_2
X_5476_ _5464_/Y _5475_/Y _6247_/B VGND VGND VPWR VPWR _5476_/Y sky130_fd_sc_hd__a21oi_2
X_8195_ _8199_/CLK _8195_/D VGND VGND VPWR VPWR _8195_/Q sky130_fd_sc_hd__dfxtp_2
X_7215_ _7205_/X _7209_/Y _7214_/X VGND VGND VPWR VPWR _8343_/D sky130_fd_sc_hd__a21oi_2
X_4427_ _4427_/A VGND VGND VPWR VPWR _8151_/D sky130_fd_sc_hd__buf_1
X_7146_ _7159_/A _7146_/B VGND VGND VPWR VPWR _7146_/Y sky130_fd_sc_hd__nor2_2
XFILLER_113_571 VGND VGND VPWR VPWR sky130_fd_sc_hd__decap_3
XFILLER_48_38 VGND VGND VPWR VPWR sky130_fd_sc_hd__decap_3
XFILLER_58_113 VGND VGND VPWR VPWR sky130_fd_sc_hd__decap_3
XFILLER_59_647 VGND VGND VPWR VPWR sky130_fd_sc_hd__decap_3
XFILLER_86_433 VGND VGND VPWR VPWR sky130_fd_sc_hd__decap_3
X_4358_ _7930_/B _4358_/B VGND VGND VPWR VPWR _4359_/A sky130_fd_sc_hd__and2_2
XFILLER_74_606 VGND VGND VPWR VPWR sky130_fd_sc_hd__decap_3
X_7077_ _8200_/Q _8264_/Q VGND VGND VPWR VPWR _7078_/B sky130_fd_sc_hd__and2_2
X_4289_ _4289_/A VGND VGND VPWR VPWR _8082_/D sky130_fd_sc_hd__buf_1
XFILLER_100_265 VGND VGND VPWR VPWR sky130_fd_sc_hd__decap_3
XFILLER_27_500 VGND VGND VPWR VPWR sky130_fd_sc_hd__decap_3
XFILLER_39_360 VGND VGND VPWR VPWR sky130_fd_sc_hd__decap_3
XFILLER_74_628 VGND VGND VPWR VPWR sky130_fd_sc_hd__fill_2
XFILLER_86_477 VGND VGND VPWR VPWR sky130_fd_sc_hd__decap_3
X_6028_ _6148_/A _6023_/B _6098_/A _5817_/A VGND VGND VPWR VPWR _6028_/X sky130_fd_sc_hd__a22o_2
XFILLER_27_544 VGND VGND VPWR VPWR sky130_fd_sc_hd__decap_3
XFILLER_39_382 VGND VGND VPWR VPWR sky130_fd_sc_hd__decap_3
XFILLER_54_330 VGND VGND VPWR VPWR sky130_fd_sc_hd__decap_3
XFILLER_64_26 VGND VGND VPWR VPWR sky130_fd_sc_hd__fill_2
XFILLER_73_149 VGND VGND VPWR VPWR sky130_fd_sc_hd__decap_3
XTAP_TAPCELL_ROW_68_1142 VGND VPWR sky130_fd_sc_hd__tapvpwrvgnd_1
XFILLER_14_216 VGND VGND VPWR VPWR sky130_fd_sc_hd__decap_3
XFILLER_54_385 VGND VGND VPWR VPWR sky130_fd_sc_hd__decap_3
X_7979_ _8386_/CLK _7979_/D VGND VGND VPWR VPWR _7979_/Q sky130_fd_sc_hd__dfxtp_2
XFILLER_42_558 VGND VGND VPWR VPWR sky130_fd_sc_hd__decap_3
XFILLER_10_411 VGND VGND VPWR VPWR sky130_fd_sc_hd__decap_3
XFILLER_80_47 VGND VGND VPWR VPWR sky130_fd_sc_hd__fill_2
XTAP_TAPCELL_ROW_12_417 VGND VPWR sky130_fd_sc_hd__tapvpwrvgnd_1
XFILLER_22_271 VGND VGND VPWR VPWR sky130_fd_sc_hd__decap_3
XFILLER_10_477 VGND VGND VPWR VPWR sky130_fd_sc_hd__decap_3
XFILLER_6_404 VGND VGND VPWR VPWR sky130_fd_sc_hd__decap_3
XFILLER_108_321 VGND VGND VPWR VPWR sky130_fd_sc_hd__decap_3
XFILLER_89_23 VGND VGND VPWR VPWR sky130_fd_sc_hd__fill_2
XFILLER_108_365 VGND VGND VPWR VPWR sky130_fd_sc_hd__decap_3
XTAP_TAPCELL_ROW_79_1282 VGND VPWR sky130_fd_sc_hd__tapvpwrvgnd_1
XFILLER_108_387 VGND VGND VPWR VPWR sky130_fd_sc_hd__decap_3
XTAP_TAPCELL_ROW_92_1460 VGND VPWR sky130_fd_sc_hd__tapvpwrvgnd_1
XFILLER_104_582 VGND VGND VPWR VPWR sky130_fd_sc_hd__decap_3
XFILLER_49_113 VGND VGND VPWR VPWR sky130_fd_sc_hd__decap_3
XFILLER_89_271 VGND VGND VPWR VPWR sky130_fd_sc_hd__decap_3
XFILLER_77_433 VGND VGND VPWR VPWR sky130_fd_sc_hd__decap_3
XFILLER_77_444 VGND VGND VPWR VPWR sky130_fd_sc_hd__decap_3
XFILLER_77_455 VGND VGND VPWR VPWR sky130_fd_sc_hd__decap_3
XFILLER_65_617 VGND VGND VPWR VPWR sky130_fd_sc_hd__fill_1
XFILLER_65_628 VGND VGND VPWR VPWR sky130_fd_sc_hd__fill_2
XFILLER_77_477 VGND VGND VPWR VPWR sky130_fd_sc_hd__decap_3
XFILLER_18_533 VGND VGND VPWR VPWR sky130_fd_sc_hd__decap_3
XFILLER_38_82 VGND VGND VPWR VPWR sky130_fd_sc_hd__fill_2
XFILLER_45_330 VGND VGND VPWR VPWR sky130_fd_sc_hd__decap_3
XFILLER_92_436 VGND VGND VPWR VPWR sky130_fd_sc_hd__decap_3
XFILLER_92_458 VGND VGND VPWR VPWR sky130_fd_sc_hd__decap_3
XFILLER_33_503 VGND VGND VPWR VPWR sky130_fd_sc_hd__fill_1
XFILLER_45_352 VGND VGND VPWR VPWR sky130_fd_sc_hd__decap_3
XFILLER_80_609 VGND VGND VPWR VPWR sky130_fd_sc_hd__decap_3
XFILLER_33_514 VGND VGND VPWR VPWR sky130_fd_sc_hd__decap_3
XFILLER_45_374 VGND VGND VPWR VPWR sky130_fd_sc_hd__decap_3
XFILLER_45_396 VGND VGND VPWR VPWR sky130_fd_sc_hd__decap_3
XFILLER_33_547 VGND VGND VPWR VPWR sky130_fd_sc_hd__decap_3
XFILLER_72_193 VGND VGND VPWR VPWR sky130_fd_sc_hd__decap_3
XFILLER_60_388 VGND VGND VPWR VPWR sky130_fd_sc_hd__decap_3
XFILLER_13_271 VGND VGND VPWR VPWR sky130_fd_sc_hd__fill_1
XFILLER_70_80 VGND VGND VPWR VPWR sky130_fd_sc_hd__decap_3
XFILLER_9_253 VGND VGND VPWR VPWR sky130_fd_sc_hd__decap_3
Xclkload12 _8207_/CLK VGND VGND VPWR VPWR clkload12/X sky130_fd_sc_hd__clkbuf_4
Xclkload23 _8385_/CLK VGND VGND VPWR VPWR clkload23/X sky130_fd_sc_hd__clkbuf_4
Xclkload34 _8402_/CLK VGND VGND VPWR VPWR clkload34/X sky130_fd_sc_hd__clkbuf_8
XFILLER_55_3 VGND VGND VPWR VPWR sky130_fd_sc_hd__fill_2
X_5330_ _8289_/Q _6769_/B VGND VGND VPWR VPWR _5402_/A sky130_fd_sc_hd__nor2_2
X_5261_ _5259_/X _5260_/X _5451_/S VGND VGND VPWR VPWR _5261_/X sky130_fd_sc_hd__mux2_2
XFILLER_114_346 VGND VGND VPWR VPWR sky130_fd_sc_hd__decap_3
XFILLER_114_368 VGND VGND VPWR VPWR sky130_fd_sc_hd__decap_3
XFILLER_87_208 VGND VGND VPWR VPWR sky130_fd_sc_hd__decap_3
X_7000_ _8204_/Q _5398_/A _5618_/A _8268_/Q VGND VGND VPWR VPWR _7000_/X sky130_fd_sc_hd__a2bb2o_2
X_4212_ _7898_/B _4212_/B VGND VGND VPWR VPWR _4213_/A sky130_fd_sc_hd__and2_2
XFILLER_68_400 VGND VGND VPWR VPWR sky130_fd_sc_hd__decap_3
X_5192_ _5192_/A VGND VGND VPWR VPWR _5507_/A sky130_fd_sc_hd__clkbuf_1
XFILLER_110_530 VGND VGND VPWR VPWR sky130_fd_sc_hd__fill_2
XFILLER_68_433 VGND VGND VPWR VPWR sky130_fd_sc_hd__decap_3
X_4143_ _4143_/A VGND VGND VPWR VPWR _8009_/D sky130_fd_sc_hd__buf_1
XFILLER_110_574 VGND VGND VPWR VPWR sky130_fd_sc_hd__decap_3
XFILLER_55_116 VGND VGND VPWR VPWR sky130_fd_sc_hd__decap_3
XFILLER_56_639 VGND VGND VPWR VPWR sky130_fd_sc_hd__decap_3
XFILLER_68_466 VGND VGND VPWR VPWR sky130_fd_sc_hd__decap_3
XFILLER_68_477 VGND VGND VPWR VPWR sky130_fd_sc_hd__decap_3
XFILLER_95_263 VGND VGND VPWR VPWR sky130_fd_sc_hd__decap_3
X_4074_ _7898_/B _8378_/Q VGND VGND VPWR VPWR _4075_/A sky130_fd_sc_hd__and2_2
XFILLER_83_436 VGND VGND VPWR VPWR sky130_fd_sc_hd__decap_3
XFILLER_83_458 VGND VGND VPWR VPWR sky130_fd_sc_hd__decap_3
X_7902_ _8321_/Q _7930_/B VGND VGND VPWR VPWR _7903_/A sky130_fd_sc_hd__and2_2
XFILLER_36_330 VGND VGND VPWR VPWR sky130_fd_sc_hd__decap_3
XFILLER_36_363 VGND VGND VPWR VPWR sky130_fd_sc_hd__fill_1
XFILLER_48_190 VGND VGND VPWR VPWR sky130_fd_sc_hd__decap_3
XTAP_TAPCELL_ROW_104_1607 VGND VPWR sky130_fd_sc_hd__tapvpwrvgnd_1
XFILLER_24_536 VGND VGND VPWR VPWR sky130_fd_sc_hd__decap_3
XFILLER_36_374 VGND VGND VPWR VPWR sky130_fd_sc_hd__fill_1
XFILLER_51_322 VGND VGND VPWR VPWR sky130_fd_sc_hd__decap_3
XFILLER_91_491 VGND VGND VPWR VPWR sky130_fd_sc_hd__decap_3
X_7833_ _8223_/Q _8287_/Q VGND VGND VPWR VPWR _7833_/Y sky130_fd_sc_hd__nor2_2
XTAP_TAPCELL_ROW_47_870 VGND VPWR sky130_fd_sc_hd__tapvpwrvgnd_1
X_7764_ _7765_/A _7760_/X _7763_/X VGND VGND VPWR VPWR _7764_/Y sky130_fd_sc_hd__a21oi_2
XFILLER_51_366 VGND VGND VPWR VPWR sky130_fd_sc_hd__decap_3
XFILLER_51_388 VGND VGND VPWR VPWR sky130_fd_sc_hd__decap_3
X_6715_ _6825_/A _7007_/A VGND VGND VPWR VPWR _7067_/A sky130_fd_sc_hd__or2_2
X_4976_ _4976_/A VGND VGND VPWR VPWR _7225_/A sky130_fd_sc_hd__inv_2
XFILLER_51_399 VGND VGND VPWR VPWR sky130_fd_sc_hd__decap_3
X_7695_ _7653_/X _8188_/Q _7655_/X _7693_/Y _7694_/X VGND VGND VPWR VPWR _7705_/B
+ sky130_fd_sc_hd__a311o_2
XTAP_TAPCELL_ROW_63_1083 VGND VPWR sky130_fd_sc_hd__tapvpwrvgnd_1
XTAP_TAPCELL_ROW_63_1072 VGND VPWR sky130_fd_sc_hd__tapvpwrvgnd_1
Xclkload6 clkload6/A VGND VGND VPWR VPWR clkload6/Y sky130_fd_sc_hd__clkinv_4
X_6646_ _8193_/Q _8192_/Q _8191_/Q _8190_/Q _7796_/A _7812_/A VGND VGND VPWR VPWR
+ _6646_/X sky130_fd_sc_hd__mux4_2
X_6577_ _5464_/A _6172_/A _6571_/X _6576_/X VGND VGND VPWR VPWR _6577_/X sky130_fd_sc_hd__o31a_2
XFILLER_3_407 VGND VGND VPWR VPWR sky130_fd_sc_hd__fill_2
XFILLER_3_418 VGND VGND VPWR VPWR sky130_fd_sc_hd__decap_3
X_8316_ _8386_/CLK _8316_/D VGND VGND VPWR VPWR _8316_/Q sky130_fd_sc_hd__dfxtp_2
X_5528_ _5528_/A _8165_/Q VGND VGND VPWR VPWR _5561_/A sky130_fd_sc_hd__or2_2
XFILLER_105_335 VGND VGND VPWR VPWR sky130_fd_sc_hd__fill_1
XTAP_TAPCELL_ROW_115_1758 VGND VPWR sky130_fd_sc_hd__tapvpwrvgnd_1
XFILLER_105_346 VGND VGND VPWR VPWR sky130_fd_sc_hd__decap_3
XFILLER_59_37 VGND VGND VPWR VPWR sky130_fd_sc_hd__decap_3
X_8247_ _8382_/CLK _8247_/D VGND VGND VPWR VPWR _8247_/Q sky130_fd_sc_hd__dfxtp_2
X_5459_ _5176_/X _5177_/X _5684_/S VGND VGND VPWR VPWR _5459_/X sky130_fd_sc_hd__mux2_2
XFILLER_115_21 VGND VGND VPWR VPWR sky130_fd_sc_hd__decap_3
XFILLER_59_411 VGND VGND VPWR VPWR sky130_fd_sc_hd__decap_3
X_8178_ _8360_/CLK _8178_/D VGND VGND VPWR VPWR _8178_/Q sky130_fd_sc_hd__dfxtp_4
XFILLER_101_541 VGND VGND VPWR VPWR sky130_fd_sc_hd__decap_3
XFILLER_59_444 VGND VGND VPWR VPWR sky130_fd_sc_hd__decap_3
XFILLER_59_455 VGND VGND VPWR VPWR sky130_fd_sc_hd__fill_2
XFILLER_86_230 VGND VGND VPWR VPWR sky130_fd_sc_hd__decap_3
X_7129_ _8206_/Q _7228_/B _7129_/C VGND VGND VPWR VPWR _7227_/C sky130_fd_sc_hd__or3_4
XFILLER_47_606 VGND VGND VPWR VPWR sky130_fd_sc_hd__decap_3
XFILLER_47_617 VGND VGND VPWR VPWR sky130_fd_sc_hd__decap_3
XFILLER_46_116 VGND VGND VPWR VPWR sky130_fd_sc_hd__fill_1
XFILLER_74_436 VGND VGND VPWR VPWR sky130_fd_sc_hd__decap_3
XFILLER_86_285 VGND VGND VPWR VPWR sky130_fd_sc_hd__decap_3
XFILLER_27_352 VGND VGND VPWR VPWR sky130_fd_sc_hd__decap_3
XFILLER_39_190 VGND VGND VPWR VPWR sky130_fd_sc_hd__fill_1
XFILLER_55_661 VGND VGND VPWR VPWR sky130_fd_sc_hd__decap_3
XFILLER_74_469 VGND VGND VPWR VPWR sky130_fd_sc_hd__decap_3
XFILLER_27_385 VGND VGND VPWR VPWR sky130_fd_sc_hd__decap_3
XFILLER_27_396 VGND VGND VPWR VPWR sky130_fd_sc_hd__fill_2
XFILLER_54_171 VGND VGND VPWR VPWR sky130_fd_sc_hd__decap_3
XFILLER_61_119 VGND VGND VPWR VPWR sky130_fd_sc_hd__decap_3
XFILLER_70_620 VGND VGND VPWR VPWR sky130_fd_sc_hd__decap_3
XFILLER_70_653 VGND VGND VPWR VPWR sky130_fd_sc_hd__decap_3
XFILLER_91_35 VGND VGND VPWR VPWR sky130_fd_sc_hd__decap_3
XFILLER_91_57 VGND VGND VPWR VPWR sky130_fd_sc_hd__fill_2
XFILLER_30_528 VGND VGND VPWR VPWR sky130_fd_sc_hd__decap_3
XFILLER_42_388 VGND VGND VPWR VPWR sky130_fd_sc_hd__decap_3
XFILLER_91_68 VGND VGND VPWR VPWR sky130_fd_sc_hd__decap_3
XFILLER_24_73 VGND VGND VPWR VPWR sky130_fd_sc_hd__decap_3
XFILLER_30_539 VGND VGND VPWR VPWR sky130_fd_sc_hd__decap_3
XTAP_TAPCELL_ROW_25_586 VGND VPWR sky130_fd_sc_hd__tapvpwrvgnd_1
XFILLER_7_724 VGND VGND VPWR VPWR sky130_fd_sc_hd__decap_3
XFILLER_109_630 VGND VGND VPWR VPWR sky130_fd_sc_hd__fill_2
XFILLER_109_663 VGND VGND VPWR VPWR sky130_fd_sc_hd__decap_3
XFILLER_6_256 VGND VGND VPWR VPWR sky130_fd_sc_hd__decap_3
XFILLER_108_162 VGND VGND VPWR VPWR sky130_fd_sc_hd__decap_3
XFILLER_108_195 VGND VGND VPWR VPWR sky130_fd_sc_hd__fill_1
XFILLER_69_208 VGND VGND VPWR VPWR sky130_fd_sc_hd__decap_3
XFILLER_111_327 VGND VGND VPWR VPWR sky130_fd_sc_hd__decap_3
XFILLER_78_731 VGND VGND VPWR VPWR sky130_fd_sc_hd__fill_2
XFILLER_97_528 VGND VGND VPWR VPWR sky130_fd_sc_hd__decap_3
XFILLER_65_414 VGND VGND VPWR VPWR sky130_fd_sc_hd__decap_3
XFILLER_77_252 VGND VGND VPWR VPWR sky130_fd_sc_hd__decap_3
XFILLER_92_200 VGND VGND VPWR VPWR sky130_fd_sc_hd__decap_3
XFILLER_93_701 VGND VGND VPWR VPWR sky130_fd_sc_hd__decap_3
XFILLER_37_116 VGND VGND VPWR VPWR sky130_fd_sc_hd__fill_2
XFILLER_37_127 VGND VGND VPWR VPWR sky130_fd_sc_hd__fill_2
XFILLER_65_447 VGND VGND VPWR VPWR sky130_fd_sc_hd__fill_1
XFILLER_46_650 VGND VGND VPWR VPWR sky130_fd_sc_hd__fill_2
XFILLER_65_469 VGND VGND VPWR VPWR sky130_fd_sc_hd__decap_3
XFILLER_18_374 VGND VGND VPWR VPWR sky130_fd_sc_hd__decap_3
XFILLER_61_620 VGND VGND VPWR VPWR sky130_fd_sc_hd__decap_3
XFILLER_33_333 VGND VGND VPWR VPWR sky130_fd_sc_hd__decap_3
XFILLER_33_355 VGND VGND VPWR VPWR sky130_fd_sc_hd__decap_3
XFILLER_73_491 VGND VGND VPWR VPWR sky130_fd_sc_hd__decap_3
X_4830_ _8263_/Q _8199_/Q VGND VGND VPWR VPWR _6846_/B sky130_fd_sc_hd__and2b_2
XFILLER_33_388 VGND VGND VPWR VPWR sky130_fd_sc_hd__decap_3
XFILLER_60_141 VGND VGND VPWR VPWR sky130_fd_sc_hd__decap_3
XFILLER_33_399 VGND VGND VPWR VPWR sky130_fd_sc_hd__decap_3
X_4761_ _8212_/Q VGND VGND VPWR VPWR _4762_/A sky130_fd_sc_hd__inv_2
XFILLER_119_427 VGND VGND VPWR VPWR sky130_fd_sc_hd__decap_3
X_7480_ _6950_/X _7479_/X _6677_/X _7240_/X _6536_/A _6818_/S VGND VGND VPWR VPWR
+ _7480_/X sky130_fd_sc_hd__mux4_2
X_6500_ _6504_/A2 _5398_/A _5338_/A VGND VGND VPWR VPWR _6500_/Y sky130_fd_sc_hd__o21ai_2
X_4692_ _7843_/A _8150_/Q VGND VGND VPWR VPWR _4693_/A sky130_fd_sc_hd__and2_2
XFILLER_119_449 VGND VGND VPWR VPWR sky130_fd_sc_hd__decap_3
X_6431_ _8185_/Q _8186_/Q _6431_/C VGND VGND VPWR VPWR _6550_/A sky130_fd_sc_hd__or3_4
X_6362_ _8248_/Q _6307_/B _6361_/X VGND VGND VPWR VPWR _6362_/X sky130_fd_sc_hd__a21o_2
XFILLER_115_633 VGND VGND VPWR VPWR sky130_fd_sc_hd__decap_3
X_8101_ clkload8/A _8101_/D VGND VGND VPWR VPWR _8101_/Q sky130_fd_sc_hd__dfxtp_2
X_5313_ _5313_/A VGND VGND VPWR VPWR _7843_/C sky130_fd_sc_hd__clkbuf_1
XFILLER_114_121 VGND VGND VPWR VPWR sky130_fd_sc_hd__decap_3
X_6293_ _8181_/Q _8245_/Q _6291_/X _6292_/X VGND VGND VPWR VPWR _6293_/X sky130_fd_sc_hd__a211o_2
XFILLER_102_305 VGND VGND VPWR VPWR sky130_fd_sc_hd__decap_3
XFILLER_115_688 VGND VGND VPWR VPWR sky130_fd_sc_hd__fill_2
X_8032_ clkload3/A _8032_/D VGND VGND VPWR VPWR _8032_/Q sky130_fd_sc_hd__dfxtp_2
X_5244_ _7825_/A _5221_/X _5237_/Y _7827_/A VGND VGND VPWR VPWR _5244_/X sky130_fd_sc_hd__a211o_2
XFILLER_102_338 VGND VGND VPWR VPWR sky130_fd_sc_hd__decap_3
X_5175_ split/A _5491_/C _5310_/A _8163_/Q _7783_/A _7805_/A VGND VGND VPWR VPWR _5175_/X
+ sky130_fd_sc_hd__mux4_2
XFILLER_110_360 VGND VGND VPWR VPWR sky130_fd_sc_hd__decap_3
XFILLER_29_617 VGND VGND VPWR VPWR sky130_fd_sc_hd__decap_3
XFILLER_29_628 VGND VGND VPWR VPWR sky130_fd_sc_hd__decap_3
XFILLER_68_263 VGND VGND VPWR VPWR sky130_fd_sc_hd__decap_3
XTAP_TAPCELL_ROW_110_1688 VGND VPWR sky130_fd_sc_hd__tapvpwrvgnd_1
X_4126_ _7930_/B _7933_/Q VGND VGND VPWR VPWR _4127_/A sky130_fd_sc_hd__and2_2
XFILLER_110_382 VGND VGND VPWR VPWR sky130_fd_sc_hd__decap_3
XFILLER_29_639 VGND VGND VPWR VPWR sky130_fd_sc_hd__fill_1
XFILLER_56_436 VGND VGND VPWR VPWR sky130_fd_sc_hd__decap_3
XFILLER_83_222 VGND VGND VPWR VPWR sky130_fd_sc_hd__fill_2
XFILLER_83_244 VGND VGND VPWR VPWR sky130_fd_sc_hd__decap_3
X_4057_ _4057_/A VGND VGND VPWR VPWR _7966_/D sky130_fd_sc_hd__buf_1
XFILLER_43_119 VGND VGND VPWR VPWR sky130_fd_sc_hd__decap_3
XFILLER_64_480 VGND VGND VPWR VPWR sky130_fd_sc_hd__decap_3
XFILLER_71_428 VGND VGND VPWR VPWR sky130_fd_sc_hd__decap_3
XFILLER_83_277 VGND VGND VPWR VPWR sky130_fd_sc_hd__decap_3
XTAP_TAPCELL_ROW_65_1101 VGND VPWR sky130_fd_sc_hd__tapvpwrvgnd_1
XFILLER_24_322 VGND VGND VPWR VPWR sky130_fd_sc_hd__decap_3
XFILLER_36_193 VGND VGND VPWR VPWR sky130_fd_sc_hd__decap_3
X_7816_ _8163_/Q _7680_/B _7672_/A VGND VGND VPWR VPWR _7816_/Y sky130_fd_sc_hd__o21ai_2
XFILLER_24_377 VGND VGND VPWR VPWR sky130_fd_sc_hd__decap_3
XFILLER_51_152 VGND VGND VPWR VPWR sky130_fd_sc_hd__decap_3
XFILLER_12_539 VGND VGND VPWR VPWR sky130_fd_sc_hd__decap_3
XFILLER_51_196 VGND VGND VPWR VPWR sky130_fd_sc_hd__decap_3
XFILLER_61_27 VGND VGND VPWR VPWR sky130_fd_sc_hd__decap_3
X_7747_ _7747_/A _7747_/B VGND VGND VPWR VPWR _7824_/S sky130_fd_sc_hd__xnor2_2
X_4959_ _8163_/Q _6707_/S VGND VGND VPWR VPWR _5651_/B sky130_fd_sc_hd__or2b_2
X_7678_ _5579_/S _5785_/A _5200_/Y _7677_/Y VGND VGND VPWR VPWR _7678_/X sky130_fd_sc_hd__a31o_2
XTAP_TAPCELL_ROW_22_545 VGND VPWR sky130_fd_sc_hd__tapvpwrvgnd_1
X_6629_ _6606_/Y _6607_/X _6610_/Y _6964_/A _6628_/X VGND VGND VPWR VPWR _6629_/X
+ sky130_fd_sc_hd__a221o_2
XFILLER_106_611 VGND VGND VPWR VPWR sky130_fd_sc_hd__decap_3
XFILLER_4_727 VGND VGND VPWR VPWR sky130_fd_sc_hd__decap_3
XTAP_TAPCELL_ROW_76_1241 VGND VPWR sky130_fd_sc_hd__tapvpwrvgnd_1
XFILLER_3_259 VGND VGND VPWR VPWR sky130_fd_sc_hd__fill_2
XTAP_TAPCELL_ROW_76_1252 VGND VPWR sky130_fd_sc_hd__tapvpwrvgnd_1
XFILLER_105_187 VGND VGND VPWR VPWR sky130_fd_sc_hd__decap_3
XFILLER_79_517 VGND VGND VPWR VPWR sky130_fd_sc_hd__decap_3
XFILLER_19_40 VGND VGND VPWR VPWR sky130_fd_sc_hd__decap_3
XFILLER_47_414 VGND VGND VPWR VPWR sky130_fd_sc_hd__decap_3
XFILLER_87_561 VGND VGND VPWR VPWR sky130_fd_sc_hd__decap_3
XFILLER_101_382 VGND VGND VPWR VPWR sky130_fd_sc_hd__fill_2
XFILLER_101_393 VGND VGND VPWR VPWR sky130_fd_sc_hd__decap_3
XFILLER_19_116 VGND VGND VPWR VPWR sky130_fd_sc_hd__decap_3
XFILLER_47_447 VGND VGND VPWR VPWR sky130_fd_sc_hd__fill_1
XFILLER_59_274 VGND VGND VPWR VPWR sky130_fd_sc_hd__decap_3
XFILLER_74_200 VGND VGND VPWR VPWR sky130_fd_sc_hd__decap_3
XFILLER_87_583 VGND VGND VPWR VPWR sky130_fd_sc_hd__decap_3
XFILLER_19_149 VGND VGND VPWR VPWR sky130_fd_sc_hd__decap_3
XFILLER_35_609 VGND VGND VPWR VPWR sky130_fd_sc_hd__decap_3
XFILLER_62_406 VGND VGND VPWR VPWR sky130_fd_sc_hd__decap_3
XFILLER_74_233 VGND VGND VPWR VPWR sky130_fd_sc_hd__decap_3
XFILLER_90_704 VGND VGND VPWR VPWR sky130_fd_sc_hd__decap_3
XFILLER_27_160 VGND VGND VPWR VPWR sky130_fd_sc_hd__decap_3
XFILLER_28_694 VGND VGND VPWR VPWR sky130_fd_sc_hd__decap_3
XFILLER_43_620 VGND VGND VPWR VPWR sky130_fd_sc_hd__decap_3
XFILLER_62_439 VGND VGND VPWR VPWR sky130_fd_sc_hd__decap_3
XFILLER_74_277 VGND VGND VPWR VPWR sky130_fd_sc_hd__fill_2
XTAP_TAPCELL_ROW_2_281 VGND VPWR sky130_fd_sc_hd__tapvpwrvgnd_1
XFILLER_15_333 VGND VGND VPWR VPWR sky130_fd_sc_hd__decap_3
XTAP_TAPCELL_ROW_87_1392 VGND VPWR sky130_fd_sc_hd__tapvpwrvgnd_1
XFILLER_15_377 VGND VGND VPWR VPWR sky130_fd_sc_hd__decap_3
XFILLER_30_303 VGND VGND VPWR VPWR sky130_fd_sc_hd__decap_3
XFILLER_35_94 VGND VGND VPWR VPWR sky130_fd_sc_hd__decap_3
XFILLER_42_185 VGND VGND VPWR VPWR sky130_fd_sc_hd__fill_2
XFILLER_70_483 VGND VGND VPWR VPWR sky130_fd_sc_hd__decap_3
XFILLER_11_550 VGND VGND VPWR VPWR sky130_fd_sc_hd__decap_3
XFILLER_30_347 VGND VGND VPWR VPWR sky130_fd_sc_hd__decap_3
XFILLER_11_561 VGND VGND VPWR VPWR sky130_fd_sc_hd__fill_2
XFILLER_11_572 VGND VGND VPWR VPWR sky130_fd_sc_hd__decap_3
XFILLER_11_594 VGND VGND VPWR VPWR sky130_fd_sc_hd__decap_3
XFILLER_51_60 VGND VGND VPWR VPWR sky130_fd_sc_hd__decap_3
XFILLER_7_532 VGND VGND VPWR VPWR sky130_fd_sc_hd__decap_3
XFILLER_116_419 VGND VGND VPWR VPWR sky130_fd_sc_hd__fill_1
Xmax_cap207 _6787_/A VGND VGND VPWR VPWR _6454_/A sky130_fd_sc_hd__buf_4
XFILLER_109_471 VGND VGND VPWR VPWR sky130_fd_sc_hd__decap_3
Xmax_cap229 _5192_/A VGND VGND VPWR VPWR _6445_/A1 sky130_fd_sc_hd__buf_4
Xmax_cap218 _7843_/C VGND VGND VPWR VPWR _6589_/B2 sky130_fd_sc_hd__buf_6
XFILLER_111_113 VGND VGND VPWR VPWR sky130_fd_sc_hd__fill_1
XFILLER_112_669 VGND VGND VPWR VPWR sky130_fd_sc_hd__fill_2
XFILLER_111_179 VGND VGND VPWR VPWR sky130_fd_sc_hd__decap_3
XFILLER_66_701 VGND VGND VPWR VPWR sky130_fd_sc_hd__decap_3
XFILLER_78_561 VGND VGND VPWR VPWR sky130_fd_sc_hd__decap_3
XFILLER_97_369 VGND VGND VPWR VPWR sky130_fd_sc_hd__decap_3
XFILLER_38_447 VGND VGND VPWR VPWR sky130_fd_sc_hd__decap_3
XFILLER_65_222 VGND VGND VPWR VPWR sky130_fd_sc_hd__fill_2
XFILLER_93_520 VGND VGND VPWR VPWR sky130_fd_sc_hd__decap_3
Xclone320 _7555_/S VGND VGND VPWR VPWR _5684_/S sky130_fd_sc_hd__clkbuf_16
XFILLER_81_704 VGND VGND VPWR VPWR sky130_fd_sc_hd__decap_3
XFILLER_93_553 VGND VGND VPWR VPWR sky130_fd_sc_hd__decap_3
XFILLER_93_564 VGND VGND VPWR VPWR sky130_fd_sc_hd__fill_2
X_6980_ _7193_/A _6979_/X _6533_/A VGND VGND VPWR VPWR _6980_/Y sky130_fd_sc_hd__o21ai_2
XFILLER_53_417 VGND VGND VPWR VPWR sky130_fd_sc_hd__decap_3
XFILLER_65_299 VGND VGND VPWR VPWR sky130_fd_sc_hd__decap_3
XFILLER_80_203 VGND VGND VPWR VPWR sky130_fd_sc_hd__decap_3
XFILLER_93_597 VGND VGND VPWR VPWR sky130_fd_sc_hd__decap_3
X_5931_ _5561_/B _5561_/A _4947_/B _5868_/X _5930_/X VGND VGND VPWR VPWR _6302_/B
+ sky130_fd_sc_hd__a41o_4
XFILLER_18_171 VGND VGND VPWR VPWR sky130_fd_sc_hd__decap_3
XFILLER_34_631 VGND VGND VPWR VPWR sky130_fd_sc_hd__decap_3
XFILLER_46_480 VGND VGND VPWR VPWR sky130_fd_sc_hd__decap_3
XFILLER_80_236 VGND VGND VPWR VPWR sky130_fd_sc_hd__decap_3
XFILLER_34_675 VGND VGND VPWR VPWR sky130_fd_sc_hd__fill_1
X_5862_ _5861_/X _5487_/X _6818_/S VGND VGND VPWR VPWR _5863_/B sky130_fd_sc_hd__mux2_2
XFILLER_21_325 VGND VGND VPWR VPWR sky130_fd_sc_hd__decap_3
XFILLER_61_494 VGND VGND VPWR VPWR sky130_fd_sc_hd__fill_1
X_7601_ _8222_/Q _8286_/Q _7600_/X VGND VGND VPWR VPWR _7601_/X sky130_fd_sc_hd__a21o_2
X_5793_ _5026_/B _5756_/X _5792_/X VGND VGND VPWR VPWR _5793_/X sky130_fd_sc_hd__a21o_2
X_4813_ _8203_/Q _4813_/B VGND VGND VPWR VPWR _4814_/B sky130_fd_sc_hd__or2_2
X_7532_ _8218_/Q _8219_/Q _7532_/C VGND VGND VPWR VPWR _7608_/C sky130_fd_sc_hd__or3_4
X_4744_ _4744_/A _4744_/B VGND VGND VPWR VPWR _4745_/A sky130_fd_sc_hd__nor2_2
XTAP_TAPCELL_ROW_60_1042 VGND VPWR sky130_fd_sc_hd__tapvpwrvgnd_1
XFILLER_107_408 VGND VGND VPWR VPWR sky130_fd_sc_hd__fill_2
XFILLER_119_268 VGND VGND VPWR VPWR sky130_fd_sc_hd__decap_3
X_7463_ _7463_/A _7463_/B VGND VGND VPWR VPWR _7463_/X sky130_fd_sc_hd__or2_2
X_4675_ _4675_/A VGND VGND VPWR VPWR _8275_/D sky130_fd_sc_hd__buf_1
X_7394_ _8214_/Q _8278_/Q _7394_/C VGND VGND VPWR VPWR _7394_/X sky130_fd_sc_hd__or3_2
X_6414_ _8251_/Q _5399_/X wire225/X VGND VGND VPWR VPWR _6414_/Y sky130_fd_sc_hd__o21ai_2
XFILLER_115_441 VGND VGND VPWR VPWR sky130_fd_sc_hd__decap_3
XFILLER_115_452 VGND VGND VPWR VPWR sky130_fd_sc_hd__fill_2
XTAP_TAPCELL_ROW_112_1717 VGND VPWR sky130_fd_sc_hd__tapvpwrvgnd_1
X_6345_ _8185_/Q _8249_/Q _6344_/X VGND VGND VPWR VPWR _6345_/X sky130_fd_sc_hd__a21o_2
XFILLER_102_102 VGND VGND VPWR VPWR sky130_fd_sc_hd__decap_3
XFILLER_103_614 VGND VGND VPWR VPWR sky130_fd_sc_hd__fill_2
XFILLER_1_719 VGND VGND VPWR VPWR sky130_fd_sc_hd__decap_3
X_6276_ _6275_/X _5985_/X _6355_/A VGND VGND VPWR VPWR _6277_/B sky130_fd_sc_hd__mux2_2
XFILLER_88_358 VGND VGND VPWR VPWR sky130_fd_sc_hd__decap_3
X_8015_ _8352_/CLK _8015_/D VGND VGND VPWR VPWR _8015_/Q sky130_fd_sc_hd__dfxtp_2
Xinput108 operand_b[44] VGND VGND VPWR VPWR _4392_/B sky130_fd_sc_hd__clkdlybuf4s25_1
X_5227_ _5225_/X _5226_/X _5451_/S VGND VGND VPWR VPWR _5227_/X sky130_fd_sc_hd__mux2_2
XFILLER_102_168 VGND VGND VPWR VPWR sky130_fd_sc_hd__decap_3
XFILLER_57_712 VGND VGND VPWR VPWR sky130_fd_sc_hd__decap_3
XFILLER_69_550 VGND VGND VPWR VPWR sky130_fd_sc_hd__decap_3
XFILLER_69_561 VGND VGND VPWR VPWR sky130_fd_sc_hd__decap_3
XFILLER_76_509 VGND VGND VPWR VPWR sky130_fd_sc_hd__fill_2
Xinput119 operand_b[54] VGND VGND VPWR VPWR _4412_/B sky130_fd_sc_hd__clkdlybuf4s25_1
XFILLER_29_414 VGND VGND VPWR VPWR sky130_fd_sc_hd__decap_3
XFILLER_56_200 VGND VGND VPWR VPWR sky130_fd_sc_hd__decap_3
XFILLER_96_380 VGND VGND VPWR VPWR sky130_fd_sc_hd__decap_3
X_5158_ _5154_/X _5157_/X _5684_/S VGND VGND VPWR VPWR _5158_/X sky130_fd_sc_hd__mux2_2
XTAP_TAPCELL_ROW_71_1182 VGND VPWR sky130_fd_sc_hd__tapvpwrvgnd_1
XFILLER_29_447 VGND VGND VPWR VPWR sky130_fd_sc_hd__fill_1
XFILLER_29_458 VGND VGND VPWR VPWR sky130_fd_sc_hd__decap_3
XFILLER_56_233 VGND VGND VPWR VPWR sky130_fd_sc_hd__decap_3
XFILLER_56_49 VGND VGND VPWR VPWR sky130_fd_sc_hd__decap_3
XFILLER_72_704 VGND VGND VPWR VPWR sky130_fd_sc_hd__decap_3
XFILLER_84_542 VGND VGND VPWR VPWR sky130_fd_sc_hd__decap_3
X_5089_ _6462_/B _5700_/B VGND VGND VPWR VPWR _5435_/A sky130_fd_sc_hd__or2_2
X_4109_ _4109_/A VGND VGND VPWR VPWR _7992_/D sky130_fd_sc_hd__buf_1
XFILLER_44_439 VGND VGND VPWR VPWR sky130_fd_sc_hd__decap_3
XFILLER_56_288 VGND VGND VPWR VPWR sky130_fd_sc_hd__fill_2
XFILLER_71_203 VGND VGND VPWR VPWR sky130_fd_sc_hd__decap_3
XFILLER_84_575 VGND VGND VPWR VPWR sky130_fd_sc_hd__fill_1
XTAP_TAPCELL_ROW_27_615 VGND VPWR sky130_fd_sc_hd__tapvpwrvgnd_1
XTAP_TAPCELL_ROW_27_604 VGND VPWR sky130_fd_sc_hd__tapvpwrvgnd_1
XFILLER_37_480 VGND VGND VPWR VPWR sky130_fd_sc_hd__decap_3
XFILLER_71_225 VGND VGND VPWR VPWR sky130_fd_sc_hd__decap_3
XFILLER_71_247 VGND VGND VPWR VPWR sky130_fd_sc_hd__decap_3
XTAP_TAPCELL_ROW_55_968 VGND VPWR sky130_fd_sc_hd__tapvpwrvgnd_1
XFILLER_24_130 VGND VGND VPWR VPWR sky130_fd_sc_hd__decap_3
XFILLER_24_141 VGND VGND VPWR VPWR sky130_fd_sc_hd__decap_3
XFILLER_40_601 VGND VGND VPWR VPWR sky130_fd_sc_hd__decap_3
XFILLER_72_26 VGND VGND VPWR VPWR sky130_fd_sc_hd__fill_2
XTAP_TAPCELL_ROW_55_979 VGND VPWR sky130_fd_sc_hd__tapvpwrvgnd_1
XFILLER_12_325 VGND VGND VPWR VPWR sky130_fd_sc_hd__decap_3
XFILLER_24_174 VGND VGND VPWR VPWR sky130_fd_sc_hd__decap_3
XFILLER_12_347 VGND VGND VPWR VPWR sky130_fd_sc_hd__decap_3
XFILLER_40_656 VGND VGND VPWR VPWR sky130_fd_sc_hd__decap_3
XFILLER_8_329 VGND VGND VPWR VPWR sky130_fd_sc_hd__decap_3
XFILLER_20_380 VGND VGND VPWR VPWR sky130_fd_sc_hd__decap_3
XFILLER_21_41 VGND VGND VPWR VPWR sky130_fd_sc_hd__decap_3
XFILLER_106_430 VGND VGND VPWR VPWR sky130_fd_sc_hd__fill_1
XFILLER_106_441 VGND VGND VPWR VPWR sky130_fd_sc_hd__decap_3
XFILLER_21_74 VGND VGND VPWR VPWR sky130_fd_sc_hd__decap_3
XFILLER_97_23 VGND VGND VPWR VPWR sky130_fd_sc_hd__fill_2
XFILLER_79_314 VGND VGND VPWR VPWR sky130_fd_sc_hd__decap_3
XFILLER_106_496 VGND VGND VPWR VPWR sky130_fd_sc_hd__decap_3
XFILLER_97_67 VGND VGND VPWR VPWR sky130_fd_sc_hd__decap_3
XFILLER_48_701 VGND VGND VPWR VPWR sky130_fd_sc_hd__decap_3
XFILLER_48_712 VGND VGND VPWR VPWR sky130_fd_sc_hd__decap_3
XFILLER_79_369 VGND VGND VPWR VPWR sky130_fd_sc_hd__decap_3
XTAP_TAPCELL_ROW_7_351 VGND VPWR sky130_fd_sc_hd__tapvpwrvgnd_1
XFILLER_75_520 VGND VGND VPWR VPWR sky130_fd_sc_hd__decap_3
XTAP_TAPCELL_ROW_89_1421 VGND VPWR sky130_fd_sc_hd__tapvpwrvgnd_1
XTAP_TAPCELL_ROW_89_1410 VGND VPWR sky130_fd_sc_hd__tapvpwrvgnd_1
XFILLER_101_190 VGND VGND VPWR VPWR sky130_fd_sc_hd__decap_3
XFILLER_46_60 VGND VGND VPWR VPWR sky130_fd_sc_hd__fill_2
XFILLER_62_203 VGND VGND VPWR VPWR sky130_fd_sc_hd__decap_3
XFILLER_90_523 VGND VGND VPWR VPWR sky130_fd_sc_hd__decap_3
XFILLER_46_71 VGND VGND VPWR VPWR sky130_fd_sc_hd__decap_3
XFILLER_90_545 VGND VGND VPWR VPWR sky130_fd_sc_hd__decap_3
XFILLER_15_152 VGND VGND VPWR VPWR sky130_fd_sc_hd__decap_3
XFILLER_16_675 VGND VGND VPWR VPWR sky130_fd_sc_hd__decap_3
XFILLER_90_589 VGND VGND VPWR VPWR sky130_fd_sc_hd__decap_3
XFILLER_43_472 VGND VGND VPWR VPWR sky130_fd_sc_hd__decap_3
XFILLER_30_144 VGND VGND VPWR VPWR sky130_fd_sc_hd__decap_3
XFILLER_7_32 VGND VGND VPWR VPWR sky130_fd_sc_hd__decap_3
XFILLER_7_340 VGND VGND VPWR VPWR sky130_fd_sc_hd__decap_3
XFILLER_116_227 VGND VGND VPWR VPWR sky130_fd_sc_hd__decap_3
XFILLER_7_362 VGND VGND VPWR VPWR sky130_fd_sc_hd__decap_3
X_4460_ _7898_/B _8034_/Q VGND VGND VPWR VPWR _4461_/A sky130_fd_sc_hd__and2_2
XFILLER_7_98 VGND VGND VPWR VPWR sky130_fd_sc_hd__decap_3
X_4391_ _4391_/A VGND VGND VPWR VPWR _8133_/D sky130_fd_sc_hd__buf_1
XFILLER_97_100 VGND VGND VPWR VPWR sky130_fd_sc_hd__fill_2
XFILLER_98_601 VGND VGND VPWR VPWR sky130_fd_sc_hd__decap_3
X_6130_ _6130_/A _6130_/B _6130_/C VGND VGND VPWR VPWR _6130_/X sky130_fd_sc_hd__and3_2
XFILLER_97_133 VGND VGND VPWR VPWR sky130_fd_sc_hd__fill_2
XFILLER_98_645 VGND VGND VPWR VPWR sky130_fd_sc_hd__decap_3
XFILLER_112_455 VGND VGND VPWR VPWR sky130_fd_sc_hd__decap_3
XFILLER_112_477 VGND VGND VPWR VPWR sky130_fd_sc_hd__decap_3
XFILLER_85_317 VGND VGND VPWR VPWR sky130_fd_sc_hd__decap_3
XFILLER_97_144 VGND VGND VPWR VPWR sky130_fd_sc_hd__decap_3
XFILLER_98_689 VGND VGND VPWR VPWR sky130_fd_sc_hd__decap_3
X_6061_ _6061_/A VGND VGND VPWR VPWR _6650_/C sky130_fd_sc_hd__inv_2
XFILLER_100_628 VGND VGND VPWR VPWR sky130_fd_sc_hd__decap_3
XFILLER_38_200 VGND VGND VPWR VPWR sky130_fd_sc_hd__decap_3
XFILLER_66_520 VGND VGND VPWR VPWR sky130_fd_sc_hd__decap_3
XFILLER_78_380 VGND VGND VPWR VPWR sky130_fd_sc_hd__decap_3
XFILLER_97_199 VGND VGND VPWR VPWR sky130_fd_sc_hd__decap_3
X_5012_ _6706_/S _5318_/B _5011_/X VGND VGND VPWR VPWR _5012_/Y sky130_fd_sc_hd__o21ai_2
XFILLER_38_233 VGND VGND VPWR VPWR sky130_fd_sc_hd__decap_3
XFILLER_54_704 VGND VGND VPWR VPWR sky130_fd_sc_hd__decap_3
XFILLER_66_542 VGND VGND VPWR VPWR sky130_fd_sc_hd__decap_3
XFILLER_66_564 VGND VGND VPWR VPWR sky130_fd_sc_hd__decap_3
XFILLER_53_214 VGND VGND VPWR VPWR sky130_fd_sc_hd__decap_3
XFILLER_81_512 VGND VGND VPWR VPWR sky130_fd_sc_hd__fill_2
XFILLER_93_361 VGND VGND VPWR VPWR sky130_fd_sc_hd__decap_3
XFILLER_26_439 VGND VGND VPWR VPWR sky130_fd_sc_hd__decap_3
XFILLER_81_556 VGND VGND VPWR VPWR sky130_fd_sc_hd__decap_3
X_6963_ _7076_/B _6963_/B VGND VGND VPWR VPWR _6964_/C sky130_fd_sc_hd__or2_2
XFILLER_53_258 VGND VGND VPWR VPWR sky130_fd_sc_hd__fill_2
XFILLER_81_567 VGND VGND VPWR VPWR sky130_fd_sc_hd__decap_3
X_6894_ _5674_/X _5677_/X _6892_/Y _7193_/A VGND VGND VPWR VPWR _6894_/X sky130_fd_sc_hd__a31o_2
X_5914_ _7825_/A _5913_/Y _6247_/B VGND VGND VPWR VPWR _5914_/X sky130_fd_sc_hd__a21o_2
XFILLER_34_472 VGND VGND VPWR VPWR sky130_fd_sc_hd__decap_3
XFILLER_34_483 VGND VGND VPWR VPWR sky130_fd_sc_hd__decap_3
X_5845_ _8172_/Q _8236_/Q _8288_/Q VGND VGND VPWR VPWR _5845_/X sky130_fd_sc_hd__mux2_2
XTAP_TAPCELL_ROW_52_938 VGND VPWR sky130_fd_sc_hd__tapvpwrvgnd_1
XFILLER_21_133 VGND VGND VPWR VPWR sky130_fd_sc_hd__decap_3
XFILLER_22_645 VGND VGND VPWR VPWR sky130_fd_sc_hd__decap_3
XFILLER_42_29 VGND VGND VPWR VPWR sky130_fd_sc_hd__decap_3
XFILLER_21_166 VGND VGND VPWR VPWR sky130_fd_sc_hd__fill_2
XFILLER_21_188 VGND VGND VPWR VPWR sky130_fd_sc_hd__decap_3
X_5776_ _5358_/X _5362_/X _6707_/S VGND VGND VPWR VPWR _5777_/B sky130_fd_sc_hd__mux2_2
XTAP_TAPCELL_ROW_32_673 VGND VPWR sky130_fd_sc_hd__tapvpwrvgnd_1
X_7515_ _8219_/Q _8283_/Q VGND VGND VPWR VPWR _7515_/X sky130_fd_sc_hd__or2_2
Xrebuffer448 _6302_/B VGND VGND VPWR VPWR _5933_/A sky130_fd_sc_hd__buf_6
X_4727_ _8221_/Q _7585_/B VGND VGND VPWR VPWR _7541_/A sky130_fd_sc_hd__nor2_2
XFILLER_107_205 VGND VGND VPWR VPWR sky130_fd_sc_hd__decap_3
X_7446_ _5296_/A _7445_/X _8281_/Q VGND VGND VPWR VPWR _7453_/B sky130_fd_sc_hd__o21a_2
X_4658_ _7930_/B _8133_/Q VGND VGND VPWR VPWR _4659_/A sky130_fd_sc_hd__and2_2
XFILLER_107_238 VGND VGND VPWR VPWR sky130_fd_sc_hd__decap_3
Xinput90 operand_b[28] VGND VGND VPWR VPWR _4360_/B sky130_fd_sc_hd__clkdlybuf4s25_1
XFILLER_1_505 VGND VGND VPWR VPWR sky130_fd_sc_hd__fill_2
XFILLER_88_100 VGND VGND VPWR VPWR sky130_fd_sc_hd__decap_3
XFILLER_89_601 VGND VGND VPWR VPWR sky130_fd_sc_hd__fill_1
XFILLER_89_623 VGND VGND VPWR VPWR sky130_fd_sc_hd__decap_3
X_7377_ _8215_/Q _8279_/Q _7619_/A VGND VGND VPWR VPWR _7377_/X sky130_fd_sc_hd__o21a_2
X_4589_ _4589_/A VGND VGND VPWR VPWR _8232_/D sky130_fd_sc_hd__buf_1
XTAP_TAPCELL_ROW_73_1211 VGND VPWR sky130_fd_sc_hd__tapvpwrvgnd_1
XFILLER_103_411 VGND VGND VPWR VPWR sky130_fd_sc_hd__fill_2
XFILLER_107_66 VGND VGND VPWR VPWR sky130_fd_sc_hd__fill_1
XFILLER_88_133 VGND VGND VPWR VPWR sky130_fd_sc_hd__decap_3
XFILLER_89_645 VGND VGND VPWR VPWR sky130_fd_sc_hd__decap_3
X_6328_ _6109_/A _6327_/X _5124_/A VGND VGND VPWR VPWR _6328_/Y sky130_fd_sc_hd__o21ai_2
XFILLER_103_444 VGND VGND VPWR VPWR sky130_fd_sc_hd__decap_3
XFILLER_103_455 VGND VGND VPWR VPWR sky130_fd_sc_hd__decap_3
XFILLER_67_26 VGND VGND VPWR VPWR sky130_fd_sc_hd__fill_1
XFILLER_67_37 VGND VGND VPWR VPWR sky130_fd_sc_hd__fill_1
X_6259_ _6297_/D _6259_/B VGND VGND VPWR VPWR _6259_/X sky130_fd_sc_hd__xor2_2
XFILLER_76_339 VGND VGND VPWR VPWR sky130_fd_sc_hd__decap_3
XFILLER_88_177 VGND VGND VPWR VPWR sky130_fd_sc_hd__decap_3
XTAP_TAPCELL_ROW_4_310 VGND VPWR sky130_fd_sc_hd__tapvpwrvgnd_1
XFILLER_29_222 VGND VGND VPWR VPWR sky130_fd_sc_hd__fill_2
XFILLER_91_309 VGND VGND VPWR VPWR sky130_fd_sc_hd__decap_3
XFILLER_17_406 VGND VGND VPWR VPWR sky130_fd_sc_hd__decap_3
XFILLER_29_277 VGND VGND VPWR VPWR sky130_fd_sc_hd__decap_3
XFILLER_29_288 VGND VGND VPWR VPWR sky130_fd_sc_hd__decap_3
XFILLER_44_203 VGND VGND VPWR VPWR sky130_fd_sc_hd__decap_3
XFILLER_57_564 VGND VGND VPWR VPWR sky130_fd_sc_hd__decap_3
XFILLER_72_545 VGND VGND VPWR VPWR sky130_fd_sc_hd__decap_3
XFILLER_83_47 VGND VGND VPWR VPWR sky130_fd_sc_hd__decap_3
XFILLER_83_69 VGND VGND VPWR VPWR sky130_fd_sc_hd__decap_3
XFILLER_13_601 VGND VGND VPWR VPWR sky130_fd_sc_hd__decap_3
XFILLER_72_589 VGND VGND VPWR VPWR sky130_fd_sc_hd__fill_1
XTAP_TAPCELL_ROW_84_1351 VGND VPWR sky130_fd_sc_hd__tapvpwrvgnd_1
XFILLER_12_111 VGND VGND VPWR VPWR sky130_fd_sc_hd__decap_3
XFILLER_16_85 VGND VGND VPWR VPWR sky130_fd_sc_hd__decap_3
XPHY_EDGE_ROW_11_Right_11 VGND VGND VPWR VPWR sky130_fd_sc_hd__decap_3
XFILLER_12_144 VGND VGND VPWR VPWR sky130_fd_sc_hd__decap_3
XFILLER_13_645 VGND VGND VPWR VPWR sky130_fd_sc_hd__decap_3
XFILLER_13_667 VGND VGND VPWR VPWR sky130_fd_sc_hd__decap_3
XFILLER_40_442 VGND VGND VPWR VPWR sky130_fd_sc_hd__decap_3
XFILLER_40_475 VGND VGND VPWR VPWR sky130_fd_sc_hd__fill_1
XFILLER_40_486 VGND VGND VPWR VPWR sky130_fd_sc_hd__decap_3
XFILLER_8_115 VGND VGND VPWR VPWR sky130_fd_sc_hd__decap_3
XFILLER_32_62 VGND VGND VPWR VPWR sky130_fd_sc_hd__decap_3
XFILLER_4_321 VGND VGND VPWR VPWR sky130_fd_sc_hd__decap_3
XTAP_TAPCELL_ROW_10_389 VGND VPWR sky130_fd_sc_hd__tapvpwrvgnd_1
XTAP_TAPCELL_ROW_95_1491 VGND VPWR sky130_fd_sc_hd__tapvpwrvgnd_1
XFILLER_106_271 VGND VGND VPWR VPWR sky130_fd_sc_hd__decap_3
XFILLER_4_387 VGND VGND VPWR VPWR sky130_fd_sc_hd__decap_3
XFILLER_79_111 VGND VGND VPWR VPWR sky130_fd_sc_hd__fill_1
XPHY_EDGE_ROW_20_Right_20 VGND VGND VPWR VPWR sky130_fd_sc_hd__decap_3
XFILLER_79_166 VGND VGND VPWR VPWR sky130_fd_sc_hd__fill_2
XFILLER_95_615 VGND VGND VPWR VPWR sky130_fd_sc_hd__fill_1
XFILLER_48_520 VGND VGND VPWR VPWR sky130_fd_sc_hd__decap_3
XFILLER_67_328 VGND VGND VPWR VPWR sky130_fd_sc_hd__decap_3
XFILLER_79_199 VGND VGND VPWR VPWR sky130_fd_sc_hd__decap_3
XFILLER_48_542 VGND VGND VPWR VPWR sky130_fd_sc_hd__decap_3
XFILLER_82_309 VGND VGND VPWR VPWR sky130_fd_sc_hd__decap_3
XFILLER_94_147 VGND VGND VPWR VPWR sky130_fd_sc_hd__decap_3
XFILLER_63_512 VGND VGND VPWR VPWR sky130_fd_sc_hd__decap_3
XFILLER_75_350 VGND VGND VPWR VPWR sky130_fd_sc_hd__decap_3
XFILLER_35_236 VGND VGND VPWR VPWR sky130_fd_sc_hd__fill_2
XFILLER_35_269 VGND VGND VPWR VPWR sky130_fd_sc_hd__decap_3
XFILLER_51_707 VGND VGND VPWR VPWR sky130_fd_sc_hd__decap_3
XFILLER_51_729 VGND VGND VPWR VPWR sky130_fd_sc_hd__decap_3
XFILLER_63_589 VGND VGND VPWR VPWR sky130_fd_sc_hd__fill_2
XFILLER_50_228 VGND VGND VPWR VPWR sky130_fd_sc_hd__decap_3
XTAP_TAPCELL_ROW_18_489 VGND VPWR sky130_fd_sc_hd__tapvpwrvgnd_1
XFILLER_31_475 VGND VGND VPWR VPWR sky130_fd_sc_hd__fill_1
X_5630_ _5747_/A2 _8166_/Q _8165_/Q _8164_/Q _5678_/S _5452_/S VGND VGND VPWR VPWR
+ _5630_/X sky130_fd_sc_hd__mux4_2
XFILLER_31_497 VGND VGND VPWR VPWR sky130_fd_sc_hd__decap_3
X_5561_ _5561_/A _5561_/B VGND VGND VPWR VPWR _5562_/B sky130_fd_sc_hd__and2_2
X_8280_ _8280_/CLK _8280_/D VGND VGND VPWR VPWR _8280_/Q sky130_fd_sc_hd__dfxtp_2
X_7300_ _7300_/A _7300_/B VGND VGND VPWR VPWR _7300_/Y sky130_fd_sc_hd__nand2_2
X_5492_ _6775_/B _5700_/B VGND VGND VPWR VPWR _5492_/Y sky130_fd_sc_hd__nor2_2
X_4512_ _7930_/B _8060_/Q VGND VGND VPWR VPWR _4513_/A sky130_fd_sc_hd__and2_2
X_7231_ _7231_/A _7231_/B VGND VGND VPWR VPWR _7231_/X sky130_fd_sc_hd__or2_2
X_4443_ _4443_/A VGND VGND VPWR VPWR _8159_/D sky130_fd_sc_hd__buf_1
X_7162_ _4801_/A _7161_/X _5061_/A VGND VGND VPWR VPWR _7223_/C sky130_fd_sc_hd__o21bai_2
X_4374_ _7930_/B _4374_/B VGND VGND VPWR VPWR _4375_/A sky130_fd_sc_hd__and2_2
XFILLER_98_475 VGND VGND VPWR VPWR sky130_fd_sc_hd__fill_1
X_7093_ _7121_/A _7093_/B VGND VGND VPWR VPWR _8340_/D sky130_fd_sc_hd__nor2_2
X_6113_ _5966_/X _6080_/Y _6081_/X _6112_/X _7898_/B VGND VGND VPWR VPWR _8312_/D
+ sky130_fd_sc_hd__o311a_2
XFILLER_58_339 VGND VGND VPWR VPWR sky130_fd_sc_hd__fill_1
XFILLER_85_125 VGND VGND VPWR VPWR sky130_fd_sc_hd__fill_1
XFILLER_86_626 VGND VGND VPWR VPWR sky130_fd_sc_hd__decap_3
XFILLER_86_648 VGND VGND VPWR VPWR sky130_fd_sc_hd__decap_3
XPHY_EDGE_ROW_13_Left_133 VGND VGND VPWR VPWR sky130_fd_sc_hd__decap_3
X_6044_ _6097_/A _8240_/Q _6003_/B _6003_/C VGND VGND VPWR VPWR _6045_/A sky130_fd_sc_hd__a22o_4
XFILLER_37_18 VGND VGND VPWR VPWR sky130_fd_sc_hd__decap_3
XFILLER_39_531 VGND VGND VPWR VPWR sky130_fd_sc_hd__decap_3
XFILLER_39_575 VGND VGND VPWR VPWR sky130_fd_sc_hd__decap_3
XFILLER_54_501 VGND VGND VPWR VPWR sky130_fd_sc_hd__decap_3
XFILLER_85_169 VGND VGND VPWR VPWR sky130_fd_sc_hd__fill_1
XFILLER_39_597 VGND VGND VPWR VPWR sky130_fd_sc_hd__decap_3
XFILLER_81_331 VGND VGND VPWR VPWR sky130_fd_sc_hd__decap_3
XTAP_TAPCELL_ROW_107_1649 VGND VPWR sky130_fd_sc_hd__tapvpwrvgnd_1
X_7995_ _8269_/CLK _7995_/D VGND VGND VPWR VPWR _7995_/Q sky130_fd_sc_hd__dfxtp_2
XTAP_TAPCELL_ROW_37_743 VGND VPWR sky130_fd_sc_hd__tapvpwrvgnd_1
XFILLER_41_206 VGND VGND VPWR VPWR sky130_fd_sc_hd__decap_3
XFILLER_54_567 VGND VGND VPWR VPWR sky130_fd_sc_hd__fill_2
XFILLER_54_589 VGND VGND VPWR VPWR sky130_fd_sc_hd__decap_3
XFILLER_81_364 VGND VGND VPWR VPWR sky130_fd_sc_hd__decap_3
X_6946_ _7474_/A _6946_/B VGND VGND VPWR VPWR _7006_/C sky130_fd_sc_hd__nor2_2
XFILLER_41_228 VGND VGND VPWR VPWR sky130_fd_sc_hd__decap_3
XFILLER_22_442 VGND VGND VPWR VPWR sky130_fd_sc_hd__decap_3
XPHY_EDGE_ROW_22_Left_142 VGND VGND VPWR VPWR sky130_fd_sc_hd__decap_3
X_6877_ _8262_/Q _6876_/X _8198_/Q VGND VGND VPWR VPWR _6877_/X sky130_fd_sc_hd__o21a_2
XFILLER_22_464 VGND VGND VPWR VPWR sky130_fd_sc_hd__decap_3
XFILLER_22_486 VGND VGND VPWR VPWR sky130_fd_sc_hd__decap_3
X_5828_ _5943_/C _5943_/B _5828_/A2 _6095_/A _5678_/S _5452_/S VGND VGND VPWR VPWR
+ _5828_/X sky130_fd_sc_hd__mux4_2
XFILLER_10_648 VGND VGND VPWR VPWR sky130_fd_sc_hd__decap_3
XFILLER_10_659 VGND VGND VPWR VPWR sky130_fd_sc_hd__decap_3
X_5759_ _6804_/A _5756_/X _5757_/Y _5966_/A _5867_/C VGND VGND VPWR VPWR _5759_/X
+ sky130_fd_sc_hd__o221a_2
XFILLER_108_503 VGND VGND VPWR VPWR sky130_fd_sc_hd__fill_2
XFILLER_108_547 VGND VGND VPWR VPWR sky130_fd_sc_hd__fill_1
XFILLER_118_21 VGND VGND VPWR VPWR sky130_fd_sc_hd__decap_3
XFILLER_118_32 VGND VGND VPWR VPWR sky130_fd_sc_hd__decap_3
Xrebuffer289 _8224_/Q VGND VGND VPWR VPWR _5286_/A sky130_fd_sc_hd__buf_4
Xrebuffer278 _5284_/A VGND VGND VPWR VPWR _5491_/A sky130_fd_sc_hd__buf_2
XTAP_TAPCELL_ROW_118_1789 VGND VPWR sky130_fd_sc_hd__tapvpwrvgnd_1
X_7429_ _7417_/X _7429_/B _7429_/C _7429_/D VGND VGND VPWR VPWR _7429_/X sky130_fd_sc_hd__and4b_2
XFILLER_116_580 VGND VGND VPWR VPWR sky130_fd_sc_hd__decap_3
XFILLER_89_431 VGND VGND VPWR VPWR sky130_fd_sc_hd__decap_3
XPHY_EDGE_ROW_31_Left_151 VGND VGND VPWR VPWR sky130_fd_sc_hd__decap_3
XFILLER_103_252 VGND VGND VPWR VPWR sky130_fd_sc_hd__decap_3
XFILLER_76_125 VGND VGND VPWR VPWR sky130_fd_sc_hd__decap_3
XFILLER_76_147 VGND VGND VPWR VPWR sky130_fd_sc_hd__decap_3
XFILLER_94_35 VGND VGND VPWR VPWR sky130_fd_sc_hd__fill_2
XFILLER_18_704 VGND VGND VPWR VPWR sky130_fd_sc_hd__fill_2
XFILLER_57_361 VGND VGND VPWR VPWR sky130_fd_sc_hd__decap_3
XFILLER_64_309 VGND VGND VPWR VPWR sky130_fd_sc_hd__decap_3
XFILLER_94_46 VGND VGND VPWR VPWR sky130_fd_sc_hd__decap_3
XFILLER_17_225 VGND VGND VPWR VPWR sky130_fd_sc_hd__decap_3
XFILLER_27_51 VGND VGND VPWR VPWR sky130_fd_sc_hd__decap_3
XFILLER_45_523 VGND VGND VPWR VPWR sky130_fd_sc_hd__decap_3
XFILLER_85_692 VGND VGND VPWR VPWR sky130_fd_sc_hd__decap_3
XFILLER_91_128 VGND VGND VPWR VPWR sky130_fd_sc_hd__decap_3
XFILLER_33_729 VGND VGND VPWR VPWR sky130_fd_sc_hd__decap_3
XFILLER_45_556 VGND VGND VPWR VPWR sky130_fd_sc_hd__decap_3
XFILLER_45_567 VGND VGND VPWR VPWR sky130_fd_sc_hd__decap_3
XFILLER_72_342 VGND VGND VPWR VPWR sky130_fd_sc_hd__decap_3
XFILLER_72_397 VGND VGND VPWR VPWR sky130_fd_sc_hd__decap_3
XPHY_EDGE_ROW_40_Left_160 VGND VGND VPWR VPWR sky130_fd_sc_hd__decap_3
XTAP_TAPCELL_ROW_15_448 VGND VPWR sky130_fd_sc_hd__tapvpwrvgnd_1
XTAP_TAPCELL_ROW_15_459 VGND VPWR sky130_fd_sc_hd__tapvpwrvgnd_1
XFILLER_40_250 VGND VGND VPWR VPWR sky130_fd_sc_hd__fill_2
XFILLER_9_402 VGND VGND VPWR VPWR sky130_fd_sc_hd__decap_3
XFILLER_9_413 VGND VGND VPWR VPWR sky130_fd_sc_hd__decap_3
XTAP_TAPCELL_ROW_97_1520 VGND VPWR sky130_fd_sc_hd__tapvpwrvgnd_1
XFILLER_99_206 VGND VGND VPWR VPWR sky130_fd_sc_hd__decap_3
Xrebuffer790 _8168_/Q VGND VGND VPWR VPWR _6095_/A sky130_fd_sc_hd__buf_2
XFILLER_114_539 VGND VGND VPWR VPWR sky130_fd_sc_hd__fill_2
XFILLER_99_239 VGND VGND VPWR VPWR sky130_fd_sc_hd__decap_3
XFILLER_4_88 VGND VGND VPWR VPWR sky130_fd_sc_hd__decap_3
XFILLER_95_423 VGND VGND VPWR VPWR sky130_fd_sc_hd__decap_3
XFILLER_67_125 VGND VGND VPWR VPWR sky130_fd_sc_hd__decap_3
XFILLER_68_659 VGND VGND VPWR VPWR sky130_fd_sc_hd__decap_3
XFILLER_68_91 VGND VGND VPWR VPWR sky130_fd_sc_hd__decap_3
XFILLER_83_607 VGND VGND VPWR VPWR sky130_fd_sc_hd__decap_3
X_4090_ _7898_/B _8386_/Q VGND VGND VPWR VPWR _4091_/A sky130_fd_sc_hd__and2_2
XFILLER_36_512 VGND VGND VPWR VPWR sky130_fd_sc_hd__decap_3
XFILLER_67_169 VGND VGND VPWR VPWR sky130_fd_sc_hd__fill_2
XFILLER_48_372 VGND VGND VPWR VPWR sky130_fd_sc_hd__decap_3
XFILLER_76_681 VGND VGND VPWR VPWR sky130_fd_sc_hd__decap_3
XFILLER_63_364 VGND VGND VPWR VPWR sky130_fd_sc_hd__decap_3
XFILLER_91_673 VGND VGND VPWR VPWR sky130_fd_sc_hd__decap_3
X_6800_ _6565_/A _6565_/B _6794_/Y _6799_/Y VGND VGND VPWR VPWR _6800_/Y sky130_fd_sc_hd__o31ai_2
XFILLER_23_228 VGND VGND VPWR VPWR sky130_fd_sc_hd__decap_3
XFILLER_36_589 VGND VGND VPWR VPWR sky130_fd_sc_hd__decap_3
XFILLER_90_161 VGND VGND VPWR VPWR sky130_fd_sc_hd__fill_1
X_7780_ _5897_/A _7660_/A _7664_/X VGND VGND VPWR VPWR _7780_/Y sky130_fd_sc_hd__o21ai_2
X_4992_ _7633_/C _4989_/X _4990_/X _4991_/Y VGND VGND VPWR VPWR _4994_/B sky130_fd_sc_hd__a31o_2
XTAP_TAPCELL_ROW_34_702 VGND VPWR sky130_fd_sc_hd__tapvpwrvgnd_1
XFILLER_51_559 VGND VGND VPWR VPWR sky130_fd_sc_hd__fill_1
X_6731_ _6731_/A _6731_/B VGND VGND VPWR VPWR _6731_/Y sky130_fd_sc_hd__xnor2_2
XTAP_TAPCELL_ROW_102_1579 VGND VPWR sky130_fd_sc_hd__tapvpwrvgnd_1
X_6662_ _6644_/X _6662_/B _6662_/C _6662_/D VGND VGND VPWR VPWR _6662_/X sky130_fd_sc_hd__and4b_2
X_8401_ _8401_/CLK _8401_/D VGND VGND VPWR VPWR _8401_/Q sky130_fd_sc_hd__dfxtp_2
X_5613_ _5508_/X _5562_/Y _5612_/X _7898_/B VGND VGND VPWR VPWR _8300_/D sky130_fd_sc_hd__o211a_2
X_8332_ _8400_/CLK _8332_/D VGND VGND VPWR VPWR _8332_/Q sky130_fd_sc_hd__dfxtp_2
X_6593_ _8187_/Q _8251_/Q _6592_/X VGND VGND VPWR VPWR _6593_/X sky130_fd_sc_hd__o21ba_2
XFILLER_117_333 VGND VGND VPWR VPWR sky130_fd_sc_hd__decap_3
X_5544_ _8165_/Q _8164_/Q _8163_/Q _5491_/C _5678_/S _5452_/S VGND VGND VPWR VPWR
+ _5544_/X sky130_fd_sc_hd__mux4_2
XTAP_TAPCELL_ROW_57_1003 VGND VPWR sky130_fd_sc_hd__tapvpwrvgnd_1
XFILLER_117_355 VGND VGND VPWR VPWR sky130_fd_sc_hd__decap_3
X_8263_ _8400_/CLK _8263_/D VGND VGND VPWR VPWR _8263_/Q sky130_fd_sc_hd__dfxtp_2
X_5475_ _5475_/A _5475_/B VGND VGND VPWR VPWR _5475_/Y sky130_fd_sc_hd__nand2_2
XFILLER_105_539 VGND VGND VPWR VPWR sky130_fd_sc_hd__decap_3
X_8194_ _8392_/CLK _8194_/D VGND VGND VPWR VPWR _8194_/Q sky130_fd_sc_hd__dfxtp_2
X_7214_ _6910_/A _7212_/X _7213_/Y _7844_/A VGND VGND VPWR VPWR _7214_/X sky130_fd_sc_hd__a31o_2
X_4426_ _7843_/A _4426_/B VGND VGND VPWR VPWR _4427_/A sky130_fd_sc_hd__and2_2
X_7145_ _7159_/A _7146_/B VGND VGND VPWR VPWR _7145_/Y sky130_fd_sc_hd__nand2_2
XFILLER_100_200 VGND VGND VPWR VPWR sky130_fd_sc_hd__fill_1
XFILLER_113_561 VGND VGND VPWR VPWR sky130_fd_sc_hd__fill_1
XFILLER_86_401 VGND VGND VPWR VPWR sky130_fd_sc_hd__decap_3
X_4357_ _4357_/A VGND VGND VPWR VPWR _8116_/D sky130_fd_sc_hd__buf_1
XFILLER_100_211 VGND VGND VPWR VPWR sky130_fd_sc_hd__decap_3
XFILLER_100_233 VGND VGND VPWR VPWR sky130_fd_sc_hd__decap_3
XFILLER_58_125 VGND VGND VPWR VPWR sky130_fd_sc_hd__decap_3
XFILLER_58_147 VGND VGND VPWR VPWR sky130_fd_sc_hd__fill_2
XFILLER_59_659 VGND VGND VPWR VPWR sky130_fd_sc_hd__decap_3
XFILLER_86_445 VGND VGND VPWR VPWR sky130_fd_sc_hd__decap_3
X_7076_ _7076_/A _7076_/B VGND VGND VPWR VPWR _7167_/C sky130_fd_sc_hd__and2_2
X_4288_ _7843_/A _4288_/B VGND VGND VPWR VPWR _4289_/A sky130_fd_sc_hd__and2_2
XFILLER_100_277 VGND VGND VPWR VPWR sky130_fd_sc_hd__decap_3
XFILLER_46_309 VGND VGND VPWR VPWR sky130_fd_sc_hd__decap_3
X_6027_ _6027_/A _6027_/B VGND VGND VPWR VPWR _6027_/Y sky130_fd_sc_hd__nand2_2
XFILLER_100_299 VGND VGND VPWR VPWR sky130_fd_sc_hd__decap_3
XFILLER_66_180 VGND VGND VPWR VPWR sky130_fd_sc_hd__decap_3
XFILLER_73_128 VGND VGND VPWR VPWR sky130_fd_sc_hd__decap_3
XFILLER_27_556 VGND VGND VPWR VPWR sky130_fd_sc_hd__decap_3
XFILLER_27_567 VGND VGND VPWR VPWR sky130_fd_sc_hd__decap_3
XFILLER_54_353 VGND VGND VPWR VPWR sky130_fd_sc_hd__decap_3
XFILLER_64_38 VGND VGND VPWR VPWR sky130_fd_sc_hd__decap_3
XFILLER_82_651 VGND VGND VPWR VPWR sky130_fd_sc_hd__decap_3
XTAP_TAPCELL_ROW_68_1143 VGND VPWR sky130_fd_sc_hd__tapvpwrvgnd_1
XFILLER_14_228 VGND VGND VPWR VPWR sky130_fd_sc_hd__decap_3
XFILLER_15_729 VGND VGND VPWR VPWR sky130_fd_sc_hd__decap_3
XFILLER_54_397 VGND VGND VPWR VPWR sky130_fd_sc_hd__decap_3
X_7978_ _8384_/CLK _7978_/D VGND VGND VPWR VPWR _7978_/Q sky130_fd_sc_hd__dfxtp_2
XTAP_TAPCELL_ROW_81_1310 VGND VPWR sky130_fd_sc_hd__tapvpwrvgnd_1
X_6929_ _6099_/A _7072_/B _6148_/A _6943_/B VGND VGND VPWR VPWR _6929_/X sky130_fd_sc_hd__a2bb2o_2
XFILLER_50_570 VGND VGND VPWR VPWR sky130_fd_sc_hd__fill_2
XTAP_TAPCELL_ROW_12_418 VGND VPWR sky130_fd_sc_hd__tapvpwrvgnd_1
XFILLER_6_416 VGND VGND VPWR VPWR sky130_fd_sc_hd__decap_3
XFILLER_6_427 VGND VGND VPWR VPWR sky130_fd_sc_hd__fill_1
XFILLER_108_333 VGND VGND VPWR VPWR sky130_fd_sc_hd__decap_3
XFILLER_10_489 VGND VGND VPWR VPWR sky130_fd_sc_hd__decap_3
XFILLER_13_97 VGND VGND VPWR VPWR sky130_fd_sc_hd__decap_3
XFILLER_108_355 VGND VGND VPWR VPWR sky130_fd_sc_hd__decap_3
XFILLER_89_57 VGND VGND VPWR VPWR sky130_fd_sc_hd__fill_1
XTAP_TAPCELL_ROW_79_1283 VGND VPWR sky130_fd_sc_hd__tapvpwrvgnd_1
XFILLER_96_209 VGND VGND VPWR VPWR sky130_fd_sc_hd__decap_3
XTAP_TAPCELL_ROW_92_1461 VGND VPWR sky130_fd_sc_hd__tapvpwrvgnd_1
XTAP_TAPCELL_ROW_92_1450 VGND VPWR sky130_fd_sc_hd__tapvpwrvgnd_1
XFILLER_2_699 VGND VGND VPWR VPWR sky130_fd_sc_hd__fill_1
XFILLER_1_187 VGND VGND VPWR VPWR sky130_fd_sc_hd__fill_2
XFILLER_49_125 VGND VGND VPWR VPWR sky130_fd_sc_hd__decap_3
XFILLER_37_309 VGND VGND VPWR VPWR sky130_fd_sc_hd__decap_3
XFILLER_38_61 VGND VGND VPWR VPWR sky130_fd_sc_hd__decap_3
XFILLER_49_169 VGND VGND VPWR VPWR sky130_fd_sc_hd__decap_3
XFILLER_77_489 VGND VGND VPWR VPWR sky130_fd_sc_hd__decap_3
XFILLER_92_404 VGND VGND VPWR VPWR sky130_fd_sc_hd__decap_3
XFILLER_58_681 VGND VGND VPWR VPWR sky130_fd_sc_hd__fill_2
XFILLER_64_128 VGND VGND VPWR VPWR sky130_fd_sc_hd__decap_3
XFILLER_18_545 VGND VGND VPWR VPWR sky130_fd_sc_hd__decap_3
XFILLER_18_556 VGND VGND VPWR VPWR sky130_fd_sc_hd__fill_2
XFILLER_18_589 VGND VGND VPWR VPWR sky130_fd_sc_hd__decap_3
XFILLER_33_526 VGND VGND VPWR VPWR sky130_fd_sc_hd__decap_3
XFILLER_45_386 VGND VGND VPWR VPWR sky130_fd_sc_hd__decap_3
XFILLER_60_301 VGND VGND VPWR VPWR sky130_fd_sc_hd__fill_1
XFILLER_60_323 VGND VGND VPWR VPWR sky130_fd_sc_hd__fill_1
XFILLER_72_172 VGND VGND VPWR VPWR sky130_fd_sc_hd__decap_3
XFILLER_73_673 VGND VGND VPWR VPWR sky130_fd_sc_hd__decap_3
XFILLER_54_71 VGND VGND VPWR VPWR sky130_fd_sc_hd__decap_3
XFILLER_60_334 VGND VGND VPWR VPWR sky130_fd_sc_hd__decap_3
XFILLER_60_356 VGND VGND VPWR VPWR sky130_fd_sc_hd__decap_3
XFILLER_13_250 VGND VGND VPWR VPWR sky130_fd_sc_hd__decap_3
XFILLER_20_209 VGND VGND VPWR VPWR sky130_fd_sc_hd__decap_3
XFILLER_41_570 VGND VGND VPWR VPWR sky130_fd_sc_hd__decap_3
XFILLER_9_221 VGND VGND VPWR VPWR sky130_fd_sc_hd__decap_3
XFILLER_9_287 VGND VGND VPWR VPWR sky130_fd_sc_hd__decap_3
Xclkload13 _8229_/CLK VGND VGND VPWR VPWR clkload13/X sky130_fd_sc_hd__clkbuf_4
Xclkload24 _8384_/CLK VGND VGND VPWR VPWR clkload24/X sky130_fd_sc_hd__clkbuf_4
Xclkload35 _8397_/CLK VGND VGND VPWR VPWR clkload35/X sky130_fd_sc_hd__clkbuf_4
X_5260_ _7694_/B _8190_/Q _5678_/S VGND VGND VPWR VPWR _5260_/X sky130_fd_sc_hd__mux2_2
X_4211_ _4211_/A VGND VGND VPWR VPWR _8043_/D sky130_fd_sc_hd__buf_1
XFILLER_68_412 VGND VGND VPWR VPWR sky130_fd_sc_hd__decap_3
XFILLER_96_721 VGND VGND VPWR VPWR sky130_fd_sc_hd__decap_3
X_5191_ _7838_/B VGND VGND VPWR VPWR _5192_/A sky130_fd_sc_hd__clkbuf_1
XFILLER_110_542 VGND VGND VPWR VPWR sky130_fd_sc_hd__decap_3
XFILLER_68_445 VGND VGND VPWR VPWR sky130_fd_sc_hd__decap_3
XFILLER_95_242 VGND VGND VPWR VPWR sky130_fd_sc_hd__decap_3
X_4142_ _7930_/B _7941_/Q VGND VGND VPWR VPWR _4143_/A sky130_fd_sc_hd__and2_2
XFILLER_28_309 VGND VGND VPWR VPWR sky130_fd_sc_hd__decap_3
XFILLER_49_670 VGND VGND VPWR VPWR sky130_fd_sc_hd__fill_2
XFILLER_55_106 VGND VGND VPWR VPWR sky130_fd_sc_hd__decap_3
XFILLER_68_489 VGND VGND VPWR VPWR sky130_fd_sc_hd__decap_3
XFILLER_95_275 VGND VGND VPWR VPWR sky130_fd_sc_hd__decap_3
X_4073_ _4073_/A VGND VGND VPWR VPWR _7974_/D sky130_fd_sc_hd__buf_1
XFILLER_55_128 VGND VGND VPWR VPWR sky130_fd_sc_hd__decap_3
X_7901_ _7901_/A VGND VGND VPWR VPWR _8387_/D sky130_fd_sc_hd__buf_1
XFILLER_36_342 VGND VGND VPWR VPWR sky130_fd_sc_hd__decap_3
XFILLER_64_651 VGND VGND VPWR VPWR sky130_fd_sc_hd__decap_3
XFILLER_24_515 VGND VGND VPWR VPWR sky130_fd_sc_hd__decap_3
XFILLER_63_172 VGND VGND VPWR VPWR sky130_fd_sc_hd__fill_1
XFILLER_64_684 VGND VGND VPWR VPWR sky130_fd_sc_hd__decap_3
XTAP_TAPCELL_ROW_104_1608 VGND VPWR sky130_fd_sc_hd__tapvpwrvgnd_1
X_7832_ _8223_/Q _8287_/Q VGND VGND VPWR VPWR _7838_/C sky130_fd_sc_hd__nand2_2
XTAP_TAPCELL_ROW_47_871 VGND VPWR sky130_fd_sc_hd__tapvpwrvgnd_1
XFILLER_24_559 VGND VGND VPWR VPWR sky130_fd_sc_hd__fill_2
XFILLER_36_397 VGND VGND VPWR VPWR sky130_fd_sc_hd__decap_3
XFILLER_51_334 VGND VGND VPWR VPWR sky130_fd_sc_hd__fill_2
XFILLER_51_356 VGND VGND VPWR VPWR sky130_fd_sc_hd__fill_2
X_7763_ _7754_/A _7761_/Y _7762_/Y _7796_/A VGND VGND VPWR VPWR _7763_/X sky130_fd_sc_hd__a22o_2
X_4975_ _8208_/Q _7222_/B _4781_/A _4780_/A VGND VGND VPWR VPWR _4976_/A sky130_fd_sc_hd__a31oi_2
X_6714_ _6825_/B _6825_/C _6825_/D VGND VGND VPWR VPWR _7007_/A sky130_fd_sc_hd__or3_2
XFILLER_32_570 VGND VGND VPWR VPWR sky130_fd_sc_hd__decap_3
XFILLER_32_592 VGND VGND VPWR VPWR sky130_fd_sc_hd__decap_3
X_7694_ _7812_/A _7694_/B _7820_/B VGND VGND VPWR VPWR _7694_/X sky130_fd_sc_hd__and3_2
XTAP_TAPCELL_ROW_63_1084 VGND VPWR sky130_fd_sc_hd__tapvpwrvgnd_1
XTAP_TAPCELL_ROW_63_1073 VGND VPWR sky130_fd_sc_hd__tapvpwrvgnd_1
XFILLER_109_108 VGND VGND VPWR VPWR sky130_fd_sc_hd__decap_3
XFILLER_50_29 VGND VGND VPWR VPWR sky130_fd_sc_hd__decap_3
Xclkload7 clkload7/A VGND VGND VPWR VPWR clkload7/X sky130_fd_sc_hd__clkbuf_8
X_6645_ _6648_/A _6645_/B VGND VGND VPWR VPWR _6645_/Y sky130_fd_sc_hd__nand2_2
X_6576_ _6529_/A _7626_/B _6575_/X _5857_/A _7193_/A VGND VGND VPWR VPWR _6576_/X
+ sky130_fd_sc_hd__a221o_2
X_8315_ _8377_/CLK _8315_/D VGND VGND VPWR VPWR _8315_/Q sky130_fd_sc_hd__dfxtp_2
X_5527_ _6086_/A _6462_/B VGND VGND VPWR VPWR _5626_/A sky130_fd_sc_hd__nor2_2
XFILLER_105_314 VGND VGND VPWR VPWR sky130_fd_sc_hd__decap_3
XFILLER_118_697 VGND VGND VPWR VPWR sky130_fd_sc_hd__decap_3
XTAP_TAPCELL_ROW_115_1748 VGND VPWR sky130_fd_sc_hd__tapvpwrvgnd_1
XTAP_TAPCELL_ROW_115_1759 VGND VPWR sky130_fd_sc_hd__tapvpwrvgnd_1
X_8246_ _8377_/CLK _8246_/D VGND VGND VPWR VPWR _8246_/Q sky130_fd_sc_hd__dfxtp_2
XFILLER_59_49 VGND VGND VPWR VPWR sky130_fd_sc_hd__decap_3
XFILLER_78_209 VGND VGND VPWR VPWR sky130_fd_sc_hd__fill_1
X_5458_ _5165_/X _5169_/X _5684_/S VGND VGND VPWR VPWR _5458_/X sky130_fd_sc_hd__mux2_2
X_8177_ clkload8/A _8177_/D VGND VGND VPWR VPWR _8177_/Q sky130_fd_sc_hd__dfxtp_4
X_5389_ _5247_/X _5248_/X _5249_/X _5257_/X _7783_/A _6706_/S VGND VGND VPWR VPWR
+ _5389_/X sky130_fd_sc_hd__mux4_2
X_4409_ _4409_/A VGND VGND VPWR VPWR _8142_/D sky130_fd_sc_hd__buf_1
XFILLER_101_520 VGND VGND VPWR VPWR sky130_fd_sc_hd__decap_3
XFILLER_115_33 VGND VGND VPWR VPWR sky130_fd_sc_hd__decap_3
XFILLER_59_423 VGND VGND VPWR VPWR sky130_fd_sc_hd__decap_3
XFILLER_87_732 VGND VGND VPWR VPWR sky130_fd_sc_hd__fill_1
X_7128_ _8206_/Q _7228_/B _7128_/C VGND VGND VPWR VPWR _7317_/C sky130_fd_sc_hd__and3_2
XFILLER_115_66 VGND VGND VPWR VPWR sky130_fd_sc_hd__decap_3
XFILLER_115_77 VGND VGND VPWR VPWR sky130_fd_sc_hd__decap_3
XFILLER_47_629 VGND VGND VPWR VPWR sky130_fd_sc_hd__fill_2
XFILLER_74_404 VGND VGND VPWR VPWR sky130_fd_sc_hd__decap_3
XFILLER_75_15 VGND VGND VPWR VPWR sky130_fd_sc_hd__decap_3
XFILLER_86_242 VGND VGND VPWR VPWR sky130_fd_sc_hd__decap_3
XFILLER_86_253 VGND VGND VPWR VPWR sky130_fd_sc_hd__fill_2
X_7059_ _8206_/Q _8205_/Q _7796_/A VGND VGND VPWR VPWR _7059_/X sky130_fd_sc_hd__mux2_2
XFILLER_101_586 VGND VGND VPWR VPWR sky130_fd_sc_hd__decap_3
XFILLER_74_448 VGND VGND VPWR VPWR sky130_fd_sc_hd__decap_3
XFILLER_86_297 VGND VGND VPWR VPWR sky130_fd_sc_hd__decap_3
XFILLER_27_364 VGND VGND VPWR VPWR sky130_fd_sc_hd__decap_3
XFILLER_54_150 VGND VGND VPWR VPWR sky130_fd_sc_hd__decap_3
XFILLER_55_673 VGND VGND VPWR VPWR sky130_fd_sc_hd__fill_2
XFILLER_55_695 VGND VGND VPWR VPWR sky130_fd_sc_hd__decap_3
XFILLER_15_559 VGND VGND VPWR VPWR sky130_fd_sc_hd__fill_1
XFILLER_54_183 VGND VGND VPWR VPWR sky130_fd_sc_hd__decap_3
XFILLER_91_25 VGND VGND VPWR VPWR sky130_fd_sc_hd__decap_3
XFILLER_30_507 VGND VGND VPWR VPWR sky130_fd_sc_hd__fill_1
XFILLER_70_665 VGND VGND VPWR VPWR sky130_fd_sc_hd__fill_1
XFILLER_11_721 VGND VGND VPWR VPWR sky130_fd_sc_hd__decap_3
XFILLER_11_732 VGND VGND VPWR VPWR sky130_fd_sc_hd__fill_1
XFILLER_24_52 VGND VGND VPWR VPWR sky130_fd_sc_hd__decap_3
XFILLER_24_85 VGND VGND VPWR VPWR sky130_fd_sc_hd__decap_3
XTAP_TAPCELL_ROW_25_587 VGND VPWR sky130_fd_sc_hd__tapvpwrvgnd_1
XFILLER_10_242 VGND VGND VPWR VPWR sky130_fd_sc_hd__decap_3
XFILLER_10_253 VGND VGND VPWR VPWR sky130_fd_sc_hd__decap_3
XFILLER_109_620 VGND VGND VPWR VPWR sky130_fd_sc_hd__fill_1
XFILLER_109_642 VGND VGND VPWR VPWR sky130_fd_sc_hd__fill_1
XFILLER_10_286 VGND VGND VPWR VPWR sky130_fd_sc_hd__fill_1
XFILLER_6_213 VGND VGND VPWR VPWR sky130_fd_sc_hd__decap_3
XFILLER_6_235 VGND VGND VPWR VPWR sky130_fd_sc_hd__decap_3
XFILLER_2_430 VGND VGND VPWR VPWR sky130_fd_sc_hd__decap_3
XFILLER_111_306 VGND VGND VPWR VPWR sky130_fd_sc_hd__decap_3
XFILLER_104_380 VGND VGND VPWR VPWR sky130_fd_sc_hd__fill_2
XFILLER_104_391 VGND VGND VPWR VPWR sky130_fd_sc_hd__decap_3
XFILLER_49_60 VGND VGND VPWR VPWR sky130_fd_sc_hd__decap_3
XFILLER_77_231 VGND VGND VPWR VPWR sky130_fd_sc_hd__decap_3
XFILLER_77_264 VGND VGND VPWR VPWR sky130_fd_sc_hd__decap_3
XFILLER_93_713 VGND VGND VPWR VPWR sky130_fd_sc_hd__decap_3
XFILLER_65_426 VGND VGND VPWR VPWR sky130_fd_sc_hd__decap_3
XFILLER_92_212 VGND VGND VPWR VPWR sky130_fd_sc_hd__decap_3
XFILLER_18_331 VGND VGND VPWR VPWR sky130_fd_sc_hd__decap_3
XFILLER_92_234 VGND VGND VPWR VPWR sky130_fd_sc_hd__decap_3
XFILLER_92_267 VGND VGND VPWR VPWR sky130_fd_sc_hd__decap_3
XFILLER_33_312 VGND VGND VPWR VPWR sky130_fd_sc_hd__decap_3
XFILLER_45_172 VGND VGND VPWR VPWR sky130_fd_sc_hd__decap_3
XFILLER_52_109 VGND VGND VPWR VPWR sky130_fd_sc_hd__decap_3
XFILLER_61_610 VGND VGND VPWR VPWR sky130_fd_sc_hd__decap_3
XFILLER_65_81 VGND VGND VPWR VPWR sky130_fd_sc_hd__decap_3
XFILLER_73_470 VGND VGND VPWR VPWR sky130_fd_sc_hd__decap_3
XFILLER_60_131 VGND VGND VPWR VPWR sky130_fd_sc_hd__decap_3
XFILLER_61_632 VGND VGND VPWR VPWR sky130_fd_sc_hd__decap_3
XTAP_TAPCELL_ROW_44_830 VGND VPWR sky130_fd_sc_hd__tapvpwrvgnd_1
XFILLER_33_367 VGND VGND VPWR VPWR sky130_fd_sc_hd__decap_3
XFILLER_60_153 VGND VGND VPWR VPWR sky130_fd_sc_hd__decap_3
XFILLER_14_592 VGND VGND VPWR VPWR sky130_fd_sc_hd__decap_3
XFILLER_60_186 VGND VGND VPWR VPWR sky130_fd_sc_hd__decap_3
XFILLER_60_197 VGND VGND VPWR VPWR sky130_fd_sc_hd__decap_3
X_4760_ _7366_/B _4980_/A VGND VGND VPWR VPWR _7398_/A sky130_fd_sc_hd__or2_2
XPHY_EDGE_ROW_112_Right_112 VGND VGND VPWR VPWR sky130_fd_sc_hd__decap_3
X_4691_ _4691_/A VGND VGND VPWR VPWR _8283_/D sky130_fd_sc_hd__buf_1
X_6430_ _8290_/Q _6416_/X _6418_/X _5812_/A _6429_/Y VGND VGND VPWR VPWR _6430_/X
+ sky130_fd_sc_hd__a221o_2
X_6361_ _8248_/Q _6306_/X _8184_/Q VGND VGND VPWR VPWR _6361_/X sky130_fd_sc_hd__o21ba_4
XPHY_EDGE_ROW_49_Right_49 VGND VGND VPWR VPWR sky130_fd_sc_hd__decap_3
X_8100_ clkload8/A _8100_/D VGND VGND VPWR VPWR _8100_/Q sky130_fd_sc_hd__dfxtp_2
X_5312_ _5316_/A _5312_/B VGND VGND VPWR VPWR _5312_/X sky130_fd_sc_hd__xor2_2
XFILLER_114_144 VGND VGND VPWR VPWR sky130_fd_sc_hd__decap_3
X_6292_ _8180_/Q _8244_/Q _8246_/Q _4890_/B VGND VGND VPWR VPWR _6292_/X sky130_fd_sc_hd__a22o_2
XFILLER_88_518 VGND VGND VPWR VPWR sky130_fd_sc_hd__fill_2
X_8031_ clkload3/A _8031_/D VGND VGND VPWR VPWR _8031_/Q sky130_fd_sc_hd__dfxtp_2
X_5243_ _7747_/A VGND VGND VPWR VPWR _7827_/A sky130_fd_sc_hd__buf_1
XFILLER_68_231 VGND VGND VPWR VPWR sky130_fd_sc_hd__decap_3
XFILLER_69_732 VGND VGND VPWR VPWR sky130_fd_sc_hd__fill_1
X_5174_ _5166_/X _5173_/X _6818_/S VGND VGND VPWR VPWR _5174_/X sky130_fd_sc_hd__mux2_2
XFILLER_29_607 VGND VGND VPWR VPWR sky130_fd_sc_hd__fill_1
XFILLER_56_404 VGND VGND VPWR VPWR sky130_fd_sc_hd__decap_3
XFILLER_68_242 VGND VGND VPWR VPWR sky130_fd_sc_hd__decap_3
XFILLER_96_562 VGND VGND VPWR VPWR sky130_fd_sc_hd__decap_3
XTAP_TAPCELL_ROW_110_1689 VGND VPWR sky130_fd_sc_hd__tapvpwrvgnd_1
X_4125_ _4125_/A VGND VGND VPWR VPWR _8000_/D sky130_fd_sc_hd__buf_1
XFILLER_110_372 VGND VGND VPWR VPWR sky130_fd_sc_hd__decap_3
XFILLER_28_106 VGND VGND VPWR VPWR sky130_fd_sc_hd__decap_3
XFILLER_68_275 VGND VGND VPWR VPWR sky130_fd_sc_hd__decap_3
XFILLER_45_29 VGND VGND VPWR VPWR sky130_fd_sc_hd__decap_3
XFILLER_83_256 VGND VGND VPWR VPWR sky130_fd_sc_hd__decap_3
XPHY_EDGE_ROW_58_Right_58 VGND VGND VPWR VPWR sky130_fd_sc_hd__decap_3
X_4056_ _7930_/B _8369_/Q VGND VGND VPWR VPWR _4057_/A sky130_fd_sc_hd__and2_2
XFILLER_37_673 VGND VGND VPWR VPWR sky130_fd_sc_hd__decap_3
XFILLER_43_109 VGND VGND VPWR VPWR sky130_fd_sc_hd__decap_3
XFILLER_83_289 VGND VGND VPWR VPWR sky130_fd_sc_hd__decap_3
XTAP_TAPCELL_ROW_65_1102 VGND VPWR sky130_fd_sc_hd__tapvpwrvgnd_1
XFILLER_101_24 VGND VGND VPWR VPWR sky130_fd_sc_hd__decap_3
XFILLER_24_312 VGND VGND VPWR VPWR sky130_fd_sc_hd__fill_2
XFILLER_24_334 VGND VGND VPWR VPWR sky130_fd_sc_hd__decap_3
XFILLER_52_643 VGND VGND VPWR VPWR sky130_fd_sc_hd__fill_1
XFILLER_64_492 VGND VGND VPWR VPWR sky130_fd_sc_hd__decap_3
X_7815_ _5684_/S _7656_/B _5346_/Y _7814_/Y VGND VGND VPWR VPWR _7815_/X sky130_fd_sc_hd__a31o_2
XFILLER_101_57 VGND VGND VPWR VPWR sky130_fd_sc_hd__decap_3
XFILLER_12_507 VGND VGND VPWR VPWR sky130_fd_sc_hd__decap_3
XFILLER_24_356 VGND VGND VPWR VPWR sky130_fd_sc_hd__decap_3
XFILLER_51_131 VGND VGND VPWR VPWR sky130_fd_sc_hd__decap_3
XFILLER_51_164 VGND VGND VPWR VPWR sky130_fd_sc_hd__decap_3
XFILLER_24_389 VGND VGND VPWR VPWR sky130_fd_sc_hd__decap_3
XFILLER_61_39 VGND VGND VPWR VPWR sky130_fd_sc_hd__decap_3
X_7746_ _7825_/B _7746_/B VGND VGND VPWR VPWR _7747_/B sky130_fd_sc_hd__nand2_2
X_4958_ _4958_/A VGND VGND VPWR VPWR _4960_/A sky130_fd_sc_hd__inv_2
XFILLER_20_551 VGND VGND VPWR VPWR sky130_fd_sc_hd__decap_3
X_7677_ _7797_/A1 _8222_/Q _5121_/A _5579_/S VGND VGND VPWR VPWR _7677_/Y sky130_fd_sc_hd__a211oi_2
X_4889_ _4890_/B _8246_/Q VGND VGND VPWR VPWR _6393_/A sky130_fd_sc_hd__and2b_2
XTAP_TAPCELL_ROW_22_546 VGND VPWR sky130_fd_sc_hd__tapvpwrvgnd_1
XFILLER_20_573 VGND VGND VPWR VPWR sky130_fd_sc_hd__decap_3
X_6628_ _8290_/Q _6614_/X _6619_/X _6721_/A _6627_/X VGND VGND VPWR VPWR _6628_/X
+ sky130_fd_sc_hd__a221o_2
XFILLER_117_6 VGND VGND VPWR VPWR sky130_fd_sc_hd__decap_3
XFILLER_20_595 VGND VGND VPWR VPWR sky130_fd_sc_hd__decap_3
XPHY_EDGE_ROW_67_Right_67 VGND VGND VPWR VPWR sky130_fd_sc_hd__decap_3
XFILLER_106_623 VGND VGND VPWR VPWR sky130_fd_sc_hd__decap_3
X_6559_ _8254_/Q _6523_/B _6558_/X VGND VGND VPWR VPWR _6560_/B sky130_fd_sc_hd__o21a_2
XTAP_TAPCELL_ROW_76_1242 VGND VPWR sky130_fd_sc_hd__tapvpwrvgnd_1
XFILLER_105_111 VGND VGND VPWR VPWR sky130_fd_sc_hd__fill_1
XFILLER_10_32 VGND VGND VPWR VPWR sky130_fd_sc_hd__decap_3
XFILLER_10_43 VGND VGND VPWR VPWR sky130_fd_sc_hd__decap_3
XPHY_EDGE_ROW_5_Left_125 VGND VGND VPWR VPWR sky130_fd_sc_hd__decap_3
XTAP_TAPCELL_ROW_76_1253 VGND VPWR sky130_fd_sc_hd__tapvpwrvgnd_1
XFILLER_105_166 VGND VGND VPWR VPWR sky130_fd_sc_hd__fill_2
XFILLER_10_65 VGND VGND VPWR VPWR sky130_fd_sc_hd__decap_3
XFILLER_79_529 VGND VGND VPWR VPWR sky130_fd_sc_hd__decap_3
X_8229_ _8229_/CLK _8229_/D VGND VGND VPWR VPWR _8229_/Q sky130_fd_sc_hd__dfxtp_4
XFILLER_105_199 VGND VGND VPWR VPWR sky130_fd_sc_hd__decap_3
XFILLER_19_106 VGND VGND VPWR VPWR sky130_fd_sc_hd__decap_3
XFILLER_19_128 VGND VGND VPWR VPWR sky130_fd_sc_hd__decap_3
XFILLER_19_52 VGND VGND VPWR VPWR sky130_fd_sc_hd__decap_3
XFILLER_19_63 VGND VGND VPWR VPWR sky130_fd_sc_hd__decap_3
XFILLER_47_426 VGND VGND VPWR VPWR sky130_fd_sc_hd__decap_3
XFILLER_74_212 VGND VGND VPWR VPWR sky130_fd_sc_hd__decap_3
XFILLER_87_595 VGND VGND VPWR VPWR sky130_fd_sc_hd__decap_3
XPHY_EDGE_ROW_76_Right_76 VGND VGND VPWR VPWR sky130_fd_sc_hd__decap_3
XFILLER_28_651 VGND VGND VPWR VPWR sky130_fd_sc_hd__decap_3
XFILLER_74_245 VGND VGND VPWR VPWR sky130_fd_sc_hd__decap_3
XFILLER_74_256 VGND VGND VPWR VPWR sky130_fd_sc_hd__decap_3
XFILLER_34_109 VGND VGND VPWR VPWR sky130_fd_sc_hd__decap_3
XFILLER_62_418 VGND VGND VPWR VPWR sky130_fd_sc_hd__fill_2
XFILLER_74_289 VGND VGND VPWR VPWR sky130_fd_sc_hd__fill_1
XTAP_TAPCELL_ROW_2_282 VGND VPWR sky130_fd_sc_hd__tapvpwrvgnd_1
XFILLER_15_312 VGND VGND VPWR VPWR sky130_fd_sc_hd__decap_3
XTAP_TAPCELL_ROW_87_1393 VGND VPWR sky130_fd_sc_hd__tapvpwrvgnd_1
XFILLER_35_73 VGND VGND VPWR VPWR sky130_fd_sc_hd__decap_3
XFILLER_30_315 VGND VGND VPWR VPWR sky130_fd_sc_hd__decap_3
XFILLER_30_326 VGND VGND VPWR VPWR sky130_fd_sc_hd__decap_3
XFILLER_42_197 VGND VGND VPWR VPWR sky130_fd_sc_hd__decap_3
XFILLER_70_473 VGND VGND VPWR VPWR sky130_fd_sc_hd__decap_3
XFILLER_51_72 VGND VGND VPWR VPWR sky130_fd_sc_hd__fill_1
XFILLER_7_511 VGND VGND VPWR VPWR sky130_fd_sc_hd__fill_2
XPHY_EDGE_ROW_85_Right_85 VGND VGND VPWR VPWR sky130_fd_sc_hd__decap_3
Xmax_cap219 _5299_/X VGND VGND VPWR VPWR _5319_/A sky130_fd_sc_hd__buf_6
XFILLER_109_494 VGND VGND VPWR VPWR sky130_fd_sc_hd__decap_3
XFILLER_112_604 VGND VGND VPWR VPWR sky130_fd_sc_hd__decap_3
XFILLER_112_648 VGND VGND VPWR VPWR sky130_fd_sc_hd__decap_3
XFILLER_97_337 VGND VGND VPWR VPWR sky130_fd_sc_hd__fill_2
XFILLER_97_359 VGND VGND VPWR VPWR sky130_fd_sc_hd__fill_1
XFILLER_111_147 VGND VGND VPWR VPWR sky130_fd_sc_hd__decap_3
XFILLER_111_169 VGND VGND VPWR VPWR sky130_fd_sc_hd__fill_1
XFILLER_66_713 VGND VGND VPWR VPWR sky130_fd_sc_hd__decap_3
XPHY_EDGE_ROW_94_Right_94 VGND VGND VPWR VPWR sky130_fd_sc_hd__decap_3
XTAP_TAPCELL_ROW_49_900 VGND VPWR sky130_fd_sc_hd__tapvpwrvgnd_1
XFILLER_38_426 VGND VGND VPWR VPWR sky130_fd_sc_hd__decap_3
XFILLER_78_595 VGND VGND VPWR VPWR sky130_fd_sc_hd__fill_2
XFILLER_93_532 VGND VGND VPWR VPWR sky130_fd_sc_hd__decap_3
XFILLER_19_651 VGND VGND VPWR VPWR sky130_fd_sc_hd__decap_3
XFILLER_38_459 VGND VGND VPWR VPWR sky130_fd_sc_hd__decap_3
XFILLER_65_234 VGND VGND VPWR VPWR sky130_fd_sc_hd__decap_3
XFILLER_76_80 VGND VGND VPWR VPWR sky130_fd_sc_hd__decap_3
XFILLER_18_150 VGND VGND VPWR VPWR sky130_fd_sc_hd__decap_3
XFILLER_19_673 VGND VGND VPWR VPWR sky130_fd_sc_hd__decap_3
XFILLER_25_109 VGND VGND VPWR VPWR sky130_fd_sc_hd__decap_3
XFILLER_53_429 VGND VGND VPWR VPWR sky130_fd_sc_hd__decap_3
XFILLER_65_278 VGND VGND VPWR VPWR sky130_fd_sc_hd__fill_2
XFILLER_81_716 VGND VGND VPWR VPWR sky130_fd_sc_hd__fill_2
XFILLER_81_727 VGND VGND VPWR VPWR sky130_fd_sc_hd__fill_1
XFILLER_93_576 VGND VGND VPWR VPWR sky130_fd_sc_hd__decap_3
XPHY_EDGE_ROW_69_Left_189 VGND VGND VPWR VPWR sky130_fd_sc_hd__decap_3
X_5930_ _8172_/Q _8236_/Q _5874_/X _5906_/X VGND VGND VPWR VPWR _5930_/X sky130_fd_sc_hd__a211o_4
XFILLER_46_492 VGND VGND VPWR VPWR sky130_fd_sc_hd__fill_2
XFILLER_34_654 VGND VGND VPWR VPWR sky130_fd_sc_hd__decap_3
XFILLER_80_259 VGND VGND VPWR VPWR sky130_fd_sc_hd__decap_3
X_7600_ _8222_/Q _8286_/Q _7619_/A VGND VGND VPWR VPWR _7600_/X sky130_fd_sc_hd__o21a_2
X_5861_ _5860_/X _5780_/X _5678_/X _5594_/X _7812_/A _7670_/A VGND VGND VPWR VPWR
+ _5861_/X sky130_fd_sc_hd__mux4_2
XFILLER_21_337 VGND VGND VPWR VPWR sky130_fd_sc_hd__decap_3
XFILLER_61_473 VGND VGND VPWR VPWR sky130_fd_sc_hd__decap_3
X_5792_ _5026_/B _5756_/X _5719_/Y VGND VGND VPWR VPWR _5792_/X sky130_fd_sc_hd__o21a_2
X_4812_ _8203_/Q _4813_/B VGND VGND VPWR VPWR _4814_/A sky130_fd_sc_hd__nand2_2
X_7531_ _8229_/Q _6454_/Y _6458_/Y _7530_/Y VGND VGND VPWR VPWR _7531_/Y sky130_fd_sc_hd__a22oi_2
X_4743_ _8281_/Q _8217_/Q VGND VGND VPWR VPWR _4744_/B sky130_fd_sc_hd__nor2b_2
XTAP_TAPCELL_ROW_60_1043 VGND VPWR sky130_fd_sc_hd__tapvpwrvgnd_1
X_7462_ _7463_/A _7463_/B VGND VGND VPWR VPWR _7462_/Y sky130_fd_sc_hd__nand2_2
XPHY_EDGE_ROW_78_Left_198 VGND VGND VPWR VPWR sky130_fd_sc_hd__decap_3
X_6413_ _8187_/Q _5399_/X _5718_/X _8251_/Q VGND VGND VPWR VPWR _6413_/X sky130_fd_sc_hd__a2bb2o_2
X_4674_ _7930_/B _8141_/Q VGND VGND VPWR VPWR _4675_/A sky130_fd_sc_hd__and2_2
X_7393_ _8214_/Q _8278_/Q _7394_/C VGND VGND VPWR VPWR _7393_/Y sky130_fd_sc_hd__nand3_2
XFILLER_115_431 VGND VGND VPWR VPWR sky130_fd_sc_hd__decap_3
X_6344_ _8185_/Q _8249_/Q _6999_/A1 VGND VGND VPWR VPWR _6344_/X sky130_fd_sc_hd__o21a_2
XFILLER_0_219 VGND VGND VPWR VPWR sky130_fd_sc_hd__decap_3
XFILLER_103_626 VGND VGND VPWR VPWR sky130_fd_sc_hd__decap_3
XTAP_TAPCELL_ROW_112_1718 VGND VPWR sky130_fd_sc_hd__tapvpwrvgnd_1
X_6275_ _6274_/X _6127_/X _6706_/S VGND VGND VPWR VPWR _6275_/X sky130_fd_sc_hd__mux2_2
XFILLER_102_114 VGND VGND VPWR VPWR sky130_fd_sc_hd__decap_3
XFILLER_115_497 VGND VGND VPWR VPWR sky130_fd_sc_hd__decap_3
XFILLER_88_326 VGND VGND VPWR VPWR sky130_fd_sc_hd__decap_3
X_8014_ _8390_/CLK _8014_/D VGND VGND VPWR VPWR _8014_/Q sky130_fd_sc_hd__dfxtp_2
Xinput109 operand_b[45] VGND VGND VPWR VPWR _4394_/B sky130_fd_sc_hd__clkdlybuf4s25_1
X_5226_ _8197_/Q _8198_/Q _6380_/S VGND VGND VPWR VPWR _5226_/X sky130_fd_sc_hd__mux2_2
XFILLER_102_147 VGND VGND VPWR VPWR sky130_fd_sc_hd__decap_3
XFILLER_29_426 VGND VGND VPWR VPWR sky130_fd_sc_hd__decap_3
XFILLER_56_212 VGND VGND VPWR VPWR sky130_fd_sc_hd__decap_3
XFILLER_69_573 VGND VGND VPWR VPWR sky130_fd_sc_hd__decap_3
XFILLER_69_595 VGND VGND VPWR VPWR sky130_fd_sc_hd__decap_3
XFILLER_84_521 VGND VGND VPWR VPWR sky130_fd_sc_hd__decap_3
X_5157_ _5155_/X _5156_/X _5634_/S VGND VGND VPWR VPWR _5157_/X sky130_fd_sc_hd__mux2_2
XTAP_TAPCELL_ROW_71_1183 VGND VPWR sky130_fd_sc_hd__tapvpwrvgnd_1
XFILLER_56_245 VGND VGND VPWR VPWR sky130_fd_sc_hd__decap_3
XFILLER_96_392 VGND VGND VPWR VPWR sky130_fd_sc_hd__decap_3
X_5088_ _5107_/B VGND VGND VPWR VPWR _6462_/B sky130_fd_sc_hd__clkbuf_1
X_4108_ _7930_/B _8395_/Q VGND VGND VPWR VPWR _4109_/A sky130_fd_sc_hd__and2_2
XFILLER_37_470 VGND VGND VPWR VPWR sky130_fd_sc_hd__decap_3
XFILLER_44_407 VGND VGND VPWR VPWR sky130_fd_sc_hd__decap_3
XFILLER_56_267 VGND VGND VPWR VPWR sky130_fd_sc_hd__decap_3
XFILLER_71_215 VGND VGND VPWR VPWR sky130_fd_sc_hd__fill_1
X_4039_ _4039_/A VGND VGND VPWR VPWR _7957_/D sky130_fd_sc_hd__buf_1
XTAP_TAPCELL_ROW_27_616 VGND VPWR sky130_fd_sc_hd__tapvpwrvgnd_1
XTAP_TAPCELL_ROW_27_605 VGND VPWR sky130_fd_sc_hd__tapvpwrvgnd_1
XFILLER_37_492 VGND VGND VPWR VPWR sky130_fd_sc_hd__decap_3
XTAP_TAPCELL_ROW_55_969 VGND VPWR sky130_fd_sc_hd__tapvpwrvgnd_1
XFILLER_24_153 VGND VGND VPWR VPWR sky130_fd_sc_hd__decap_3
XFILLER_25_654 VGND VGND VPWR VPWR sky130_fd_sc_hd__decap_3
XFILLER_52_451 VGND VGND VPWR VPWR sky130_fd_sc_hd__fill_1
XFILLER_71_259 VGND VGND VPWR VPWR sky130_fd_sc_hd__decap_3
XFILLER_24_186 VGND VGND VPWR VPWR sky130_fd_sc_hd__decap_3
XFILLER_40_635 VGND VGND VPWR VPWR sky130_fd_sc_hd__fill_1
XFILLER_24_197 VGND VGND VPWR VPWR sky130_fd_sc_hd__decap_3
XFILLER_40_668 VGND VGND VPWR VPWR sky130_fd_sc_hd__decap_3
X_7729_ _8183_/Q _7672_/A _7681_/X VGND VGND VPWR VPWR _7729_/Y sky130_fd_sc_hd__o21ai_2
XFILLER_20_392 VGND VGND VPWR VPWR sky130_fd_sc_hd__decap_3
XFILLER_115_3 VGND VGND VPWR VPWR sky130_fd_sc_hd__decap_3
XFILLER_4_525 VGND VGND VPWR VPWR sky130_fd_sc_hd__decap_3
XFILLER_4_547 VGND VGND VPWR VPWR sky130_fd_sc_hd__decap_3
XFILLER_106_464 VGND VGND VPWR VPWR sky130_fd_sc_hd__decap_3
XFILLER_97_35 VGND VGND VPWR VPWR sky130_fd_sc_hd__decap_3
XFILLER_79_337 VGND VGND VPWR VPWR sky130_fd_sc_hd__decap_3
XFILLER_79_348 VGND VGND VPWR VPWR sky130_fd_sc_hd__decap_3
XFILLER_94_307 VGND VGND VPWR VPWR sky130_fd_sc_hd__fill_1
XTAP_TAPCELL_ROW_7_352 VGND VPWR sky130_fd_sc_hd__tapvpwrvgnd_1
XFILLER_47_212 VGND VGND VPWR VPWR sky130_fd_sc_hd__decap_3
XFILLER_94_329 VGND VGND VPWR VPWR sky130_fd_sc_hd__decap_3
XTAP_TAPCELL_ROW_89_1422 VGND VPWR sky130_fd_sc_hd__tapvpwrvgnd_1
XTAP_TAPCELL_ROW_89_1411 VGND VPWR sky130_fd_sc_hd__tapvpwrvgnd_1
XFILLER_47_223 VGND VGND VPWR VPWR sky130_fd_sc_hd__fill_1
XFILLER_75_532 VGND VGND VPWR VPWR sky130_fd_sc_hd__decap_3
XFILLER_35_429 VGND VGND VPWR VPWR sky130_fd_sc_hd__decap_3
XFILLER_90_502 VGND VGND VPWR VPWR sky130_fd_sc_hd__decap_3
XFILLER_16_621 VGND VGND VPWR VPWR sky130_fd_sc_hd__decap_3
XFILLER_46_83 VGND VGND VPWR VPWR sky130_fd_sc_hd__fill_1
XFILLER_16_654 VGND VGND VPWR VPWR sky130_fd_sc_hd__decap_3
XFILLER_90_568 VGND VGND VPWR VPWR sky130_fd_sc_hd__decap_3
XFILLER_15_164 VGND VGND VPWR VPWR sky130_fd_sc_hd__decap_3
XFILLER_16_698 VGND VGND VPWR VPWR sky130_fd_sc_hd__fill_2
XFILLER_30_101 VGND VGND VPWR VPWR sky130_fd_sc_hd__fill_2
XFILLER_31_624 VGND VGND VPWR VPWR sky130_fd_sc_hd__decap_3
XFILLER_30_123 VGND VGND VPWR VPWR sky130_fd_sc_hd__decap_3
XFILLER_30_156 VGND VGND VPWR VPWR sky130_fd_sc_hd__fill_1
XFILLER_11_381 VGND VGND VPWR VPWR sky130_fd_sc_hd__decap_3
XFILLER_7_44 VGND VGND VPWR VPWR sky130_fd_sc_hd__decap_3
XFILLER_117_729 VGND VGND VPWR VPWR sky130_fd_sc_hd__decap_3
XFILLER_7_352 VGND VGND VPWR VPWR sky130_fd_sc_hd__decap_3
XFILLER_7_374 VGND VGND VPWR VPWR sky130_fd_sc_hd__decap_3
XFILLER_7_66 VGND VGND VPWR VPWR sky130_fd_sc_hd__decap_3
XFILLER_7_396 VGND VGND VPWR VPWR sky130_fd_sc_hd__decap_3
X_4390_ _7930_/B _4390_/B VGND VGND VPWR VPWR _4391_/A sky130_fd_sc_hd__and2_2
XFILLER_112_401 VGND VGND VPWR VPWR sky130_fd_sc_hd__fill_1
XFILLER_98_613 VGND VGND VPWR VPWR sky130_fd_sc_hd__fill_1
XFILLER_112_434 VGND VGND VPWR VPWR sky130_fd_sc_hd__fill_1
XFILLER_30_3 VGND VGND VPWR VPWR sky130_fd_sc_hd__decap_3
Xload_slew255 _7843_/A VGND VGND VPWR VPWR _7930_/B sky130_fd_sc_hd__clkbuf_16
X_6060_ _6059_/X _5749_/A _6648_/A VGND VGND VPWR VPWR _6061_/A sky130_fd_sc_hd__mux2_2
XFILLER_112_489 VGND VGND VPWR VPWR sky130_fd_sc_hd__decap_3
XFILLER_97_178 VGND VGND VPWR VPWR sky130_fd_sc_hd__decap_3
X_5011_ _6706_/S _5318_/B _4968_/A _5430_/B _5010_/X VGND VGND VPWR VPWR _5011_/X
+ sky130_fd_sc_hd__a221o_2
XFILLER_78_392 VGND VGND VPWR VPWR sky130_fd_sc_hd__decap_3
XFILLER_93_340 VGND VGND VPWR VPWR sky130_fd_sc_hd__decap_3
XFILLER_26_407 VGND VGND VPWR VPWR sky130_fd_sc_hd__decap_3
XFILLER_38_267 VGND VGND VPWR VPWR sky130_fd_sc_hd__decap_3
XFILLER_38_289 VGND VGND VPWR VPWR sky130_fd_sc_hd__fill_1
XFILLER_66_598 VGND VGND VPWR VPWR sky130_fd_sc_hd__decap_3
XFILLER_81_502 VGND VGND VPWR VPWR sky130_fd_sc_hd__fill_2
XFILLER_93_373 VGND VGND VPWR VPWR sky130_fd_sc_hd__decap_3
XFILLER_19_481 VGND VGND VPWR VPWR sky130_fd_sc_hd__decap_3
XFILLER_53_237 VGND VGND VPWR VPWR sky130_fd_sc_hd__decap_3
XTAP_TAPCELL_ROW_109_1680 VGND VPWR sky130_fd_sc_hd__tapvpwrvgnd_1
X_6962_ _7076_/B _6963_/B VGND VGND VPWR VPWR _6964_/B sky130_fd_sc_hd__nand2_2
X_6893_ _5674_/X _6892_/Y _5683_/X VGND VGND VPWR VPWR _6893_/X sky130_fd_sc_hd__a21o_2
X_5913_ _6130_/B _5913_/B VGND VGND VPWR VPWR _5913_/Y sky130_fd_sc_hd__nand2_2
XFILLER_34_462 VGND VGND VPWR VPWR sky130_fd_sc_hd__fill_1
X_5844_ _6769_/A _5843_/X _5701_/X _8172_/Q VGND VGND VPWR VPWR _5844_/X sky130_fd_sc_hd__o2bb2a_2
XTAP_TAPCELL_ROW_52_939 VGND VPWR sky130_fd_sc_hd__tapvpwrvgnd_1
XFILLER_21_145 VGND VGND VPWR VPWR sky130_fd_sc_hd__decap_3
XFILLER_22_657 VGND VGND VPWR VPWR sky130_fd_sc_hd__decap_3
XFILLER_61_281 VGND VGND VPWR VPWR sky130_fd_sc_hd__decap_3
XFILLER_61_292 VGND VGND VPWR VPWR sky130_fd_sc_hd__decap_3
XPHY_EDGE_ROW_86_Left_206 VGND VGND VPWR VPWR sky130_fd_sc_hd__decap_3
X_7514_ _8219_/Q _8283_/Q VGND VGND VPWR VPWR _7514_/Y sky130_fd_sc_hd__nand2_2
X_5775_ _7646_/A _5773_/Y _5774_/X VGND VGND VPWR VPWR _5775_/X sky130_fd_sc_hd__o21a_2
XTAP_TAPCELL_ROW_32_674 VGND VPWR sky130_fd_sc_hd__tapvpwrvgnd_1
X_4726_ _8285_/Q VGND VGND VPWR VPWR _7585_/B sky130_fd_sc_hd__inv_2
XFILLER_107_217 VGND VGND VPWR VPWR sky130_fd_sc_hd__decap_3
X_7445_ _6769_/B _7444_/X _5293_/Y _8217_/Q VGND VGND VPWR VPWR _7445_/X sky130_fd_sc_hd__a2bb2o_2
X_4657_ _4657_/A VGND VGND VPWR VPWR _8266_/D sky130_fd_sc_hd__buf_1
X_7376_ _7374_/Y _7375_/X _5966_/X VGND VGND VPWR VPWR _7376_/Y sky130_fd_sc_hd__a21oi_2
Xinput91 operand_b[29] VGND VGND VPWR VPWR _4362_/B sky130_fd_sc_hd__clkdlybuf4s25_1
Xinput80 operand_b[19] VGND VGND VPWR VPWR _4342_/B sky130_fd_sc_hd__clkdlybuf4s25_1
X_6327_ _5158_/X _5173_/X _5136_/X _5151_/X _6708_/A _7745_/A VGND VGND VPWR VPWR
+ _6327_/X sky130_fd_sc_hd__mux4_2
X_4588_ _7898_/B _8098_/Q VGND VGND VPWR VPWR _4589_/A sky130_fd_sc_hd__and2_2
XTAP_TAPCELL_ROW_73_1212 VGND VPWR sky130_fd_sc_hd__tapvpwrvgnd_1
XFILLER_103_423 VGND VGND VPWR VPWR sky130_fd_sc_hd__decap_3
XFILLER_107_34 VGND VGND VPWR VPWR sky130_fd_sc_hd__decap_3
XFILLER_115_261 VGND VGND VPWR VPWR sky130_fd_sc_hd__decap_3
XFILLER_88_112 VGND VGND VPWR VPWR sky130_fd_sc_hd__decap_3
XFILLER_89_635 VGND VGND VPWR VPWR sky130_fd_sc_hd__fill_2
XFILLER_89_657 VGND VGND VPWR VPWR sky130_fd_sc_hd__fill_2
XFILLER_89_679 VGND VGND VPWR VPWR sky130_fd_sc_hd__decap_3
X_6258_ _8246_/Q _6222_/X _6257_/X VGND VGND VPWR VPWR _6258_/X sky130_fd_sc_hd__o21a_4
XFILLER_69_381 VGND VGND VPWR VPWR sky130_fd_sc_hd__decap_3
XPHY_EDGE_ROW_95_Left_215 VGND VGND VPWR VPWR sky130_fd_sc_hd__decap_3
X_6189_ _6999_/A1 _6186_/X _6188_/X VGND VGND VPWR VPWR _6189_/X sky130_fd_sc_hd__a21o_2
X_5209_ _5579_/S _5209_/B VGND VGND VPWR VPWR _5209_/X sky130_fd_sc_hd__and2b_2
XTAP_TAPCELL_ROW_4_311 VGND VPWR sky130_fd_sc_hd__tapvpwrvgnd_1
XFILLER_57_532 VGND VGND VPWR VPWR sky130_fd_sc_hd__fill_1
XFILLER_57_543 VGND VGND VPWR VPWR sky130_fd_sc_hd__decap_3
XFILLER_17_418 VGND VGND VPWR VPWR sky130_fd_sc_hd__decap_3
XFILLER_57_576 VGND VGND VPWR VPWR sky130_fd_sc_hd__decap_3
XFILLER_84_351 VGND VGND VPWR VPWR sky130_fd_sc_hd__decap_3
XFILLER_44_215 VGND VGND VPWR VPWR sky130_fd_sc_hd__decap_3
XFILLER_72_524 VGND VGND VPWR VPWR sky130_fd_sc_hd__decap_3
XFILLER_44_259 VGND VGND VPWR VPWR sky130_fd_sc_hd__fill_1
XTAP_TAPCELL_ROW_84_1352 VGND VPWR sky130_fd_sc_hd__tapvpwrvgnd_1
XFILLER_25_462 VGND VGND VPWR VPWR sky130_fd_sc_hd__decap_3
XFILLER_12_123 VGND VGND VPWR VPWR sky130_fd_sc_hd__decap_3
XFILLER_40_421 VGND VGND VPWR VPWR sky130_fd_sc_hd__decap_3
XFILLER_40_454 VGND VGND VPWR VPWR sky130_fd_sc_hd__decap_3
XFILLER_52_281 VGND VGND VPWR VPWR sky130_fd_sc_hd__decap_3
XFILLER_12_156 VGND VGND VPWR VPWR sky130_fd_sc_hd__decap_3
XFILLER_13_679 VGND VGND VPWR VPWR sky130_fd_sc_hd__decap_3
XFILLER_32_41 VGND VGND VPWR VPWR sky130_fd_sc_hd__decap_3
XFILLER_32_85 VGND VGND VPWR VPWR sky130_fd_sc_hd__decap_3
Xrebuffer950 _6674_/X VGND VGND VPWR VPWR _6675_/A sky130_fd_sc_hd__buf_6
XFILLER_4_333 VGND VGND VPWR VPWR sky130_fd_sc_hd__decap_3
XFILLER_106_283 VGND VGND VPWR VPWR sky130_fd_sc_hd__fill_1
XTAP_TAPCELL_ROW_95_1492 VGND VPWR sky130_fd_sc_hd__tapvpwrvgnd_1
XFILLER_79_178 VGND VGND VPWR VPWR sky130_fd_sc_hd__decap_3
XFILLER_94_115 VGND VGND VPWR VPWR sky130_fd_sc_hd__fill_1
XFILLER_48_554 VGND VGND VPWR VPWR sky130_fd_sc_hd__decap_3
XFILLER_57_60 VGND VGND VPWR VPWR sky130_fd_sc_hd__decap_3
XFILLER_57_71 VGND VGND VPWR VPWR sky130_fd_sc_hd__decap_3
XFILLER_94_137 VGND VGND VPWR VPWR sky130_fd_sc_hd__decap_3
XFILLER_94_159 VGND VGND VPWR VPWR sky130_fd_sc_hd__decap_3
XFILLER_57_93 VGND VGND VPWR VPWR sky130_fd_sc_hd__decap_3
XFILLER_75_362 VGND VGND VPWR VPWR sky130_fd_sc_hd__decap_3
XFILLER_75_373 VGND VGND VPWR VPWR sky130_fd_sc_hd__decap_3
XFILLER_63_524 VGND VGND VPWR VPWR sky130_fd_sc_hd__decap_3
XFILLER_63_546 VGND VGND VPWR VPWR sky130_fd_sc_hd__decap_3
XFILLER_90_332 VGND VGND VPWR VPWR sky130_fd_sc_hd__decap_3
XFILLER_16_451 VGND VGND VPWR VPWR sky130_fd_sc_hd__decap_3
XFILLER_35_248 VGND VGND VPWR VPWR sky130_fd_sc_hd__decap_3
XFILLER_63_568 VGND VGND VPWR VPWR sky130_fd_sc_hd__decap_3
XFILLER_90_365 VGND VGND VPWR VPWR sky130_fd_sc_hd__decap_3
XFILLER_16_473 VGND VGND VPWR VPWR sky130_fd_sc_hd__decap_3
XFILLER_31_410 VGND VGND VPWR VPWR sky130_fd_sc_hd__decap_3
XFILLER_31_421 VGND VGND VPWR VPWR sky130_fd_sc_hd__decap_3
XFILLER_31_443 VGND VGND VPWR VPWR sky130_fd_sc_hd__decap_3
XFILLER_43_281 VGND VGND VPWR VPWR sky130_fd_sc_hd__decap_3
X_5560_ _5512_/B _5512_/A _5530_/Y VGND VGND VPWR VPWR _5561_/B sky130_fd_sc_hd__a21o_4
XFILLER_8_672 VGND VGND VPWR VPWR sky130_fd_sc_hd__decap_3
XFILLER_8_683 VGND VGND VPWR VPWR sky130_fd_sc_hd__decap_3
X_5491_ _5491_/A split/A _5491_/C _8163_/Q VGND VGND VPWR VPWR _5532_/B sky130_fd_sc_hd__and4_2
X_4511_ _4511_/A VGND VGND VPWR VPWR _8193_/D sky130_fd_sc_hd__buf_1
XFILLER_7_160 VGND VGND VPWR VPWR sky130_fd_sc_hd__decap_3
X_7230_ _7613_/B _7231_/B _7283_/A _7562_/A VGND VGND VPWR VPWR _7230_/X sky130_fd_sc_hd__a22o_2
X_4442_ _7898_/B _4442_/B VGND VGND VPWR VPWR _4443_/A sky130_fd_sc_hd__and2_2
XFILLER_104_209 VGND VGND VPWR VPWR sky130_fd_sc_hd__decap_3
XFILLER_113_732 VGND VGND VPWR VPWR sky130_fd_sc_hd__fill_1
X_7161_ _8270_/Q _7159_/Y _7160_/X VGND VGND VPWR VPWR _7161_/X sky130_fd_sc_hd__o21a_2
X_4373_ _4373_/A VGND VGND VPWR VPWR _8124_/D sky130_fd_sc_hd__buf_1
XFILLER_112_242 VGND VGND VPWR VPWR sky130_fd_sc_hd__decap_3
X_7092_ _7844_/C _7051_/Y _7091_/X VGND VGND VPWR VPWR _7093_/B sky130_fd_sc_hd__o21a_2
X_6112_ _6589_/B2 _6084_/Y _6092_/X _6102_/X _6111_/Y VGND VGND VPWR VPWR _6112_/X
+ sky130_fd_sc_hd__a2111o_2
XFILLER_100_404 VGND VGND VPWR VPWR sky130_fd_sc_hd__decap_3
XFILLER_112_253 VGND VGND VPWR VPWR sky130_fd_sc_hd__fill_2
XFILLER_58_307 VGND VGND VPWR VPWR sky130_fd_sc_hd__fill_1
XFILLER_58_318 VGND VGND VPWR VPWR sky130_fd_sc_hd__decap_3
XFILLER_86_638 VGND VGND VPWR VPWR sky130_fd_sc_hd__decap_3
XFILLER_98_487 VGND VGND VPWR VPWR sky130_fd_sc_hd__decap_3
X_6043_ _6046_/A _6043_/B VGND VGND VPWR VPWR _6043_/Y sky130_fd_sc_hd__xnor2_2
XFILLER_39_543 VGND VGND VPWR VPWR sky130_fd_sc_hd__fill_1
XFILLER_85_148 VGND VGND VPWR VPWR sky130_fd_sc_hd__decap_3
XFILLER_54_513 VGND VGND VPWR VPWR sky130_fd_sc_hd__fill_2
XFILLER_66_340 VGND VGND VPWR VPWR sky130_fd_sc_hd__decap_3
XFILLER_66_362 VGND VGND VPWR VPWR sky130_fd_sc_hd__fill_2
XFILLER_94_671 VGND VGND VPWR VPWR sky130_fd_sc_hd__decap_3
XFILLER_26_215 VGND VGND VPWR VPWR sky130_fd_sc_hd__fill_1
XFILLER_54_524 VGND VGND VPWR VPWR sky130_fd_sc_hd__decap_3
XFILLER_66_384 VGND VGND VPWR VPWR sky130_fd_sc_hd__decap_3
XFILLER_81_310 VGND VGND VPWR VPWR sky130_fd_sc_hd__decap_3
XFILLER_93_181 VGND VGND VPWR VPWR sky130_fd_sc_hd__decap_3
X_7994_ _8397_/CLK _7994_/D VGND VGND VPWR VPWR _7994_/Q sky130_fd_sc_hd__dfxtp_2
XFILLER_26_248 VGND VGND VPWR VPWR sky130_fd_sc_hd__decap_3
XFILLER_26_259 VGND VGND VPWR VPWR sky130_fd_sc_hd__decap_3
XFILLER_81_343 VGND VGND VPWR VPWR sky130_fd_sc_hd__decap_3
X_6945_ _8200_/Q _8201_/Q _6975_/D VGND VGND VPWR VPWR _6946_/B sky130_fd_sc_hd__nand3_2
XTAP_TAPCELL_ROW_37_744 VGND VPWR sky130_fd_sc_hd__tapvpwrvgnd_1
XFILLER_81_376 VGND VGND VPWR VPWR sky130_fd_sc_hd__decap_3
XFILLER_22_421 VGND VGND VPWR VPWR sky130_fd_sc_hd__decap_3
X_6876_ _8197_/Q _8261_/Q _6875_/X VGND VGND VPWR VPWR _6876_/X sky130_fd_sc_hd__o21a_2
XFILLER_10_605 VGND VGND VPWR VPWR sky130_fd_sc_hd__decap_3
X_5827_ _7825_/A _5820_/X _5826_/Y VGND VGND VPWR VPWR _5827_/Y sky130_fd_sc_hd__o21ai_2
XFILLER_10_638 VGND VGND VPWR VPWR sky130_fd_sc_hd__decap_3
X_5758_ _5433_/X _5756_/X _5757_/Y _5665_/X VGND VGND VPWR VPWR _5758_/X sky130_fd_sc_hd__a22o_2
X_4709_ _4709_/A VGND VGND VPWR VPWR _8292_/D sky130_fd_sc_hd__buf_1
X_7428_ _7426_/X _7427_/X _8216_/Q VGND VGND VPWR VPWR _7429_/B sky130_fd_sc_hd__mux2_2
Xrebuffer268 _8175_/Q VGND VGND VPWR VPWR _6024_/B sky130_fd_sc_hd__buf_2
X_5689_ _7264_/A VGND VGND VPWR VPWR _6497_/B sky130_fd_sc_hd__buf_1
XFILLER_118_44 VGND VGND VPWR VPWR sky130_fd_sc_hd__decap_3
XFILLER_116_570 VGND VGND VPWR VPWR sky130_fd_sc_hd__fill_1
XFILLER_116_592 VGND VGND VPWR VPWR sky130_fd_sc_hd__decap_3
XFILLER_78_26 VGND VGND VPWR VPWR sky130_fd_sc_hd__fill_2
XFILLER_89_410 VGND VGND VPWR VPWR sky130_fd_sc_hd__decap_3
X_7359_ _8278_/Q _5292_/X _5422_/A VGND VGND VPWR VPWR _7359_/X sky130_fd_sc_hd__a21o_2
XFILLER_103_220 VGND VGND VPWR VPWR sky130_fd_sc_hd__decap_3
XFILLER_103_231 VGND VGND VPWR VPWR sky130_fd_sc_hd__decap_3
XFILLER_103_264 VGND VGND VPWR VPWR sky130_fd_sc_hd__decap_3
XFILLER_49_318 VGND VGND VPWR VPWR sky130_fd_sc_hd__decap_3
XFILLER_77_638 VGND VGND VPWR VPWR sky130_fd_sc_hd__decap_3
XFILLER_89_476 VGND VGND VPWR VPWR sky130_fd_sc_hd__decap_3
XFILLER_103_286 VGND VGND VPWR VPWR sky130_fd_sc_hd__decap_3
XFILLER_92_608 VGND VGND VPWR VPWR sky130_fd_sc_hd__decap_3
XFILLER_45_502 VGND VGND VPWR VPWR sky130_fd_sc_hd__fill_2
XFILLER_76_159 VGND VGND VPWR VPWR sky130_fd_sc_hd__decap_3
XFILLER_85_671 VGND VGND VPWR VPWR sky130_fd_sc_hd__fill_1
XFILLER_94_69 VGND VGND VPWR VPWR sky130_fd_sc_hd__decap_3
XFILLER_17_237 VGND VGND VPWR VPWR sky130_fd_sc_hd__decap_3
XFILLER_45_535 VGND VGND VPWR VPWR sky130_fd_sc_hd__decap_3
XFILLER_57_373 VGND VGND VPWR VPWR sky130_fd_sc_hd__decap_3
XFILLER_57_384 VGND VGND VPWR VPWR sky130_fd_sc_hd__decap_3
XFILLER_72_321 VGND VGND VPWR VPWR sky130_fd_sc_hd__decap_3
XFILLER_27_85 VGND VGND VPWR VPWR sky130_fd_sc_hd__fill_2
XFILLER_27_96 VGND VGND VPWR VPWR sky130_fd_sc_hd__fill_1
XFILLER_60_505 VGND VGND VPWR VPWR sky130_fd_sc_hd__decap_3
XFILLER_72_354 VGND VGND VPWR VPWR sky130_fd_sc_hd__fill_1
XFILLER_72_365 VGND VGND VPWR VPWR sky130_fd_sc_hd__decap_3
XFILLER_13_421 VGND VGND VPWR VPWR sky130_fd_sc_hd__fill_2
XFILLER_13_432 VGND VGND VPWR VPWR sky130_fd_sc_hd__decap_3
XFILLER_25_281 VGND VGND VPWR VPWR sky130_fd_sc_hd__fill_2
XFILLER_60_549 VGND VGND VPWR VPWR sky130_fd_sc_hd__decap_3
XTAP_TAPCELL_ROW_15_449 VGND VPWR sky130_fd_sc_hd__tapvpwrvgnd_1
XFILLER_40_240 VGND VGND VPWR VPWR sky130_fd_sc_hd__fill_1
XFILLER_43_51 VGND VGND VPWR VPWR sky130_fd_sc_hd__decap_3
XFILLER_9_425 VGND VGND VPWR VPWR sky130_fd_sc_hd__decap_3
XFILLER_13_487 VGND VGND VPWR VPWR sky130_fd_sc_hd__decap_3
XFILLER_40_273 VGND VGND VPWR VPWR sky130_fd_sc_hd__decap_3
XFILLER_9_447 VGND VGND VPWR VPWR sky130_fd_sc_hd__fill_1
XFILLER_9_458 VGND VGND VPWR VPWR sky130_fd_sc_hd__decap_3
XTAP_TAPCELL_ROW_97_1521 VGND VPWR sky130_fd_sc_hd__tapvpwrvgnd_1
XFILLER_5_620 VGND VGND VPWR VPWR sky130_fd_sc_hd__decap_3
XFILLER_114_507 VGND VGND VPWR VPWR sky130_fd_sc_hd__fill_2
XFILLER_4_141 VGND VGND VPWR VPWR sky130_fd_sc_hd__decap_3
XFILLER_5_653 VGND VGND VPWR VPWR sky130_fd_sc_hd__decap_3
XFILLER_5_664 VGND VGND VPWR VPWR sky130_fd_sc_hd__decap_3
XFILLER_99_218 VGND VGND VPWR VPWR sky130_fd_sc_hd__decap_3
Xrebuffer791 _8168_/Q VGND VGND VPWR VPWR _5702_/A sky130_fd_sc_hd__buf_6
XFILLER_107_570 VGND VGND VPWR VPWR sky130_fd_sc_hd__decap_3
XFILLER_107_592 VGND VGND VPWR VPWR sky130_fd_sc_hd__fill_2
XFILLER_68_616 VGND VGND VPWR VPWR sky130_fd_sc_hd__decap_3
XFILLER_68_81 VGND VGND VPWR VPWR sky130_fd_sc_hd__decap_3
XFILLER_95_402 VGND VGND VPWR VPWR sky130_fd_sc_hd__decap_3
XFILLER_95_435 VGND VGND VPWR VPWR sky130_fd_sc_hd__decap_3
XFILLER_95_457 VGND VGND VPWR VPWR sky130_fd_sc_hd__fill_2
XFILLER_36_502 VGND VGND VPWR VPWR sky130_fd_sc_hd__fill_1
XFILLER_48_362 VGND VGND VPWR VPWR sky130_fd_sc_hd__fill_2
XFILLER_48_384 VGND VGND VPWR VPWR sky130_fd_sc_hd__decap_3
XFILLER_63_321 VGND VGND VPWR VPWR sky130_fd_sc_hd__decap_3
XFILLER_76_693 VGND VGND VPWR VPWR sky130_fd_sc_hd__decap_3
XFILLER_36_546 VGND VGND VPWR VPWR sky130_fd_sc_hd__decap_3
XFILLER_36_557 VGND VGND VPWR VPWR sky130_fd_sc_hd__decap_3
XFILLER_51_505 VGND VGND VPWR VPWR sky130_fd_sc_hd__decap_3
XFILLER_63_343 VGND VGND VPWR VPWR sky130_fd_sc_hd__decap_3
XFILLER_91_641 VGND VGND VPWR VPWR sky130_fd_sc_hd__decap_3
XFILLER_23_207 VGND VGND VPWR VPWR sky130_fd_sc_hd__decap_3
XFILLER_63_376 VGND VGND VPWR VPWR sky130_fd_sc_hd__decap_3
X_6730_ _8194_/Q _6726_/X _6728_/X _6729_/X VGND VGND VPWR VPWR _6731_/B sky130_fd_sc_hd__a211o_2
X_4991_ _8220_/Q _7582_/B VGND VGND VPWR VPWR _4991_/Y sky130_fd_sc_hd__nor2_2
XTAP_TAPCELL_ROW_34_703 VGND VPWR sky130_fd_sc_hd__tapvpwrvgnd_1
XFILLER_90_195 VGND VGND VPWR VPWR sky130_fd_sc_hd__fill_1
XFILLER_31_240 VGND VGND VPWR VPWR sky130_fd_sc_hd__decap_3
X_6661_ _7182_/B _6661_/B VGND VGND VPWR VPWR _6662_/D sky130_fd_sc_hd__nand2_2
XFILLER_31_284 VGND VGND VPWR VPWR sky130_fd_sc_hd__decap_3
X_8400_ _8400_/CLK _8400_/D VGND VGND VPWR VPWR _8400_/Q sky130_fd_sc_hd__dfxtp_2
X_6592_ _6592_/A _6592_/B _6792_/C _6592_/D VGND VGND VPWR VPWR _6592_/X sky130_fd_sc_hd__or4_2
X_5612_ _6964_/A _5566_/Y _5583_/Y _5605_/X _5611_/Y VGND VGND VPWR VPWR _5612_/X
+ sky130_fd_sc_hd__a2111o_2
X_8331_ _8392_/CLK _8331_/D VGND VGND VPWR VPWR _8331_/Q sky130_fd_sc_hd__dfxtp_2
X_5543_ _7193_/A _5584_/A _5332_/A _5542_/Y VGND VGND VPWR VPWR _5543_/X sky130_fd_sc_hd__a31o_2
XFILLER_105_518 VGND VGND VPWR VPWR sky130_fd_sc_hd__decap_3
X_8262_ _8400_/CLK _8262_/D VGND VGND VPWR VPWR _8262_/Q sky130_fd_sc_hd__dfxtp_2
X_5474_ _6353_/A _5474_/B VGND VGND VPWR VPWR _5475_/B sky130_fd_sc_hd__nand2_2
XTAP_TAPCELL_ROW_57_1004 VGND VPWR sky130_fd_sc_hd__tapvpwrvgnd_1
XFILLER_117_389 VGND VGND VPWR VPWR sky130_fd_sc_hd__decap_3
X_8193_ clkload4/A _8193_/D VGND VGND VPWR VPWR _8193_/Q sky130_fd_sc_hd__dfxtp_2
X_7213_ _7213_/A _7213_/B VGND VGND VPWR VPWR _7213_/Y sky130_fd_sc_hd__nand2_2
X_4425_ _4425_/A VGND VGND VPWR VPWR _8150_/D sky130_fd_sc_hd__buf_1
XFILLER_113_551 VGND VGND VPWR VPWR sky130_fd_sc_hd__decap_3
XFILLER_98_240 VGND VGND VPWR VPWR sky130_fd_sc_hd__decap_3
X_7144_ _7166_/A _7030_/A _4814_/B _7143_/Y VGND VGND VPWR VPWR _7146_/B sky130_fd_sc_hd__o22a_2
X_4356_ _7930_/B _4356_/B VGND VGND VPWR VPWR _4357_/A sky130_fd_sc_hd__and2_2
XFILLER_48_29 VGND VGND VPWR VPWR sky130_fd_sc_hd__decap_3
XFILLER_86_424 VGND VGND VPWR VPWR sky130_fd_sc_hd__decap_3
XFILLER_58_137 VGND VGND VPWR VPWR sky130_fd_sc_hd__decap_3
XFILLER_98_284 VGND VGND VPWR VPWR sky130_fd_sc_hd__fill_2
XFILLER_98_295 VGND VGND VPWR VPWR sky130_fd_sc_hd__fill_1
X_7075_ _8206_/Q _7069_/X _7070_/X _7074_/Y VGND VGND VPWR VPWR _7075_/X sky130_fd_sc_hd__a22o_2
X_4287_ _4287_/A VGND VGND VPWR VPWR _8081_/D sky130_fd_sc_hd__buf_1
XFILLER_100_245 VGND VGND VPWR VPWR sky130_fd_sc_hd__fill_1
XFILLER_100_256 VGND VGND VPWR VPWR sky130_fd_sc_hd__decap_3
XFILLER_39_340 VGND VGND VPWR VPWR sky130_fd_sc_hd__fill_1
XFILLER_39_351 VGND VGND VPWR VPWR sky130_fd_sc_hd__decap_3
X_6026_ _7474_/A _6098_/A VGND VGND VPWR VPWR _6027_/B sky130_fd_sc_hd__or2_2
XFILLER_27_513 VGND VGND VPWR VPWR sky130_fd_sc_hd__fill_1
XFILLER_27_535 VGND VGND VPWR VPWR sky130_fd_sc_hd__decap_3
XFILLER_39_373 VGND VGND VPWR VPWR sky130_fd_sc_hd__decap_3
XFILLER_54_321 VGND VGND VPWR VPWR sky130_fd_sc_hd__decap_3
XFILLER_82_630 VGND VGND VPWR VPWR sky130_fd_sc_hd__decap_3
XFILLER_15_708 VGND VGND VPWR VPWR sky130_fd_sc_hd__decap_3
XFILLER_66_192 VGND VGND VPWR VPWR sky130_fd_sc_hd__decap_3
XTAP_TAPCELL_ROW_68_1144 VGND VPWR sky130_fd_sc_hd__tapvpwrvgnd_1
XFILLER_42_527 VGND VGND VPWR VPWR sky130_fd_sc_hd__decap_3
XFILLER_54_365 VGND VGND VPWR VPWR sky130_fd_sc_hd__fill_1
XFILLER_82_685 VGND VGND VPWR VPWR sky130_fd_sc_hd__decap_3
X_7977_ _8380_/CLK _7977_/D VGND VGND VPWR VPWR _7977_/Q sky130_fd_sc_hd__dfxtp_2
XFILLER_42_549 VGND VGND VPWR VPWR sky130_fd_sc_hd__decap_3
XFILLER_81_184 VGND VGND VPWR VPWR sky130_fd_sc_hd__decap_3
X_6928_ _7195_/B _6943_/B _7072_/B _5817_/A VGND VGND VPWR VPWR _6928_/X sky130_fd_sc_hd__a2bb2o_2
XTAP_TAPCELL_ROW_81_1311 VGND VPWR sky130_fd_sc_hd__tapvpwrvgnd_1
XFILLER_10_402 VGND VGND VPWR VPWR sky130_fd_sc_hd__decap_3
XFILLER_22_251 VGND VGND VPWR VPWR sky130_fd_sc_hd__fill_1
XFILLER_80_38 VGND VGND VPWR VPWR sky130_fd_sc_hd__decap_3
X_6859_ _8199_/Q _8263_/Q _8288_/Q VGND VGND VPWR VPWR _6859_/X sky130_fd_sc_hd__o21a_2
XFILLER_10_424 VGND VGND VPWR VPWR sky130_fd_sc_hd__decap_3
XFILLER_22_262 VGND VGND VPWR VPWR sky130_fd_sc_hd__decap_3
XFILLER_22_284 VGND VGND VPWR VPWR sky130_fd_sc_hd__decap_3
XTAP_TAPCELL_ROW_12_419 VGND VPWR sky130_fd_sc_hd__tapvpwrvgnd_1
XFILLER_108_312 VGND VGND VPWR VPWR sky130_fd_sc_hd__decap_3
XFILLER_6_439 VGND VGND VPWR VPWR sky130_fd_sc_hd__fill_1
XFILLER_89_14 VGND VGND VPWR VPWR sky130_fd_sc_hd__decap_3
XTAP_TAPCELL_ROW_79_1284 VGND VPWR sky130_fd_sc_hd__tapvpwrvgnd_1
XFILLER_108_378 VGND VGND VPWR VPWR sky130_fd_sc_hd__fill_2
XFILLER_104_540 VGND VGND VPWR VPWR sky130_fd_sc_hd__decap_3
XFILLER_1_111 VGND VGND VPWR VPWR sky130_fd_sc_hd__fill_1
XFILLER_89_240 VGND VGND VPWR VPWR sky130_fd_sc_hd__decap_3
XTAP_TAPCELL_ROW_92_1451 VGND VPWR sky130_fd_sc_hd__tapvpwrvgnd_1
XFILLER_49_104 VGND VGND VPWR VPWR sky130_fd_sc_hd__decap_3
XFILLER_77_413 VGND VGND VPWR VPWR sky130_fd_sc_hd__fill_1
XFILLER_104_595 VGND VGND VPWR VPWR sky130_fd_sc_hd__decap_3
XFILLER_77_468 VGND VGND VPWR VPWR sky130_fd_sc_hd__decap_3
XFILLER_92_416 VGND VGND VPWR VPWR sky130_fd_sc_hd__decap_3
XFILLER_18_513 VGND VGND VPWR VPWR sky130_fd_sc_hd__decap_3
XFILLER_38_73 VGND VGND VPWR VPWR sky130_fd_sc_hd__decap_3
XFILLER_92_427 VGND VGND VPWR VPWR sky130_fd_sc_hd__decap_3
XFILLER_57_181 VGND VGND VPWR VPWR sky130_fd_sc_hd__decap_3
XFILLER_85_490 VGND VGND VPWR VPWR sky130_fd_sc_hd__fill_1
XFILLER_33_505 VGND VGND VPWR VPWR sky130_fd_sc_hd__decap_3
XFILLER_54_50 VGND VGND VPWR VPWR sky130_fd_sc_hd__decap_3
XFILLER_72_162 VGND VGND VPWR VPWR sky130_fd_sc_hd__fill_1
XFILLER_73_685 VGND VGND VPWR VPWR sky130_fd_sc_hd__fill_2
XFILLER_14_730 VGND VGND VPWR VPWR sky130_fd_sc_hd__decap_3
XFILLER_33_538 VGND VGND VPWR VPWR sky130_fd_sc_hd__decap_3
XFILLER_54_83 VGND VGND VPWR VPWR sky130_fd_sc_hd__fill_1
XFILLER_72_184 VGND VGND VPWR VPWR sky130_fd_sc_hd__decap_3
XFILLER_54_94 VGND VGND VPWR VPWR sky130_fd_sc_hd__decap_3
XFILLER_13_262 VGND VGND VPWR VPWR sky130_fd_sc_hd__decap_3
XFILLER_70_71 VGND VGND VPWR VPWR sky130_fd_sc_hd__decap_3
XFILLER_9_244 VGND VGND VPWR VPWR sky130_fd_sc_hd__decap_3
Xclkload14 _8226_/CLK VGND VGND VPWR VPWR clkload14/X sky130_fd_sc_hd__clkbuf_4
Xclkload25 _8382_/CLK VGND VGND VPWR VPWR clkload25/X sky130_fd_sc_hd__clkbuf_8
XFILLER_5_461 VGND VGND VPWR VPWR sky130_fd_sc_hd__decap_3
XFILLER_5_483 VGND VGND VPWR VPWR sky130_fd_sc_hd__decap_3
X_4210_ _7898_/B _4210_/B VGND VGND VPWR VPWR _4211_/A sky130_fd_sc_hd__and2_2
XFILLER_79_91 VGND VGND VPWR VPWR sky130_fd_sc_hd__decap_3
X_5190_ _6763_/B _7631_/C VGND VGND VPWR VPWR _7838_/B sky130_fd_sc_hd__or2_2
XFILLER_110_521 VGND VGND VPWR VPWR sky130_fd_sc_hd__decap_3
XFILLER_68_424 VGND VGND VPWR VPWR sky130_fd_sc_hd__decap_3
XFILLER_95_210 VGND VGND VPWR VPWR sky130_fd_sc_hd__decap_3
X_4141_ _4141_/A VGND VGND VPWR VPWR _8008_/D sky130_fd_sc_hd__buf_1
XFILLER_110_554 VGND VGND VPWR VPWR sky130_fd_sc_hd__fill_1
XFILLER_110_565 VGND VGND VPWR VPWR sky130_fd_sc_hd__decap_3
XFILLER_68_457 VGND VGND VPWR VPWR sky130_fd_sc_hd__decap_3
XFILLER_95_254 VGND VGND VPWR VPWR sky130_fd_sc_hd__decap_3
X_4072_ _7898_/B _8377_/Q VGND VGND VPWR VPWR _4073_/A sky130_fd_sc_hd__and2_2
XFILLER_49_682 VGND VGND VPWR VPWR sky130_fd_sc_hd__decap_3
XFILLER_95_298 VGND VGND VPWR VPWR sky130_fd_sc_hd__decap_3
XFILLER_95_90 VGND VGND VPWR VPWR sky130_fd_sc_hd__decap_3
X_7900_ _8320_/Q _7930_/B VGND VGND VPWR VPWR _7901_/A sky130_fd_sc_hd__and2_2
XFILLER_36_321 VGND VGND VPWR VPWR sky130_fd_sc_hd__decap_3
XFILLER_36_354 VGND VGND VPWR VPWR sky130_fd_sc_hd__fill_2
XFILLER_64_630 VGND VGND VPWR VPWR sky130_fd_sc_hd__decap_3
XFILLER_64_663 VGND VGND VPWR VPWR sky130_fd_sc_hd__fill_1
XFILLER_36_365 VGND VGND VPWR VPWR sky130_fd_sc_hd__decap_3
XFILLER_51_302 VGND VGND VPWR VPWR sky130_fd_sc_hd__decap_3
XFILLER_63_140 VGND VGND VPWR VPWR sky130_fd_sc_hd__decap_3
XFILLER_64_696 VGND VGND VPWR VPWR sky130_fd_sc_hd__decap_3
XFILLER_91_482 VGND VGND VPWR VPWR sky130_fd_sc_hd__decap_3
XTAP_TAPCELL_ROW_104_1609 VGND VPWR sky130_fd_sc_hd__tapvpwrvgnd_1
X_7831_ _7831_/A _7831_/B _7831_/C VGND VGND VPWR VPWR _7831_/Y sky130_fd_sc_hd__nor3_4
XTAP_TAPCELL_ROW_47_872 VGND VPWR sky130_fd_sc_hd__tapvpwrvgnd_1
X_7762_ _7228_/B _7672_/X _7681_/X VGND VGND VPWR VPWR _7762_/Y sky130_fd_sc_hd__o21ai_2
X_4974_ _4974_/A VGND VGND VPWR VPWR _4974_/Y sky130_fd_sc_hd__inv_2
XFILLER_51_379 VGND VGND VPWR VPWR sky130_fd_sc_hd__decap_3
X_7693_ _7812_/A _7689_/X _7692_/X VGND VGND VPWR VPWR _7693_/Y sky130_fd_sc_hd__a21oi_2
X_6713_ _8190_/Q _8193_/Q _8194_/Q _6713_/D VGND VGND VPWR VPWR _6825_/D sky130_fd_sc_hd__nand4_2
XFILLER_32_582 VGND VGND VPWR VPWR sky130_fd_sc_hd__decap_3
X_6644_ _8193_/Q _6637_/X _6640_/X _8290_/Q _6643_/X VGND VGND VPWR VPWR _6644_/X
+ sky130_fd_sc_hd__a221o_2
XTAP_TAPCELL_ROW_63_1074 VGND VPWR sky130_fd_sc_hd__tapvpwrvgnd_1
Xclkload8 clkload8/A VGND VGND VPWR VPWR clkload8/X sky130_fd_sc_hd__clkbuf_4
X_6575_ _5637_/X _5646_/X _5645_/X _5641_/X _6620_/A _6355_/A VGND VGND VPWR VPWR
+ _6575_/X sky130_fd_sc_hd__mux4_2
XFILLER_118_665 VGND VGND VPWR VPWR sky130_fd_sc_hd__decap_3
X_8314_ _8386_/CLK _8314_/D VGND VGND VPWR VPWR _8314_/Q sky130_fd_sc_hd__dfxtp_2
X_5526_ _7193_/A _5966_/A VGND VGND VPWR VPWR _5526_/Y sky130_fd_sc_hd__nor2_2
XFILLER_105_326 VGND VGND VPWR VPWR sky130_fd_sc_hd__decap_3
XFILLER_117_164 VGND VGND VPWR VPWR sky130_fd_sc_hd__decap_3
XTAP_TAPCELL_ROW_115_1749 VGND VPWR sky130_fd_sc_hd__tapvpwrvgnd_1
X_8245_ _8377_/CLK _8245_/D VGND VGND VPWR VPWR _8245_/Q sky130_fd_sc_hd__dfxtp_2
X_5457_ _5427_/X _5437_/X _5456_/X _7898_/B VGND VGND VPWR VPWR _8297_/D sky130_fd_sc_hd__o31a_2
XFILLER_105_337 VGND VGND VPWR VPWR sky130_fd_sc_hd__decap_3
XFILLER_105_359 VGND VGND VPWR VPWR sky130_fd_sc_hd__decap_3
X_4408_ _7930_/B _4408_/B VGND VGND VPWR VPWR _4409_/A sky130_fd_sc_hd__and2_2
XFILLER_115_12 VGND VGND VPWR VPWR sky130_fd_sc_hd__decap_3
XFILLER_59_402 VGND VGND VPWR VPWR sky130_fd_sc_hd__decap_3
X_8176_ _8360_/CLK _8176_/D VGND VGND VPWR VPWR _8176_/Q sky130_fd_sc_hd__dfxtp_4
X_5388_ _5193_/X _5312_/X _5352_/X _5387_/X _7898_/B VGND VGND VPWR VPWR _8296_/D
+ sky130_fd_sc_hd__o221a_2
XFILLER_113_370 VGND VGND VPWR VPWR sky130_fd_sc_hd__decap_3
XFILLER_115_45 VGND VGND VPWR VPWR sky130_fd_sc_hd__decap_3
XFILLER_59_435 VGND VGND VPWR VPWR sky130_fd_sc_hd__decap_3
XFILLER_86_221 VGND VGND VPWR VPWR sky130_fd_sc_hd__decap_3
X_7127_ _6008_/A _6571_/C _7126_/X _6533_/A VGND VGND VPWR VPWR _7127_/X sky130_fd_sc_hd__a22o_2
X_4339_ _4339_/A VGND VGND VPWR VPWR _8107_/D sky130_fd_sc_hd__buf_1
X_7058_ _8290_/Q _7055_/Y _7057_/X VGND VGND VPWR VPWR _7058_/Y sky130_fd_sc_hd__a21oi_2
XFILLER_101_598 VGND VGND VPWR VPWR sky130_fd_sc_hd__decap_3
XFILLER_46_107 VGND VGND VPWR VPWR sky130_fd_sc_hd__decap_3
XFILLER_46_129 VGND VGND VPWR VPWR sky130_fd_sc_hd__fill_2
XFILLER_74_427 VGND VGND VPWR VPWR sky130_fd_sc_hd__decap_3
XFILLER_75_49 VGND VGND VPWR VPWR sky130_fd_sc_hd__decap_3
X_6009_ _6277_/A _6172_/A VGND VGND VPWR VPWR _6009_/Y sky130_fd_sc_hd__nand2_2
XFILLER_27_332 VGND VGND VPWR VPWR sky130_fd_sc_hd__decap_3
XFILLER_27_343 VGND VGND VPWR VPWR sky130_fd_sc_hd__decap_3
XFILLER_39_181 VGND VGND VPWR VPWR sky130_fd_sc_hd__decap_3
XFILLER_55_630 VGND VGND VPWR VPWR sky130_fd_sc_hd__decap_3
XFILLER_15_505 VGND VGND VPWR VPWR sky130_fd_sc_hd__decap_3
XFILLER_27_376 VGND VGND VPWR VPWR sky130_fd_sc_hd__decap_3
XFILLER_54_162 VGND VGND VPWR VPWR sky130_fd_sc_hd__decap_3
XFILLER_82_460 VGND VGND VPWR VPWR sky130_fd_sc_hd__decap_3
XFILLER_15_538 VGND VGND VPWR VPWR sky130_fd_sc_hd__decap_3
XFILLER_54_195 VGND VGND VPWR VPWR sky130_fd_sc_hd__fill_1
XFILLER_30_519 VGND VGND VPWR VPWR sky130_fd_sc_hd__decap_3
XFILLER_42_357 VGND VGND VPWR VPWR sky130_fd_sc_hd__fill_2
XFILLER_42_379 VGND VGND VPWR VPWR sky130_fd_sc_hd__decap_3
XFILLER_11_711 VGND VGND VPWR VPWR sky130_fd_sc_hd__decap_3
XFILLER_23_582 VGND VGND VPWR VPWR sky130_fd_sc_hd__fill_1
XTAP_TAPCELL_ROW_25_588 VGND VPWR sky130_fd_sc_hd__tapvpwrvgnd_1
XFILLER_109_610 VGND VGND VPWR VPWR sky130_fd_sc_hd__decap_3
XFILLER_108_120 VGND VGND VPWR VPWR sky130_fd_sc_hd__fill_1
XFILLER_109_676 VGND VGND VPWR VPWR sky130_fd_sc_hd__fill_1
XFILLER_6_247 VGND VGND VPWR VPWR sky130_fd_sc_hd__decap_3
XFILLER_108_153 VGND VGND VPWR VPWR sky130_fd_sc_hd__decap_3
XFILLER_40_85 VGND VGND VPWR VPWR sky130_fd_sc_hd__decap_3
XFILLER_108_197 VGND VGND VPWR VPWR sky130_fd_sc_hd__decap_3
XFILLER_97_508 VGND VGND VPWR VPWR sky130_fd_sc_hd__decap_3
XFILLER_111_318 VGND VGND VPWR VPWR sky130_fd_sc_hd__decap_3
XFILLER_77_221 VGND VGND VPWR VPWR sky130_fd_sc_hd__decap_3
XFILLER_65_405 VGND VGND VPWR VPWR sky130_fd_sc_hd__decap_3
XFILLER_77_243 VGND VGND VPWR VPWR sky130_fd_sc_hd__decap_3
XFILLER_1_35 VGND VGND VPWR VPWR sky130_fd_sc_hd__fill_1
XFILLER_65_438 VGND VGND VPWR VPWR sky130_fd_sc_hd__decap_3
XFILLER_77_276 VGND VGND VPWR VPWR sky130_fd_sc_hd__decap_3
XFILLER_77_287 VGND VGND VPWR VPWR sky130_fd_sc_hd__decap_3
XFILLER_93_725 VGND VGND VPWR VPWR sky130_fd_sc_hd__decap_3
XFILLER_18_321 VGND VGND VPWR VPWR sky130_fd_sc_hd__decap_3
XFILLER_65_60 VGND VGND VPWR VPWR sky130_fd_sc_hd__decap_3
XFILLER_92_246 VGND VGND VPWR VPWR sky130_fd_sc_hd__decap_3
XFILLER_18_365 VGND VGND VPWR VPWR sky130_fd_sc_hd__fill_1
XFILLER_45_151 VGND VGND VPWR VPWR sky130_fd_sc_hd__decap_3
XFILLER_65_93 VGND VGND VPWR VPWR sky130_fd_sc_hd__decap_3
XFILLER_33_324 VGND VGND VPWR VPWR sky130_fd_sc_hd__decap_3
XFILLER_33_346 VGND VGND VPWR VPWR sky130_fd_sc_hd__decap_3
XFILLER_46_696 VGND VGND VPWR VPWR sky130_fd_sc_hd__decap_3
XFILLER_60_110 VGND VGND VPWR VPWR sky130_fd_sc_hd__decap_3
XFILLER_61_644 VGND VGND VPWR VPWR sky130_fd_sc_hd__decap_3
XFILLER_73_482 VGND VGND VPWR VPWR sky130_fd_sc_hd__decap_3
XTAP_TAPCELL_ROW_44_831 VGND VPWR sky130_fd_sc_hd__tapvpwrvgnd_1
XFILLER_21_508 VGND VGND VPWR VPWR sky130_fd_sc_hd__decap_3
XFILLER_33_379 VGND VGND VPWR VPWR sky130_fd_sc_hd__decap_3
XFILLER_60_165 VGND VGND VPWR VPWR sky130_fd_sc_hd__decap_3
XFILLER_61_666 VGND VGND VPWR VPWR sky130_fd_sc_hd__decap_3
XFILLER_14_582 VGND VGND VPWR VPWR sky130_fd_sc_hd__decap_3
XFILLER_119_418 VGND VGND VPWR VPWR sky130_fd_sc_hd__fill_2
X_4690_ _7843_/A _8149_/Q VGND VGND VPWR VPWR _4691_/A sky130_fd_sc_hd__and2_2
XFILLER_60_3 VGND VGND VPWR VPWR sky130_fd_sc_hd__fill_2
X_6360_ _8248_/Q _6359_/B _8184_/Q VGND VGND VPWR VPWR _6360_/X sky130_fd_sc_hd__a21o_2
XFILLER_114_101 VGND VGND VPWR VPWR sky130_fd_sc_hd__decap_3
X_5311_ _5284_/X _5197_/C _5197_/B _7820_/A VGND VGND VPWR VPWR _5311_/X sky130_fd_sc_hd__a31o_4
XFILLER_114_112 VGND VGND VPWR VPWR sky130_fd_sc_hd__decap_3
X_8030_ _8224_/CLK _8030_/D VGND VGND VPWR VPWR _8030_/Q sky130_fd_sc_hd__dfxtp_2
X_6291_ _6289_/X _6290_/X _6157_/X VGND VGND VPWR VPWR _6291_/X sky130_fd_sc_hd__o21a_2
XFILLER_102_318 VGND VGND VPWR VPWR sky130_fd_sc_hd__decap_3
XFILLER_114_156 VGND VGND VPWR VPWR sky130_fd_sc_hd__fill_1
XFILLER_114_178 VGND VGND VPWR VPWR sky130_fd_sc_hd__fill_1
X_5242_ _7656_/B VGND VGND VPWR VPWR _5242_/X sky130_fd_sc_hd__clkbuf_1
XFILLER_102_329 VGND VGND VPWR VPWR sky130_fd_sc_hd__decap_3
XFILLER_96_530 VGND VGND VPWR VPWR sky130_fd_sc_hd__fill_2
X_5173_ _5169_/X _5172_/X _6706_/S VGND VGND VPWR VPWR _5173_/X sky130_fd_sc_hd__mux2_2
X_4124_ _7930_/B _7932_/Q VGND VGND VPWR VPWR _4125_/A sky130_fd_sc_hd__and2_2
XFILLER_28_118 VGND VGND VPWR VPWR sky130_fd_sc_hd__decap_3
XFILLER_56_416 VGND VGND VPWR VPWR sky130_fd_sc_hd__decap_3
XFILLER_56_427 VGND VGND VPWR VPWR sky130_fd_sc_hd__decap_3
XFILLER_68_287 VGND VGND VPWR VPWR sky130_fd_sc_hd__decap_3
XFILLER_83_202 VGND VGND VPWR VPWR sky130_fd_sc_hd__decap_3
XFILLER_96_585 VGND VGND VPWR VPWR sky130_fd_sc_hd__decap_3
Xinput1 carry_in VGND VGND VPWR VPWR input1/X sky130_fd_sc_hd__clkdlybuf4s25_1
XFILLER_49_490 VGND VGND VPWR VPWR sky130_fd_sc_hd__decap_3
X_4055_ _4055_/A VGND VGND VPWR VPWR _7965_/D sky130_fd_sc_hd__buf_1
XFILLER_37_685 VGND VGND VPWR VPWR sky130_fd_sc_hd__decap_3
XFILLER_71_408 VGND VGND VPWR VPWR sky130_fd_sc_hd__decap_3
XFILLER_71_419 VGND VGND VPWR VPWR sky130_fd_sc_hd__decap_3
XFILLER_83_268 VGND VGND VPWR VPWR sky130_fd_sc_hd__decap_3
XTAP_TAPCELL_ROW_65_1103 VGND VPWR sky130_fd_sc_hd__tapvpwrvgnd_1
XFILLER_101_14 VGND VGND VPWR VPWR sky130_fd_sc_hd__decap_3
XFILLER_36_184 VGND VGND VPWR VPWR sky130_fd_sc_hd__decap_3
X_7814_ _7805_/A _5491_/C _7656_/B _5596_/S VGND VGND VPWR VPWR _7814_/Y sky130_fd_sc_hd__a211oi_2
XFILLER_12_519 VGND VGND VPWR VPWR sky130_fd_sc_hd__fill_1
XFILLER_24_368 VGND VGND VPWR VPWR sky130_fd_sc_hd__decap_3
XFILLER_51_143 VGND VGND VPWR VPWR sky130_fd_sc_hd__decap_3
XFILLER_52_655 VGND VGND VPWR VPWR sky130_fd_sc_hd__decap_3
XFILLER_101_69 VGND VGND VPWR VPWR sky130_fd_sc_hd__decap_3
XFILLER_51_187 VGND VGND VPWR VPWR sky130_fd_sc_hd__decap_3
XFILLER_52_699 VGND VGND VPWR VPWR sky130_fd_sc_hd__fill_1
X_7745_ _7745_/A _7745_/B VGND VGND VPWR VPWR _7746_/B sky130_fd_sc_hd__nand2_2
X_4957_ _6707_/S _5417_/A VGND VGND VPWR VPWR _4958_/A sky130_fd_sc_hd__nor2_2
XFILLER_32_390 VGND VGND VPWR VPWR sky130_fd_sc_hd__decap_3
X_7676_ _7653_/X _8216_/Q _7655_/X _7658_/X _7675_/X VGND VGND VPWR VPWR _7676_/X
+ sky130_fd_sc_hd__a311o_2
X_4888_ _4888_/A _4888_/B _6366_/S _6411_/A VGND VGND VPWR VPWR _4917_/A sky130_fd_sc_hd__or4b_2
XTAP_TAPCELL_ROW_22_547 VGND VPWR sky130_fd_sc_hd__tapvpwrvgnd_1
XFILLER_20_585 VGND VGND VPWR VPWR sky130_fd_sc_hd__decap_3
X_6627_ split/X _7193_/A _7193_/B _7651_/B _6626_/X VGND VGND VPWR VPWR _6627_/X sky130_fd_sc_hd__a41o_2
X_6558_ _8254_/Q _6523_/B _8190_/Q VGND VGND VPWR VPWR _6558_/X sky130_fd_sc_hd__a21o_2
X_6489_ _8187_/Q _6489_/B VGND VGND VPWR VPWR _6489_/Y sky130_fd_sc_hd__nor2_2
X_5509_ _5476_/Y _5502_/X _5506_/Y _5508_/X _7898_/B VGND VGND VPWR VPWR _8298_/D
+ sky130_fd_sc_hd__o221a_2
XTAP_TAPCELL_ROW_76_1243 VGND VPWR sky130_fd_sc_hd__tapvpwrvgnd_1
XFILLER_105_178 VGND VGND VPWR VPWR sky130_fd_sc_hd__decap_3
XFILLER_10_77 VGND VGND VPWR VPWR sky130_fd_sc_hd__fill_1
X_8228_ _8228_/CLK _8228_/D VGND VGND VPWR VPWR _8228_/Q sky130_fd_sc_hd__dfxtp_4
XFILLER_10_99 VGND VGND VPWR VPWR sky130_fd_sc_hd__decap_3
XFILLER_59_210 VGND VGND VPWR VPWR sky130_fd_sc_hd__decap_3
XFILLER_86_26 VGND VGND VPWR VPWR sky130_fd_sc_hd__fill_2
X_8159_ clkload9/A _8159_/D VGND VGND VPWR VPWR _8159_/Q sky130_fd_sc_hd__dfxtp_2
XFILLER_59_254 VGND VGND VPWR VPWR sky130_fd_sc_hd__decap_3
XFILLER_86_48 VGND VGND VPWR VPWR sky130_fd_sc_hd__fill_2
XFILLER_87_541 VGND VGND VPWR VPWR sky130_fd_sc_hd__decap_3
XFILLER_101_362 VGND VGND VPWR VPWR sky130_fd_sc_hd__decap_3
XFILLER_47_405 VGND VGND VPWR VPWR sky130_fd_sc_hd__decap_3
XFILLER_47_438 VGND VGND VPWR VPWR sky130_fd_sc_hd__decap_3
XFILLER_59_265 VGND VGND VPWR VPWR sky130_fd_sc_hd__decap_3
XFILLER_59_287 VGND VGND VPWR VPWR sky130_fd_sc_hd__fill_2
XFILLER_28_630 VGND VGND VPWR VPWR sky130_fd_sc_hd__fill_2
XFILLER_47_449 VGND VGND VPWR VPWR sky130_fd_sc_hd__decap_3
XFILLER_74_224 VGND VGND VPWR VPWR sky130_fd_sc_hd__decap_3
Xclkbuf_leaf_39_clk clkload0/A VGND VGND VPWR VPWR clkload7/A sky130_fd_sc_hd__clkbuf_8
XFILLER_27_151 VGND VGND VPWR VPWR sky130_fd_sc_hd__decap_3
XFILLER_28_685 VGND VGND VPWR VPWR sky130_fd_sc_hd__decap_3
XFILLER_74_268 VGND VGND VPWR VPWR sky130_fd_sc_hd__decap_3
XFILLER_90_728 VGND VGND VPWR VPWR sky130_fd_sc_hd__decap_3
XTAP_TAPCELL_ROW_2_283 VGND VPWR sky130_fd_sc_hd__tapvpwrvgnd_1
XFILLER_15_324 VGND VGND VPWR VPWR sky130_fd_sc_hd__decap_3
XFILLER_35_41 VGND VGND VPWR VPWR sky130_fd_sc_hd__decap_3
XFILLER_42_110 VGND VGND VPWR VPWR sky130_fd_sc_hd__decap_3
XTAP_TAPCELL_ROW_87_1394 VGND VPWR sky130_fd_sc_hd__tapvpwrvgnd_1
XFILLER_15_368 VGND VGND VPWR VPWR sky130_fd_sc_hd__decap_3
XFILLER_35_63 VGND VGND VPWR VPWR sky130_fd_sc_hd__fill_1
XFILLER_35_85 VGND VGND VPWR VPWR sky130_fd_sc_hd__decap_3
XPHY_EDGE_ROW_106_Left_226 VGND VGND VPWR VPWR sky130_fd_sc_hd__decap_3
XFILLER_11_541 VGND VGND VPWR VPWR sky130_fd_sc_hd__decap_3
XFILLER_30_338 VGND VGND VPWR VPWR sky130_fd_sc_hd__decap_3
XFILLER_51_51 VGND VGND VPWR VPWR sky130_fd_sc_hd__decap_3
XFILLER_7_523 VGND VGND VPWR VPWR sky130_fd_sc_hd__decap_3
XFILLER_109_440 VGND VGND VPWR VPWR sky130_fd_sc_hd__decap_3
XFILLER_7_556 VGND VGND VPWR VPWR sky130_fd_sc_hd__decap_3
XFILLER_7_567 VGND VGND VPWR VPWR sky130_fd_sc_hd__fill_1
XFILLER_109_462 VGND VGND VPWR VPWR sky130_fd_sc_hd__decap_3
Xmax_cap209 _5563_/X VGND VGND VPWR VPWR _6964_/A sky130_fd_sc_hd__buf_6
XPHY_EDGE_ROW_115_Left_235 VGND VGND VPWR VPWR sky130_fd_sc_hd__decap_3
XFILLER_105_690 VGND VGND VPWR VPWR sky130_fd_sc_hd__decap_3
XFILLER_111_126 VGND VGND VPWR VPWR sky130_fd_sc_hd__decap_3
XFILLER_97_327 VGND VGND VPWR VPWR sky130_fd_sc_hd__decap_3
XFILLER_38_438 VGND VGND VPWR VPWR sky130_fd_sc_hd__decap_3
XFILLER_78_574 VGND VGND VPWR VPWR sky130_fd_sc_hd__fill_1
XFILLER_93_511 VGND VGND VPWR VPWR sky130_fd_sc_hd__decap_3
Xclone322 _6818_/S VGND VGND VPWR VPWR _6648_/A sky130_fd_sc_hd__clkbuf_16
XTAP_TAPCELL_ROW_49_901 VGND VPWR sky130_fd_sc_hd__tapvpwrvgnd_1
XFILLER_65_246 VGND VGND VPWR VPWR sky130_fd_sc_hd__fill_1
XFILLER_93_544 VGND VGND VPWR VPWR sky130_fd_sc_hd__decap_3
XFILLER_19_663 VGND VGND VPWR VPWR sky130_fd_sc_hd__decap_3
XFILLER_46_460 VGND VGND VPWR VPWR sky130_fd_sc_hd__decap_3
XFILLER_53_408 VGND VGND VPWR VPWR sky130_fd_sc_hd__decap_3
XFILLER_93_588 VGND VGND VPWR VPWR sky130_fd_sc_hd__decap_3
XFILLER_18_162 VGND VGND VPWR VPWR sky130_fd_sc_hd__decap_3
XFILLER_80_249 VGND VGND VPWR VPWR sky130_fd_sc_hd__decap_3
X_5860_ _8172_/Q _5943_/C _6380_/S VGND VGND VPWR VPWR _5860_/X sky130_fd_sc_hd__mux2_2
XFILLER_33_143 VGND VGND VPWR VPWR sky130_fd_sc_hd__decap_3
XFILLER_61_441 VGND VGND VPWR VPWR sky130_fd_sc_hd__decap_3
XFILLER_61_452 VGND VGND VPWR VPWR sky130_fd_sc_hd__decap_3
X_4811_ _8267_/Q VGND VGND VPWR VPWR _4813_/B sky130_fd_sc_hd__inv_2
XFILLER_33_165 VGND VGND VPWR VPWR sky130_fd_sc_hd__decap_3
XFILLER_34_699 VGND VGND VPWR VPWR sky130_fd_sc_hd__fill_1
XFILLER_61_485 VGND VGND VPWR VPWR sky130_fd_sc_hd__decap_3
X_5791_ _5791_/A VGND VGND VPWR VPWR _5791_/Y sky130_fd_sc_hd__inv_2
XFILLER_21_349 VGND VGND VPWR VPWR sky130_fd_sc_hd__decap_3
XFILLER_33_198 VGND VGND VPWR VPWR sky130_fd_sc_hd__decap_3
X_7530_ _8229_/Q _7529_/X _6454_/A VGND VGND VPWR VPWR _7530_/Y sky130_fd_sc_hd__o21ai_2
X_4742_ _8217_/Q _8281_/Q VGND VGND VPWR VPWR _4744_/A sky130_fd_sc_hd__and2b_2
XTAP_TAPCELL_ROW_60_1033 VGND VPWR sky130_fd_sc_hd__tapvpwrvgnd_1
X_7461_ _4986_/X _7437_/B _4744_/B VGND VGND VPWR VPWR _7463_/B sky130_fd_sc_hd__a21oi_2
X_4673_ _4673_/A VGND VGND VPWR VPWR _8274_/D sky130_fd_sc_hd__buf_1
XTAP_TAPCELL_ROW_60_1044 VGND VPWR sky130_fd_sc_hd__tapvpwrvgnd_1
X_6412_ _6390_/X _6406_/X _6411_/X _6910_/A _7844_/A VGND VGND VPWR VPWR _8320_/D
+ sky130_fd_sc_hd__a221oi_2
X_7392_ _6270_/X _6273_/Y _7391_/Y _6278_/X _7193_/A VGND VGND VPWR VPWR _7392_/X
+ sky130_fd_sc_hd__a32o_2
XFILLER_115_410 VGND VGND VPWR VPWR sky130_fd_sc_hd__decap_3
X_6343_ _7631_/A _6340_/X _6342_/X VGND VGND VPWR VPWR _6343_/Y sky130_fd_sc_hd__o21ai_2
XFILLER_103_605 VGND VGND VPWR VPWR sky130_fd_sc_hd__decap_3
XFILLER_88_305 VGND VGND VPWR VPWR sky130_fd_sc_hd__decap_3
XTAP_TAPCELL_ROW_112_1719 VGND VPWR sky130_fd_sc_hd__tapvpwrvgnd_1
X_6274_ _8183_/Q _6490_/A _8181_/Q _8180_/Q _5484_/S _5452_/S VGND VGND VPWR VPWR
+ _6274_/X sky130_fd_sc_hd__mux4_2
X_8013_ _8349_/CLK _8013_/D VGND VGND VPWR VPWR _8013_/Q sky130_fd_sc_hd__dfxtp_2
X_5225_ _8199_/Q _8200_/Q _6380_/S VGND VGND VPWR VPWR _5225_/X sky130_fd_sc_hd__mux2_2
XFILLER_102_159 VGND VGND VPWR VPWR sky130_fd_sc_hd__decap_3
XFILLER_69_541 VGND VGND VPWR VPWR sky130_fd_sc_hd__decap_3
XFILLER_29_405 VGND VGND VPWR VPWR sky130_fd_sc_hd__decap_3
XFILLER_96_371 VGND VGND VPWR VPWR sky130_fd_sc_hd__decap_3
X_5156_ _8204_/Q _8205_/Q _5484_/S VGND VGND VPWR VPWR _5156_/X sky130_fd_sc_hd__mux2_2
XTAP_TAPCELL_ROW_71_1184 VGND VPWR sky130_fd_sc_hd__tapvpwrvgnd_1
XFILLER_56_224 VGND VGND VPWR VPWR sky130_fd_sc_hd__decap_3
XFILLER_84_533 VGND VGND VPWR VPWR sky130_fd_sc_hd__decap_3
X_5087_ _4967_/Y _6763_/B _5086_/X _8290_/Q VGND VGND VPWR VPWR _5087_/X sky130_fd_sc_hd__o22a_2
X_4107_ _4107_/A VGND VGND VPWR VPWR _7991_/D sky130_fd_sc_hd__buf_1
XFILLER_25_600 VGND VGND VPWR VPWR sky130_fd_sc_hd__fill_2
XFILLER_44_419 VGND VGND VPWR VPWR sky130_fd_sc_hd__fill_1
XFILLER_56_279 VGND VGND VPWR VPWR sky130_fd_sc_hd__decap_3
XFILLER_84_566 VGND VGND VPWR VPWR sky130_fd_sc_hd__decap_3
X_4038_ _7898_/B _8360_/Q VGND VGND VPWR VPWR _4039_/A sky130_fd_sc_hd__and2_2
XTAP_TAPCELL_ROW_27_606 VGND VPWR sky130_fd_sc_hd__tapvpwrvgnd_1
XFILLER_12_305 VGND VGND VPWR VPWR sky130_fd_sc_hd__decap_3
XFILLER_24_165 VGND VGND VPWR VPWR sky130_fd_sc_hd__decap_3
XFILLER_40_614 VGND VGND VPWR VPWR sky130_fd_sc_hd__decap_3
X_5989_ _7193_/A _5988_/X _5186_/A VGND VGND VPWR VPWR _5989_/Y sky130_fd_sc_hd__o21ai_2
XFILLER_8_309 VGND VGND VPWR VPWR sky130_fd_sc_hd__fill_1
X_7728_ _8183_/Q _7663_/B _7660_/A VGND VGND VPWR VPWR _7728_/Y sky130_fd_sc_hd__o21ai_2
XFILLER_20_360 VGND VGND VPWR VPWR sky130_fd_sc_hd__fill_1
XFILLER_20_371 VGND VGND VPWR VPWR sky130_fd_sc_hd__decap_3
X_7659_ _7670_/A _7661_/B VGND VGND VPWR VPWR _7660_/A sky130_fd_sc_hd__nand2_2
XFILLER_21_32 VGND VGND VPWR VPWR sky130_fd_sc_hd__fill_1
XFILLER_21_54 VGND VGND VPWR VPWR sky130_fd_sc_hd__fill_2
XFILLER_106_410 VGND VGND VPWR VPWR sky130_fd_sc_hd__decap_3
XFILLER_106_421 VGND VGND VPWR VPWR sky130_fd_sc_hd__decap_3
XFILLER_108_3 VGND VGND VPWR VPWR sky130_fd_sc_hd__decap_3
XFILLER_97_14 VGND VGND VPWR VPWR sky130_fd_sc_hd__decap_3
XFILLER_79_305 VGND VGND VPWR VPWR sky130_fd_sc_hd__decap_3
XFILLER_97_47 VGND VGND VPWR VPWR sky130_fd_sc_hd__decap_3
XFILLER_0_732 VGND VGND VPWR VPWR sky130_fd_sc_hd__fill_1
XFILLER_106_487 VGND VGND VPWR VPWR sky130_fd_sc_hd__decap_3
Xoutput190 _8014_/Q VGND VGND VPWR VPWR result[56] sky130_fd_sc_hd__clkdlybuf4s25_1
XTAP_TAPCELL_ROW_7_353 VGND VPWR sky130_fd_sc_hd__tapvpwrvgnd_1
XTAP_TAPCELL_ROW_89_1412 VGND VPWR sky130_fd_sc_hd__tapvpwrvgnd_1
XFILLER_101_181 VGND VGND VPWR VPWR sky130_fd_sc_hd__fill_2
XFILLER_75_544 VGND VGND VPWR VPWR sky130_fd_sc_hd__decap_3
XFILLER_35_408 VGND VGND VPWR VPWR sky130_fd_sc_hd__decap_3
XFILLER_46_51 VGND VGND VPWR VPWR sky130_fd_sc_hd__decap_3
XFILLER_90_514 VGND VGND VPWR VPWR sky130_fd_sc_hd__decap_3
XFILLER_46_95 VGND VGND VPWR VPWR sky130_fd_sc_hd__decap_3
XFILLER_90_536 VGND VGND VPWR VPWR sky130_fd_sc_hd__decap_3
XFILLER_15_143 VGND VGND VPWR VPWR sky130_fd_sc_hd__decap_3
XFILLER_16_666 VGND VGND VPWR VPWR sky130_fd_sc_hd__decap_3
XFILLER_55_290 VGND VGND VPWR VPWR sky130_fd_sc_hd__decap_3
XFILLER_62_249 VGND VGND VPWR VPWR sky130_fd_sc_hd__decap_3
XFILLER_102_90 VGND VGND VPWR VPWR sky130_fd_sc_hd__decap_3
XFILLER_31_603 VGND VGND VPWR VPWR sky130_fd_sc_hd__decap_3
XFILLER_31_614 VGND VGND VPWR VPWR sky130_fd_sc_hd__fill_2
XFILLER_43_463 VGND VGND VPWR VPWR sky130_fd_sc_hd__decap_3
XFILLER_43_496 VGND VGND VPWR VPWR sky130_fd_sc_hd__decap_3
XFILLER_70_271 VGND VGND VPWR VPWR sky130_fd_sc_hd__decap_3
XFILLER_15_198 VGND VGND VPWR VPWR sky130_fd_sc_hd__decap_3
XFILLER_30_135 VGND VGND VPWR VPWR sky130_fd_sc_hd__decap_3
XFILLER_62_50 VGND VGND VPWR VPWR sky130_fd_sc_hd__decap_3
XFILLER_62_72 VGND VGND VPWR VPWR sky130_fd_sc_hd__decap_3
XFILLER_62_94 VGND VGND VPWR VPWR sky130_fd_sc_hd__decap_3
XFILLER_11_360 VGND VGND VPWR VPWR sky130_fd_sc_hd__decap_3
XFILLER_11_393 VGND VGND VPWR VPWR sky130_fd_sc_hd__decap_3
XFILLER_7_23 VGND VGND VPWR VPWR sky130_fd_sc_hd__decap_3
XFILLER_7_320 VGND VGND VPWR VPWR sky130_fd_sc_hd__decap_3
XFILLER_7_78 VGND VGND VPWR VPWR sky130_fd_sc_hd__fill_1
XFILLER_109_270 VGND VGND VPWR VPWR sky130_fd_sc_hd__fill_2
XFILLER_109_281 VGND VGND VPWR VPWR sky130_fd_sc_hd__decap_3
XFILLER_109_292 VGND VGND VPWR VPWR sky130_fd_sc_hd__decap_3
XFILLER_7_386 VGND VGND VPWR VPWR sky130_fd_sc_hd__decap_3
XFILLER_112_413 VGND VGND VPWR VPWR sky130_fd_sc_hd__decap_3
XFILLER_112_424 VGND VGND VPWR VPWR sky130_fd_sc_hd__decap_3
XFILLER_97_124 VGND VGND VPWR VPWR sky130_fd_sc_hd__decap_3
XFILLER_98_625 VGND VGND VPWR VPWR sky130_fd_sc_hd__decap_3
XFILLER_98_658 VGND VGND VPWR VPWR sky130_fd_sc_hd__decap_3
XFILLER_100_608 VGND VGND VPWR VPWR sky130_fd_sc_hd__decap_3
XFILLER_3_592 VGND VGND VPWR VPWR sky130_fd_sc_hd__decap_3
X_5010_ _5430_/B _4968_/A _5430_/A VGND VGND VPWR VPWR _5010_/X sky130_fd_sc_hd__o21a_2
XFILLER_39_703 VGND VGND VPWR VPWR sky130_fd_sc_hd__decap_3
XFILLER_78_360 VGND VGND VPWR VPWR sky130_fd_sc_hd__decap_3
XFILLER_78_371 VGND VGND VPWR VPWR sky130_fd_sc_hd__decap_3
Xload_slew256 _7843_/A VGND VGND VPWR VPWR _7898_/B sky130_fd_sc_hd__clkbuf_16
XFILLER_38_224 VGND VGND VPWR VPWR sky130_fd_sc_hd__decap_3
XFILLER_66_533 VGND VGND VPWR VPWR sky130_fd_sc_hd__fill_1
XFILLER_26_419 VGND VGND VPWR VPWR sky130_fd_sc_hd__fill_1
XFILLER_53_205 VGND VGND VPWR VPWR sky130_fd_sc_hd__decap_3
XFILLER_93_352 VGND VGND VPWR VPWR sky130_fd_sc_hd__decap_3
XFILLER_19_493 VGND VGND VPWR VPWR sky130_fd_sc_hd__fill_2
XFILLER_81_547 VGND VGND VPWR VPWR sky130_fd_sc_hd__decap_3
XFILLER_93_385 VGND VGND VPWR VPWR sky130_fd_sc_hd__decap_3
XFILLER_93_396 VGND VGND VPWR VPWR sky130_fd_sc_hd__decap_3
XTAP_TAPCELL_ROW_109_1670 VGND VPWR sky130_fd_sc_hd__tapvpwrvgnd_1
XTAP_TAPCELL_ROW_109_1681 VGND VPWR sky130_fd_sc_hd__tapvpwrvgnd_1
X_6961_ _7154_/B _6957_/Y _7154_/A VGND VGND VPWR VPWR _6963_/B sky130_fd_sc_hd__o21a_4
XFILLER_34_430 VGND VGND VPWR VPWR sky130_fd_sc_hd__fill_2
X_6892_ _7193_/A _6891_/X _6533_/A VGND VGND VPWR VPWR _6892_/Y sky130_fd_sc_hd__o21ai_2
X_5912_ _6130_/A _5824_/Y _5911_/Y _7135_/B VGND VGND VPWR VPWR _5912_/X sky130_fd_sc_hd__a31o_2
XFILLER_61_271 VGND VGND VPWR VPWR sky130_fd_sc_hd__decap_3
X_5843_ _6086_/A _5876_/A _5842_/X _6763_/A VGND VGND VPWR VPWR _5843_/X sky130_fd_sc_hd__a22o_2
XTAP_TAPCELL_ROW_52_929 VGND VPWR sky130_fd_sc_hd__tapvpwrvgnd_1
XFILLER_21_113 VGND VGND VPWR VPWR sky130_fd_sc_hd__fill_1
XFILLER_22_669 VGND VGND VPWR VPWR sky130_fd_sc_hd__decap_3
XFILLER_21_157 VGND VGND VPWR VPWR sky130_fd_sc_hd__decap_3
X_7513_ _7513_/A VGND VGND VPWR VPWR _8353_/D sky130_fd_sc_hd__buf_1
X_5774_ _6355_/A _5774_/B VGND VGND VPWR VPWR _5774_/X sky130_fd_sc_hd__or2_2
XTAP_TAPCELL_ROW_32_675 VGND VPWR sky130_fd_sc_hd__tapvpwrvgnd_1
X_4725_ _7649_/A _4725_/B VGND VGND VPWR VPWR _7588_/A sky130_fd_sc_hd__nand2_2
X_7444_ _5076_/Y _6767_/Y _7444_/S VGND VGND VPWR VPWR _7444_/X sky130_fd_sc_hd__mux2_2
X_4656_ _7930_/B _8132_/Q VGND VGND VPWR VPWR _4657_/A sky130_fd_sc_hd__and2_2
X_7375_ _8214_/Q _8278_/Q _7394_/C _7340_/B VGND VGND VPWR VPWR _7375_/X sky130_fd_sc_hd__a211o_2
Xinput81 operand_b[1] VGND VGND VPWR VPWR _4306_/B sky130_fd_sc_hd__clkdlybuf4s25_1
Xinput70 operand_b[0] VGND VGND VPWR VPWR _4304_/B sky130_fd_sc_hd__clkdlybuf4s25_1
X_4587_ _4587_/A VGND VGND VPWR VPWR _8231_/D sky130_fd_sc_hd__buf_1
XFILLER_115_240 VGND VGND VPWR VPWR sky130_fd_sc_hd__decap_3
XFILLER_89_614 VGND VGND VPWR VPWR sky130_fd_sc_hd__fill_2
Xinput92 operand_b[2] VGND VGND VPWR VPWR _4308_/B sky130_fd_sc_hd__clkdlybuf4s25_1
X_6326_ _6277_/A _5683_/B _6325_/Y _6650_/B VGND VGND VPWR VPWR _6326_/X sky130_fd_sc_hd__a211o_2
XTAP_TAPCELL_ROW_73_1213 VGND VPWR sky130_fd_sc_hd__tapvpwrvgnd_1
XTAP_TAPCELL_ROW_73_1202 VGND VPWR sky130_fd_sc_hd__tapvpwrvgnd_1
XFILLER_103_402 VGND VGND VPWR VPWR sky130_fd_sc_hd__decap_3
XFILLER_107_57 VGND VGND VPWR VPWR sky130_fd_sc_hd__decap_3
XFILLER_115_273 VGND VGND VPWR VPWR sky130_fd_sc_hd__decap_3
XFILLER_115_284 VGND VGND VPWR VPWR sky130_fd_sc_hd__decap_3
XFILLER_88_124 VGND VGND VPWR VPWR sky130_fd_sc_hd__decap_3
XFILLER_103_435 VGND VGND VPWR VPWR sky130_fd_sc_hd__decap_3
XFILLER_67_17 VGND VGND VPWR VPWR sky130_fd_sc_hd__decap_3
XFILLER_89_669 VGND VGND VPWR VPWR sky130_fd_sc_hd__decap_3
X_6257_ _6222_/X _8246_/Q _6257_/B1_N VGND VGND VPWR VPWR _6257_/X sky130_fd_sc_hd__a21bo_2
XFILLER_76_319 VGND VGND VPWR VPWR sky130_fd_sc_hd__decap_3
XFILLER_88_168 VGND VGND VPWR VPWR sky130_fd_sc_hd__decap_3
X_6188_ _6769_/A _7732_/B _6187_/Y _6121_/B _6393_/B VGND VGND VPWR VPWR _6188_/X
+ sky130_fd_sc_hd__a32o_2
X_5208_ _5205_/X _5206_/X _5384_/S VGND VGND VPWR VPWR _5209_/B sky130_fd_sc_hd__mux2_2
XTAP_TAPCELL_ROW_4_312 VGND VPWR sky130_fd_sc_hd__tapvpwrvgnd_1
XFILLER_69_393 VGND VGND VPWR VPWR sky130_fd_sc_hd__decap_3
XFILLER_84_330 VGND VGND VPWR VPWR sky130_fd_sc_hd__decap_3
X_5139_ _5137_/X _5138_/X _5634_/S VGND VGND VPWR VPWR _5139_/X sky130_fd_sc_hd__mux2_2
XFILLER_29_268 VGND VGND VPWR VPWR sky130_fd_sc_hd__decap_3
XFILLER_57_555 VGND VGND VPWR VPWR sky130_fd_sc_hd__decap_3
XFILLER_57_588 VGND VGND VPWR VPWR sky130_fd_sc_hd__decap_3
XFILLER_84_363 VGND VGND VPWR VPWR sky130_fd_sc_hd__fill_1
XFILLER_72_536 VGND VGND VPWR VPWR sky130_fd_sc_hd__decap_3
XFILLER_83_38 VGND VGND VPWR VPWR sky130_fd_sc_hd__decap_3
XFILLER_25_452 VGND VGND VPWR VPWR sky130_fd_sc_hd__decap_3
XFILLER_37_290 VGND VGND VPWR VPWR sky130_fd_sc_hd__decap_3
XFILLER_44_249 VGND VGND VPWR VPWR sky130_fd_sc_hd__decap_3
XFILLER_72_569 VGND VGND VPWR VPWR sky130_fd_sc_hd__fill_1
XTAP_TAPCELL_ROW_84_1353 VGND VPWR sky130_fd_sc_hd__tapvpwrvgnd_1
XFILLER_16_65 VGND VGND VPWR VPWR sky130_fd_sc_hd__decap_3
XFILLER_16_76 VGND VGND VPWR VPWR sky130_fd_sc_hd__decap_3
XFILLER_40_400 VGND VGND VPWR VPWR sky130_fd_sc_hd__decap_3
XFILLER_13_636 VGND VGND VPWR VPWR sky130_fd_sc_hd__decap_3
XFILLER_40_433 VGND VGND VPWR VPWR sky130_fd_sc_hd__decap_3
XFILLER_12_168 VGND VGND VPWR VPWR sky130_fd_sc_hd__decap_3
XFILLER_32_20 VGND VGND VPWR VPWR sky130_fd_sc_hd__decap_3
XFILLER_40_466 VGND VGND VPWR VPWR sky130_fd_sc_hd__decap_3
XFILLER_40_477 VGND VGND VPWR VPWR sky130_fd_sc_hd__decap_3
XFILLER_9_629 VGND VGND VPWR VPWR sky130_fd_sc_hd__decap_3
XFILLER_21_691 VGND VGND VPWR VPWR sky130_fd_sc_hd__decap_3
XFILLER_32_97 VGND VGND VPWR VPWR sky130_fd_sc_hd__decap_3
XFILLER_4_301 VGND VGND VPWR VPWR sky130_fd_sc_hd__decap_3
XFILLER_4_312 VGND VGND VPWR VPWR sky130_fd_sc_hd__decap_3
XFILLER_4_345 VGND VGND VPWR VPWR sky130_fd_sc_hd__decap_3
XFILLER_106_262 VGND VGND VPWR VPWR sky130_fd_sc_hd__decap_3
XFILLER_79_113 VGND VGND VPWR VPWR sky130_fd_sc_hd__fill_1
XTAP_TAPCELL_ROW_95_1493 VGND VPWR sky130_fd_sc_hd__tapvpwrvgnd_1
XFILLER_106_295 VGND VGND VPWR VPWR sky130_fd_sc_hd__decap_3
XFILLER_79_157 VGND VGND VPWR VPWR sky130_fd_sc_hd__decap_3
XFILLER_48_511 VGND VGND VPWR VPWR sky130_fd_sc_hd__decap_3
XFILLER_67_308 VGND VGND VPWR VPWR sky130_fd_sc_hd__decap_3
XFILLER_67_319 VGND VGND VPWR VPWR sky130_fd_sc_hd__decap_3
XFILLER_95_617 VGND VGND VPWR VPWR sky130_fd_sc_hd__decap_3
XFILLER_95_628 VGND VGND VPWR VPWR sky130_fd_sc_hd__decap_3
XFILLER_48_533 VGND VGND VPWR VPWR sky130_fd_sc_hd__decap_3
XFILLER_57_50 VGND VGND VPWR VPWR sky130_fd_sc_hd__decap_3
XFILLER_48_566 VGND VGND VPWR VPWR sky130_fd_sc_hd__decap_3
XFILLER_57_83 VGND VGND VPWR VPWR sky130_fd_sc_hd__fill_2
XFILLER_63_503 VGND VGND VPWR VPWR sky130_fd_sc_hd__fill_1
XFILLER_35_227 VGND VGND VPWR VPWR sky130_fd_sc_hd__decap_3
XFILLER_75_385 VGND VGND VPWR VPWR sky130_fd_sc_hd__decap_3
XFILLER_75_396 VGND VGND VPWR VPWR sky130_fd_sc_hd__decap_3
XFILLER_90_300 VGND VGND VPWR VPWR sky130_fd_sc_hd__decap_3
XFILLER_16_430 VGND VGND VPWR VPWR sky130_fd_sc_hd__decap_3
XFILLER_16_485 VGND VGND VPWR VPWR sky130_fd_sc_hd__decap_3
XFILLER_50_219 VGND VGND VPWR VPWR sky130_fd_sc_hd__decap_3
XFILLER_73_60 VGND VGND VPWR VPWR sky130_fd_sc_hd__fill_1
XFILLER_90_388 VGND VGND VPWR VPWR sky130_fd_sc_hd__decap_3
XFILLER_31_433 VGND VGND VPWR VPWR sky130_fd_sc_hd__fill_2
XFILLER_43_271 VGND VGND VPWR VPWR sky130_fd_sc_hd__fill_2
XFILLER_43_293 VGND VGND VPWR VPWR sky130_fd_sc_hd__decap_3
XFILLER_71_591 VGND VGND VPWR VPWR sky130_fd_sc_hd__decap_3
XFILLER_8_651 VGND VGND VPWR VPWR sky130_fd_sc_hd__decap_3
X_5490_ _5490_/A VGND VGND VPWR VPWR _5490_/Y sky130_fd_sc_hd__bufinv_8
X_4510_ _7898_/B _8059_/Q VGND VGND VPWR VPWR _4511_/A sky130_fd_sc_hd__and2_2
XFILLER_7_172 VGND VGND VPWR VPWR sky130_fd_sc_hd__fill_2
XFILLER_8_695 VGND VGND VPWR VPWR sky130_fd_sc_hd__decap_3
X_4441_ _4441_/A VGND VGND VPWR VPWR _8158_/D sky130_fd_sc_hd__buf_1
XFILLER_7_194 VGND VGND VPWR VPWR sky130_fd_sc_hd__decap_3
XPHY_EDGE_ROW_9_Right_9 VGND VGND VPWR VPWR sky130_fd_sc_hd__decap_3
X_7160_ _8270_/Q _7159_/Y _4805_/A VGND VGND VPWR VPWR _7160_/X sky130_fd_sc_hd__a21o_2
XFILLER_98_411 VGND VGND VPWR VPWR sky130_fd_sc_hd__decap_3
X_6111_ _7193_/A _7243_/A _6110_/X VGND VGND VPWR VPWR _6111_/Y sky130_fd_sc_hd__a21oi_2
X_4372_ _7930_/B _4372_/B VGND VGND VPWR VPWR _4373_/A sky130_fd_sc_hd__and2_2
XFILLER_112_232 VGND VGND VPWR VPWR sky130_fd_sc_hd__decap_3
XFILLER_86_606 VGND VGND VPWR VPWR sky130_fd_sc_hd__decap_3
XFILLER_98_455 VGND VGND VPWR VPWR sky130_fd_sc_hd__decap_3
X_7091_ _7058_/Y _7063_/X _7075_/X _7090_/Y _6910_/A VGND VGND VPWR VPWR _7091_/X
+ sky130_fd_sc_hd__a32o_2
XFILLER_100_416 VGND VGND VPWR VPWR sky130_fd_sc_hd__decap_3
XFILLER_39_511 VGND VGND VPWR VPWR sky130_fd_sc_hd__decap_3
XFILLER_85_116 VGND VGND VPWR VPWR sky130_fd_sc_hd__decap_3
XFILLER_86_617 VGND VGND VPWR VPWR sky130_fd_sc_hd__decap_3
XFILLER_98_477 VGND VGND VPWR VPWR sky130_fd_sc_hd__fill_2
XFILLER_98_499 VGND VGND VPWR VPWR sky130_fd_sc_hd__decap_3
XPHY_EDGE_ROW_107_Right_107 VGND VGND VPWR VPWR sky130_fd_sc_hd__decap_3
X_6042_ _6042_/A1 _6395_/A _6138_/C VGND VGND VPWR VPWR _6043_/B sky130_fd_sc_hd__o21a_2
XFILLER_100_427 VGND VGND VPWR VPWR sky130_fd_sc_hd__decap_3
XFILLER_112_287 VGND VGND VPWR VPWR sky130_fd_sc_hd__decap_3
XFILLER_39_522 VGND VGND VPWR VPWR sky130_fd_sc_hd__decap_3
XFILLER_79_691 VGND VGND VPWR VPWR sky130_fd_sc_hd__decap_3
XFILLER_85_138 VGND VGND VPWR VPWR sky130_fd_sc_hd__fill_1
XFILLER_39_555 VGND VGND VPWR VPWR sky130_fd_sc_hd__decap_3
XFILLER_66_352 VGND VGND VPWR VPWR sky130_fd_sc_hd__fill_2
XFILLER_54_536 VGND VGND VPWR VPWR sky130_fd_sc_hd__decap_3
XFILLER_66_374 VGND VGND VPWR VPWR sky130_fd_sc_hd__decap_3
XFILLER_66_396 VGND VGND VPWR VPWR sky130_fd_sc_hd__fill_2
XFILLER_81_322 VGND VGND VPWR VPWR sky130_fd_sc_hd__decap_3
XFILLER_94_683 VGND VGND VPWR VPWR sky130_fd_sc_hd__decap_3
XFILLER_94_694 VGND VGND VPWR VPWR sky130_fd_sc_hd__decap_3
X_7993_ _8396_/CLK _7993_/D VGND VGND VPWR VPWR _7993_/Q sky130_fd_sc_hd__dfxtp_2
XTAP_TAPCELL_ROW_37_734 VGND VPWR sky130_fd_sc_hd__tapvpwrvgnd_1
XFILLER_54_558 VGND VGND VPWR VPWR sky130_fd_sc_hd__decap_3
XFILLER_81_355 VGND VGND VPWR VPWR sky130_fd_sc_hd__decap_3
XFILLER_93_193 VGND VGND VPWR VPWR sky130_fd_sc_hd__decap_3
X_6944_ _6944_/A _6988_/B VGND VGND VPWR VPWR _6944_/Y sky130_fd_sc_hd__nor2_2
XTAP_TAPCELL_ROW_37_745 VGND VPWR sky130_fd_sc_hd__tapvpwrvgnd_1
XFILLER_22_400 VGND VGND VPWR VPWR sky130_fd_sc_hd__decap_3
XFILLER_53_19 VGND VGND VPWR VPWR sky130_fd_sc_hd__decap_3
XFILLER_81_388 VGND VGND VPWR VPWR sky130_fd_sc_hd__decap_3
XFILLER_81_399 VGND VGND VPWR VPWR sky130_fd_sc_hd__decap_3
X_6875_ _8196_/Q _8260_/Q _8261_/Q _8197_/Q VGND VGND VPWR VPWR _6875_/X sky130_fd_sc_hd__a22o_2
XTAP_TAPCELL_ROW_17_480 VGND VPWR sky130_fd_sc_hd__tapvpwrvgnd_1
XFILLER_10_617 VGND VGND VPWR VPWR sky130_fd_sc_hd__fill_1
X_5826_ _6247_/B _5821_/X _5825_/X VGND VGND VPWR VPWR _5826_/Y sky130_fd_sc_hd__o21ai_2
X_5757_ _5696_/Y _5709_/B _5702_/Y VGND VGND VPWR VPWR _5757_/Y sky130_fd_sc_hd__o21ai_2
XFILLER_5_109 VGND VGND VPWR VPWR sky130_fd_sc_hd__decap_3
X_4708_ _7898_/B _8158_/Q VGND VGND VPWR VPWR _4709_/A sky130_fd_sc_hd__and2_2
X_7427_ _7426_/B1 _5407_/X _6497_/B _7424_/X VGND VGND VPWR VPWR _7427_/X sky130_fd_sc_hd__o2bb2a_2
Xrebuffer269 _8176_/Q VGND VGND VPWR VPWR _6097_/A sky130_fd_sc_hd__buf_2
X_5688_ _5690_/B _5688_/B _8166_/Q VGND VGND VPWR VPWR _6147_/C sky130_fd_sc_hd__or3_4
X_4639_ _4639_/A VGND VGND VPWR VPWR _8257_/D sky130_fd_sc_hd__buf_1
XFILLER_1_315 VGND VGND VPWR VPWR sky130_fd_sc_hd__fill_1
XFILLER_89_422 VGND VGND VPWR VPWR sky130_fd_sc_hd__decap_3
X_7358_ _7631_/A _7354_/X _7357_/X VGND VGND VPWR VPWR _7358_/Y sky130_fd_sc_hd__o21ai_2
XFILLER_103_243 VGND VGND VPWR VPWR sky130_fd_sc_hd__decap_3
XFILLER_77_606 VGND VGND VPWR VPWR sky130_fd_sc_hd__decap_3
XFILLER_89_455 VGND VGND VPWR VPWR sky130_fd_sc_hd__decap_3
X_7289_ _7289_/A _7289_/B VGND VGND VPWR VPWR _7290_/B sky130_fd_sc_hd__and2_2
X_6309_ _5278_/X _6286_/A _6308_/X _6763_/A VGND VGND VPWR VPWR _6309_/X sky130_fd_sc_hd__a22o_2
XFILLER_77_617 VGND VGND VPWR VPWR sky130_fd_sc_hd__decap_3
XFILLER_89_488 VGND VGND VPWR VPWR sky130_fd_sc_hd__decap_3
XFILLER_94_26 VGND VGND VPWR VPWR sky130_fd_sc_hd__fill_2
XFILLER_27_20 VGND VGND VPWR VPWR sky130_fd_sc_hd__decap_3
XFILLER_57_330 VGND VGND VPWR VPWR sky130_fd_sc_hd__decap_3
XFILLER_57_352 VGND VGND VPWR VPWR sky130_fd_sc_hd__decap_3
XFILLER_69_190 VGND VGND VPWR VPWR sky130_fd_sc_hd__decap_3
XFILLER_27_42 VGND VGND VPWR VPWR sky130_fd_sc_hd__decap_3
XFILLER_45_514 VGND VGND VPWR VPWR sky130_fd_sc_hd__decap_3
XFILLER_57_396 VGND VGND VPWR VPWR sky130_fd_sc_hd__decap_3
XFILLER_72_300 VGND VGND VPWR VPWR sky130_fd_sc_hd__decap_3
XFILLER_85_683 VGND VGND VPWR VPWR sky130_fd_sc_hd__decap_3
XFILLER_91_119 VGND VGND VPWR VPWR sky130_fd_sc_hd__decap_3
XFILLER_27_64 VGND VGND VPWR VPWR sky130_fd_sc_hd__decap_3
XFILLER_45_547 VGND VGND VPWR VPWR sky130_fd_sc_hd__decap_3
XFILLER_72_333 VGND VGND VPWR VPWR sky130_fd_sc_hd__decap_3
XFILLER_25_260 VGND VGND VPWR VPWR sky130_fd_sc_hd__decap_3
XFILLER_60_528 VGND VGND VPWR VPWR sky130_fd_sc_hd__decap_3
XFILLER_72_377 VGND VGND VPWR VPWR sky130_fd_sc_hd__decap_3
XFILLER_72_388 VGND VGND VPWR VPWR sky130_fd_sc_hd__decap_3
XFILLER_53_591 VGND VGND VPWR VPWR sky130_fd_sc_hd__decap_3
XFILLER_13_444 VGND VGND VPWR VPWR sky130_fd_sc_hd__decap_3
XFILLER_13_455 VGND VGND VPWR VPWR sky130_fd_sc_hd__decap_3
XFILLER_43_63 VGND VGND VPWR VPWR sky130_fd_sc_hd__decap_3
XFILLER_40_296 VGND VGND VPWR VPWR sky130_fd_sc_hd__decap_3
XFILLER_43_96 VGND VGND VPWR VPWR sky130_fd_sc_hd__fill_1
XFILLER_9_437 VGND VGND VPWR VPWR sky130_fd_sc_hd__decap_3
XTAP_TAPCELL_ROW_97_1522 VGND VPWR sky130_fd_sc_hd__tapvpwrvgnd_1
XFILLER_4_131 VGND VGND VPWR VPWR sky130_fd_sc_hd__fill_2
Xrebuffer792 rebuffer795/X VGND VGND VPWR VPWR rebuffer792/X sky130_fd_sc_hd__buf_6
XFILLER_5_676 VGND VGND VPWR VPWR sky130_fd_sc_hd__decap_3
XFILLER_4_197 VGND VGND VPWR VPWR sky130_fd_sc_hd__decap_3
XFILLER_4_35 VGND VGND VPWR VPWR sky130_fd_sc_hd__decap_3
XFILLER_4_57 VGND VGND VPWR VPWR sky130_fd_sc_hd__fill_2
XFILLER_68_639 VGND VGND VPWR VPWR sky130_fd_sc_hd__decap_3
XFILLER_95_414 VGND VGND VPWR VPWR sky130_fd_sc_hd__decap_3
XFILLER_67_116 VGND VGND VPWR VPWR sky130_fd_sc_hd__decap_3
XFILLER_67_149 VGND VGND VPWR VPWR sky130_fd_sc_hd__decap_3
XFILLER_95_447 VGND VGND VPWR VPWR sky130_fd_sc_hd__fill_1
XFILLER_76_650 VGND VGND VPWR VPWR sky130_fd_sc_hd__decap_3
XFILLER_36_525 VGND VGND VPWR VPWR sky130_fd_sc_hd__decap_3
XFILLER_48_396 VGND VGND VPWR VPWR sky130_fd_sc_hd__decap_3
XFILLER_76_672 VGND VGND VPWR VPWR sky130_fd_sc_hd__decap_3
XFILLER_63_355 VGND VGND VPWR VPWR sky130_fd_sc_hd__decap_3
XFILLER_90_141 VGND VGND VPWR VPWR sky130_fd_sc_hd__fill_2
XFILLER_23_219 VGND VGND VPWR VPWR sky130_fd_sc_hd__decap_3
XFILLER_63_388 VGND VGND VPWR VPWR sky130_fd_sc_hd__decap_3
XFILLER_90_152 VGND VGND VPWR VPWR sky130_fd_sc_hd__decap_3
XTAP_TAPCELL_ROW_106_1640 VGND VPWR sky130_fd_sc_hd__tapvpwrvgnd_1
X_4990_ _8283_/Q _4989_/B _8219_/Q VGND VGND VPWR VPWR _4990_/X sky130_fd_sc_hd__a21bo_2
XTAP_TAPCELL_ROW_34_704 VGND VPWR sky130_fd_sc_hd__tapvpwrvgnd_1
XFILLER_51_539 VGND VGND VPWR VPWR sky130_fd_sc_hd__decap_3
XFILLER_63_399 VGND VGND VPWR VPWR sky130_fd_sc_hd__fill_2
X_6660_ _8193_/Q _6660_/B VGND VGND VPWR VPWR _6661_/B sky130_fd_sc_hd__xnor2_2
XFILLER_31_263 VGND VGND VPWR VPWR sky130_fd_sc_hd__decap_3
X_6591_ _6591_/A VGND VGND VPWR VPWR _8325_/D sky130_fd_sc_hd__buf_1
X_5611_ _5572_/Y _5609_/Y _7135_/B VGND VGND VPWR VPWR _5611_/Y sky130_fd_sc_hd__a21oi_2
XFILLER_117_302 VGND VGND VPWR VPWR sky130_fd_sc_hd__fill_1
XFILLER_31_296 VGND VGND VPWR VPWR sky130_fd_sc_hd__decap_3
X_8330_ _8397_/CLK _8330_/D VGND VGND VPWR VPWR _8330_/Q sky130_fd_sc_hd__dfxtp_2
X_5542_ _5542_/A _5542_/B VGND VGND VPWR VPWR _5542_/Y sky130_fd_sc_hd__nor2_2
XFILLER_117_368 VGND VGND VPWR VPWR sky130_fd_sc_hd__decap_3
XFILLER_8_492 VGND VGND VPWR VPWR sky130_fd_sc_hd__decap_3
X_8261_ _8400_/CLK _8261_/D VGND VGND VPWR VPWR _8261_/Q sky130_fd_sc_hd__dfxtp_2
X_5473_ _5470_/X _5142_/X _6648_/A _5472_/Y VGND VGND VPWR VPWR _5474_/B sky130_fd_sc_hd__o2bb2a_2
XTAP_TAPCELL_ROW_57_1005 VGND VPWR sky130_fd_sc_hd__tapvpwrvgnd_1
XTAP_TAPCELL_ROW_117_1780 VGND VPWR sky130_fd_sc_hd__tapvpwrvgnd_1
X_8192_ _8389_/CLK _8192_/D VGND VGND VPWR VPWR _8192_/Q sky130_fd_sc_hd__dfxtp_2
X_7212_ _7213_/A _7213_/B VGND VGND VPWR VPWR _7212_/X sky130_fd_sc_hd__or2_2
X_4424_ _7843_/A _4424_/B VGND VGND VPWR VPWR _4425_/A sky130_fd_sc_hd__and2_2
X_7143_ _7159_/A _4795_/B _6992_/A VGND VGND VPWR VPWR _7143_/Y sky130_fd_sc_hd__a21oi_2
X_4355_ _4355_/A VGND VGND VPWR VPWR _8115_/D sky130_fd_sc_hd__buf_1
XFILLER_113_574 VGND VGND VPWR VPWR sky130_fd_sc_hd__decap_3
XFILLER_59_617 VGND VGND VPWR VPWR sky130_fd_sc_hd__decap_3
X_7074_ _8206_/Q _7074_/B VGND VGND VPWR VPWR _7074_/Y sky130_fd_sc_hd__nor2_2
XFILLER_100_224 VGND VGND VPWR VPWR sky130_fd_sc_hd__decap_3
XFILLER_58_116 VGND VGND VPWR VPWR sky130_fd_sc_hd__decap_3
XFILLER_86_436 VGND VGND VPWR VPWR sky130_fd_sc_hd__decap_3
X_4286_ _7843_/A _4286_/B VGND VGND VPWR VPWR _4287_/A sky130_fd_sc_hd__and2_2
XFILLER_100_268 VGND VGND VPWR VPWR sky130_fd_sc_hd__decap_3
XFILLER_39_330 VGND VGND VPWR VPWR sky130_fd_sc_hd__decap_3
XFILLER_74_609 VGND VGND VPWR VPWR sky130_fd_sc_hd__decap_3
X_6025_ _6825_/A _6192_/B VGND VGND VPWR VPWR _6098_/A sky130_fd_sc_hd__or2_2
XFILLER_27_503 VGND VGND VPWR VPWR sky130_fd_sc_hd__fill_1
XFILLER_39_363 VGND VGND VPWR VPWR sky130_fd_sc_hd__decap_3
XFILLER_39_385 VGND VGND VPWR VPWR sky130_fd_sc_hd__decap_3
XFILLER_54_300 VGND VGND VPWR VPWR sky130_fd_sc_hd__decap_3
XFILLER_94_480 VGND VGND VPWR VPWR sky130_fd_sc_hd__fill_1
XFILLER_27_547 VGND VGND VPWR VPWR sky130_fd_sc_hd__decap_3
XFILLER_54_333 VGND VGND VPWR VPWR sky130_fd_sc_hd__fill_1
XFILLER_64_29 VGND VGND VPWR VPWR sky130_fd_sc_hd__decap_3
XFILLER_82_642 VGND VGND VPWR VPWR sky130_fd_sc_hd__fill_2
XTAP_TAPCELL_ROW_68_1145 VGND VPWR sky130_fd_sc_hd__tapvpwrvgnd_1
XFILLER_14_219 VGND VGND VPWR VPWR sky130_fd_sc_hd__fill_2
XFILLER_54_388 VGND VGND VPWR VPWR sky130_fd_sc_hd__decap_3
X_7976_ _8379_/CLK _7976_/D VGND VGND VPWR VPWR _7976_/Q sky130_fd_sc_hd__dfxtp_2
XFILLER_35_591 VGND VGND VPWR VPWR sky130_fd_sc_hd__fill_1
X_6927_ _8200_/Q _6927_/B _7009_/C VGND VGND VPWR VPWR _7072_/B sky130_fd_sc_hd__and3_2
XTAP_TAPCELL_ROW_81_1312 VGND VPWR sky130_fd_sc_hd__tapvpwrvgnd_1
XFILLER_50_561 VGND VGND VPWR VPWR sky130_fd_sc_hd__decap_3
XTAP_TAPCELL_ROW_12_409 VGND VPWR sky130_fd_sc_hd__tapvpwrvgnd_1
X_6858_ _6848_/B _6829_/X _6874_/B VGND VGND VPWR VPWR _6858_/X sky130_fd_sc_hd__mux2_2
XFILLER_13_11 VGND VGND VPWR VPWR sky130_fd_sc_hd__fill_2
XFILLER_13_33 VGND VGND VPWR VPWR sky130_fd_sc_hd__fill_1
XFILLER_22_274 VGND VGND VPWR VPWR sky130_fd_sc_hd__fill_1
X_5809_ _6999_/A1 _5806_/X _5808_/X VGND VGND VPWR VPWR _5809_/Y sky130_fd_sc_hd__a21oi_2
XFILLER_6_407 VGND VGND VPWR VPWR sky130_fd_sc_hd__decap_3
X_6789_ _8196_/Q _8260_/Q VGND VGND VPWR VPWR _6791_/A sky130_fd_sc_hd__or2b_2
XFILLER_108_324 VGND VGND VPWR VPWR sky130_fd_sc_hd__decap_3
XFILLER_108_368 VGND VGND VPWR VPWR sky130_fd_sc_hd__fill_1
XTAP_TAPCELL_ROW_79_1285 VGND VPWR sky130_fd_sc_hd__tapvpwrvgnd_1
XTAP_TAPCELL_ROW_92_1452 VGND VPWR sky130_fd_sc_hd__tapvpwrvgnd_1
XFILLER_104_563 VGND VGND VPWR VPWR sky130_fd_sc_hd__decap_3
XFILLER_89_274 VGND VGND VPWR VPWR sky130_fd_sc_hd__decap_3
XFILLER_104_585 VGND VGND VPWR VPWR sky130_fd_sc_hd__decap_3
XFILLER_49_116 VGND VGND VPWR VPWR sky130_fd_sc_hd__decap_3
XFILLER_77_436 VGND VGND VPWR VPWR sky130_fd_sc_hd__decap_3
XFILLER_77_447 VGND VGND VPWR VPWR sky130_fd_sc_hd__fill_1
XFILLER_38_41 VGND VGND VPWR VPWR sky130_fd_sc_hd__fill_1
XFILLER_38_52 VGND VGND VPWR VPWR sky130_fd_sc_hd__decap_3
XFILLER_77_458 VGND VGND VPWR VPWR sky130_fd_sc_hd__decap_3
XFILLER_38_85 VGND VGND VPWR VPWR sky130_fd_sc_hd__decap_3
XFILLER_57_160 VGND VGND VPWR VPWR sky130_fd_sc_hd__decap_3
XFILLER_73_620 VGND VGND VPWR VPWR sky130_fd_sc_hd__decap_3
XFILLER_92_439 VGND VGND VPWR VPWR sky130_fd_sc_hd__decap_3
XFILLER_18_536 VGND VGND VPWR VPWR sky130_fd_sc_hd__decap_3
XFILLER_45_333 VGND VGND VPWR VPWR sky130_fd_sc_hd__decap_3
XFILLER_72_130 VGND VGND VPWR VPWR sky130_fd_sc_hd__decap_3
XFILLER_73_642 VGND VGND VPWR VPWR sky130_fd_sc_hd__fill_1
XFILLER_33_517 VGND VGND VPWR VPWR sky130_fd_sc_hd__decap_3
XFILLER_45_355 VGND VGND VPWR VPWR sky130_fd_sc_hd__decap_3
XFILLER_45_377 VGND VGND VPWR VPWR sky130_fd_sc_hd__decap_3
XFILLER_72_141 VGND VGND VPWR VPWR sky130_fd_sc_hd__fill_1
XFILLER_73_664 VGND VGND VPWR VPWR sky130_fd_sc_hd__decap_3
XFILLER_73_697 VGND VGND VPWR VPWR sky130_fd_sc_hd__fill_1
XFILLER_26_580 VGND VGND VPWR VPWR sky130_fd_sc_hd__decap_3
XFILLER_45_399 VGND VGND VPWR VPWR sky130_fd_sc_hd__decap_3
XFILLER_60_314 VGND VGND VPWR VPWR sky130_fd_sc_hd__decap_3
XFILLER_13_241 VGND VGND VPWR VPWR sky130_fd_sc_hd__decap_3
XFILLER_41_561 VGND VGND VPWR VPWR sky130_fd_sc_hd__decap_3
XFILLER_41_583 VGND VGND VPWR VPWR sky130_fd_sc_hd__fill_2
XFILLER_70_50 VGND VGND VPWR VPWR sky130_fd_sc_hd__decap_3
XTAP_TAPCELL_ROW_101_1570 VGND VPWR sky130_fd_sc_hd__tapvpwrvgnd_1
XFILLER_70_83 VGND VGND VPWR VPWR sky130_fd_sc_hd__fill_1
XFILLER_70_94 VGND VGND VPWR VPWR sky130_fd_sc_hd__decap_3
Xclkload15 _8228_/CLK VGND VGND VPWR VPWR clkload15/X sky130_fd_sc_hd__clkbuf_4
Xclkload26 _8377_/CLK VGND VGND VPWR VPWR clkload26/Y sky130_fd_sc_hd__clkinv_2
XFILLER_114_305 VGND VGND VPWR VPWR sky130_fd_sc_hd__decap_3
XFILLER_107_390 VGND VGND VPWR VPWR sky130_fd_sc_hd__fill_2
XFILLER_114_349 VGND VGND VPWR VPWR sky130_fd_sc_hd__fill_1
XFILLER_110_500 VGND VGND VPWR VPWR sky130_fd_sc_hd__decap_3
XFILLER_68_403 VGND VGND VPWR VPWR sky130_fd_sc_hd__decap_3
X_4140_ _7930_/B _7940_/Q VGND VGND VPWR VPWR _4141_/A sky130_fd_sc_hd__and2_2
XFILLER_110_533 VGND VGND VPWR VPWR sky130_fd_sc_hd__decap_3
XFILLER_68_436 VGND VGND VPWR VPWR sky130_fd_sc_hd__decap_3
XFILLER_95_222 VGND VGND VPWR VPWR sky130_fd_sc_hd__fill_2
XFILLER_95_233 VGND VGND VPWR VPWR sky130_fd_sc_hd__decap_3
XFILLER_49_661 VGND VGND VPWR VPWR sky130_fd_sc_hd__decap_3
XFILLER_68_469 VGND VGND VPWR VPWR sky130_fd_sc_hd__decap_3
XFILLER_95_266 VGND VGND VPWR VPWR sky130_fd_sc_hd__decap_3
X_4071_ _4071_/A VGND VGND VPWR VPWR _7973_/D sky130_fd_sc_hd__buf_1
XFILLER_110_577 VGND VGND VPWR VPWR sky130_fd_sc_hd__decap_3
XFILLER_55_119 VGND VGND VPWR VPWR sky130_fd_sc_hd__decap_3
XFILLER_76_480 VGND VGND VPWR VPWR sky130_fd_sc_hd__decap_3
XFILLER_36_333 VGND VGND VPWR VPWR sky130_fd_sc_hd__decap_3
XFILLER_48_193 VGND VGND VPWR VPWR sky130_fd_sc_hd__decap_3
XFILLER_64_642 VGND VGND VPWR VPWR sky130_fd_sc_hd__fill_2
X_7830_ _5186_/A _6454_/A _7827_/B _7193_/A _7829_/X VGND VGND VPWR VPWR _7831_/A
+ sky130_fd_sc_hd__o221a_2
XFILLER_24_506 VGND VGND VPWR VPWR sky130_fd_sc_hd__decap_3
XFILLER_63_152 VGND VGND VPWR VPWR sky130_fd_sc_hd__decap_3
XFILLER_91_461 VGND VGND VPWR VPWR sky130_fd_sc_hd__decap_3
XTAP_TAPCELL_ROW_47_873 VGND VPWR sky130_fd_sc_hd__tapvpwrvgnd_1
XFILLER_24_539 VGND VGND VPWR VPWR sky130_fd_sc_hd__fill_2
XFILLER_36_388 VGND VGND VPWR VPWR sky130_fd_sc_hd__decap_3
XFILLER_51_325 VGND VGND VPWR VPWR sky130_fd_sc_hd__decap_3
X_7761_ _7228_/B _7663_/B _7660_/X VGND VGND VPWR VPWR _7761_/Y sky130_fd_sc_hd__o21ai_2
X_4973_ _4973_/A _4973_/B VGND VGND VPWR VPWR _4973_/Y sky130_fd_sc_hd__nor2_2
XFILLER_51_369 VGND VGND VPWR VPWR sky130_fd_sc_hd__fill_1
X_7692_ _7754_/A _7690_/Y _7691_/Y _7796_/A VGND VGND VPWR VPWR _7692_/X sky130_fd_sc_hd__a22o_2
X_6712_ _8188_/Q _6712_/B _8191_/Q _8192_/Q VGND VGND VPWR VPWR _6713_/D sky130_fd_sc_hd__and4_2
XFILLER_20_701 VGND VGND VPWR VPWR sky130_fd_sc_hd__decap_3
X_6643_ _8257_/Q _5422_/A _6641_/X _5273_/Y _7453_/A VGND VGND VPWR VPWR _6643_/X
+ sky130_fd_sc_hd__a221o_2
XTAP_TAPCELL_ROW_63_1075 VGND VPWR sky130_fd_sc_hd__tapvpwrvgnd_1
Xclkload9 clkload9/A VGND VGND VPWR VPWR clkload9/X sky130_fd_sc_hd__clkbuf_4
XTAP_TAPCELL_ROW_119_1820 VGND VPWR sky130_fd_sc_hd__tapvpwrvgnd_1
X_6574_ _5985_/X _6573_/X _5631_/X _6275_/X _6070_/A _6355_/A VGND VGND VPWR VPWR
+ _7626_/B sky130_fd_sc_hd__mux4_2
XFILLER_117_143 VGND VGND VPWR VPWR sky130_fd_sc_hd__decap_3
X_8313_ _8380_/CLK _8313_/D VGND VGND VPWR VPWR _8313_/Q sky130_fd_sc_hd__dfxtp_2
X_5525_ _5966_/A _5513_/Y _5524_/X VGND VGND VPWR VPWR _5525_/Y sky130_fd_sc_hd__o21ai_2
X_8244_ _8377_/CLK _8244_/D VGND VGND VPWR VPWR _8244_/Q sky130_fd_sc_hd__dfxtp_2
X_5456_ _6109_/A _6721_/B _6721_/C VGND VGND VPWR VPWR _5456_/X sky130_fd_sc_hd__and3_2
XFILLER_105_349 VGND VGND VPWR VPWR sky130_fd_sc_hd__decap_3
X_4407_ _4407_/A VGND VGND VPWR VPWR _8141_/D sky130_fd_sc_hd__buf_1
XFILLER_99_561 VGND VGND VPWR VPWR sky130_fd_sc_hd__decap_3
X_8175_ _8187_/CLK _8175_/D VGND VGND VPWR VPWR _8175_/Q sky130_fd_sc_hd__dfxtp_4
X_5387_ _6109_/A _5372_/X _5386_/X _5245_/Y VGND VGND VPWR VPWR _5387_/X sky130_fd_sc_hd__a22o_2
XFILLER_101_500 VGND VGND VPWR VPWR sky130_fd_sc_hd__decap_3
XFILLER_101_511 VGND VGND VPWR VPWR sky130_fd_sc_hd__decap_3
XFILLER_115_24 VGND VGND VPWR VPWR sky130_fd_sc_hd__decap_3
XFILLER_59_414 VGND VGND VPWR VPWR sky130_fd_sc_hd__decap_3
XFILLER_59_447 VGND VGND VPWR VPWR sky130_fd_sc_hd__fill_1
XFILLER_86_200 VGND VGND VPWR VPWR sky130_fd_sc_hd__decap_3
X_7126_ _8229_/Q _7126_/B VGND VGND VPWR VPWR _7126_/X sky130_fd_sc_hd__or2_2
X_4338_ _7898_/B _4338_/B VGND VGND VPWR VPWR _4339_/A sky130_fd_sc_hd__and2_2
XFILLER_101_544 VGND VGND VPWR VPWR sky130_fd_sc_hd__decap_3
XFILLER_47_609 VGND VGND VPWR VPWR sky130_fd_sc_hd__decap_3
XFILLER_86_233 VGND VGND VPWR VPWR sky130_fd_sc_hd__decap_3
X_7057_ _8270_/Q _5422_/X _6687_/X _7056_/X VGND VGND VPWR VPWR _7057_/X sky130_fd_sc_hd__a211o_2
X_4269_ _4269_/A VGND VGND VPWR VPWR _8072_/D sky130_fd_sc_hd__buf_1
XFILLER_101_577 VGND VGND VPWR VPWR sky130_fd_sc_hd__decap_3
XFILLER_27_311 VGND VGND VPWR VPWR sky130_fd_sc_hd__decap_3
XFILLER_74_439 VGND VGND VPWR VPWR sky130_fd_sc_hd__decap_3
XFILLER_86_288 VGND VGND VPWR VPWR sky130_fd_sc_hd__decap_3
X_6008_ _6008_/A _6008_/B VGND VGND VPWR VPWR _6008_/Y sky130_fd_sc_hd__nand2_2
XFILLER_54_130 VGND VGND VPWR VPWR sky130_fd_sc_hd__decap_3
XFILLER_27_355 VGND VGND VPWR VPWR sky130_fd_sc_hd__decap_3
XFILLER_54_141 VGND VGND VPWR VPWR sky130_fd_sc_hd__decap_3
XFILLER_55_664 VGND VGND VPWR VPWR sky130_fd_sc_hd__decap_3
XFILLER_70_601 VGND VGND VPWR VPWR sky130_fd_sc_hd__decap_3
XFILLER_27_388 VGND VGND VPWR VPWR sky130_fd_sc_hd__decap_3
XFILLER_54_174 VGND VGND VPWR VPWR sky130_fd_sc_hd__decap_3
XFILLER_70_623 VGND VGND VPWR VPWR sky130_fd_sc_hd__fill_1
XFILLER_70_634 VGND VGND VPWR VPWR sky130_fd_sc_hd__decap_3
XFILLER_82_494 VGND VGND VPWR VPWR sky130_fd_sc_hd__decap_3
XFILLER_91_38 VGND VGND VPWR VPWR sky130_fd_sc_hd__decap_3
XFILLER_91_49 VGND VGND VPWR VPWR sky130_fd_sc_hd__decap_3
X_7959_ _8388_/CLK _7959_/D VGND VGND VPWR VPWR _7959_/Q sky130_fd_sc_hd__dfxtp_2
XFILLER_70_656 VGND VGND VPWR VPWR sky130_fd_sc_hd__decap_3
XFILLER_23_561 VGND VGND VPWR VPWR sky130_fd_sc_hd__decap_3
XFILLER_24_76 VGND VGND VPWR VPWR sky130_fd_sc_hd__fill_1
XTAP_TAPCELL_ROW_25_589 VGND VPWR sky130_fd_sc_hd__tapvpwrvgnd_1
XTAP_TAPCELL_ROW_25_578 VGND VPWR sky130_fd_sc_hd__tapvpwrvgnd_1
XFILLER_10_222 VGND VGND VPWR VPWR sky130_fd_sc_hd__decap_3
XFILLER_40_20 VGND VGND VPWR VPWR sky130_fd_sc_hd__decap_3
XFILLER_7_727 VGND VGND VPWR VPWR sky130_fd_sc_hd__fill_1
XFILLER_109_666 VGND VGND VPWR VPWR sky130_fd_sc_hd__decap_3
XFILLER_10_299 VGND VGND VPWR VPWR sky130_fd_sc_hd__decap_3
XFILLER_40_42 VGND VGND VPWR VPWR sky130_fd_sc_hd__decap_3
XFILLER_6_259 VGND VGND VPWR VPWR sky130_fd_sc_hd__decap_3
XFILLER_108_165 VGND VGND VPWR VPWR sky130_fd_sc_hd__decap_3
XFILLER_2_410 VGND VGND VPWR VPWR sky130_fd_sc_hd__fill_2
XFILLER_2_421 VGND VGND VPWR VPWR sky130_fd_sc_hd__decap_3
XFILLER_78_701 VGND VGND VPWR VPWR sky130_fd_sc_hd__decap_3
XFILLER_104_360 VGND VGND VPWR VPWR sky130_fd_sc_hd__decap_3
XFILLER_104_371 VGND VGND VPWR VPWR sky130_fd_sc_hd__decap_3
XFILLER_77_200 VGND VGND VPWR VPWR sky130_fd_sc_hd__decap_3
XFILLER_49_95 VGND VGND VPWR VPWR sky130_fd_sc_hd__decap_3
XFILLER_77_255 VGND VGND VPWR VPWR sky130_fd_sc_hd__decap_3
XFILLER_93_704 VGND VGND VPWR VPWR sky130_fd_sc_hd__decap_3
XFILLER_65_417 VGND VGND VPWR VPWR sky130_fd_sc_hd__decap_3
XFILLER_77_299 VGND VGND VPWR VPWR sky130_fd_sc_hd__decap_3
XFILLER_92_203 VGND VGND VPWR VPWR sky130_fd_sc_hd__decap_3
XFILLER_58_480 VGND VGND VPWR VPWR sky130_fd_sc_hd__decap_3
XFILLER_65_50 VGND VGND VPWR VPWR sky130_fd_sc_hd__decap_3
XFILLER_92_225 VGND VGND VPWR VPWR sky130_fd_sc_hd__decap_3
XFILLER_18_377 VGND VGND VPWR VPWR sky130_fd_sc_hd__decap_3
XFILLER_33_303 VGND VGND VPWR VPWR sky130_fd_sc_hd__decap_3
XFILLER_45_130 VGND VGND VPWR VPWR sky130_fd_sc_hd__decap_3
XFILLER_65_72 VGND VGND VPWR VPWR sky130_fd_sc_hd__decap_3
XFILLER_73_461 VGND VGND VPWR VPWR sky130_fd_sc_hd__decap_3
XFILLER_80_409 VGND VGND VPWR VPWR sky130_fd_sc_hd__fill_2
XFILLER_45_185 VGND VGND VPWR VPWR sky130_fd_sc_hd__decap_3
XFILLER_60_100 VGND VGND VPWR VPWR sky130_fd_sc_hd__fill_1
XFILLER_60_122 VGND VGND VPWR VPWR sky130_fd_sc_hd__decap_3
XFILLER_61_623 VGND VGND VPWR VPWR sky130_fd_sc_hd__decap_3
XFILLER_73_494 VGND VGND VPWR VPWR sky130_fd_sc_hd__decap_3
XTAP_TAPCELL_ROW_44_832 VGND VPWR sky130_fd_sc_hd__tapvpwrvgnd_1
XFILLER_33_358 VGND VGND VPWR VPWR sky130_fd_sc_hd__decap_3
XFILLER_60_144 VGND VGND VPWR VPWR sky130_fd_sc_hd__decap_3
XFILLER_60_177 VGND VGND VPWR VPWR sky130_fd_sc_hd__decap_3
XFILLER_81_60 VGND VGND VPWR VPWR sky130_fd_sc_hd__decap_3
XFILLER_41_380 VGND VGND VPWR VPWR sky130_fd_sc_hd__decap_3
XFILLER_115_603 VGND VGND VPWR VPWR sky130_fd_sc_hd__decap_3
XFILLER_115_614 VGND VGND VPWR VPWR sky130_fd_sc_hd__fill_2
X_6290_ _8243_/Q _6290_/B VGND VGND VPWR VPWR _6290_/X sky130_fd_sc_hd__and2_2
X_5310_ _5310_/A _5310_/B VGND VGND VPWR VPWR _7820_/A sky130_fd_sc_hd__and2_4
XFILLER_114_124 VGND VGND VPWR VPWR sky130_fd_sc_hd__fill_2
XFILLER_5_281 VGND VGND VPWR VPWR sky130_fd_sc_hd__fill_2
X_5241_ _7661_/B VGND VGND VPWR VPWR _7656_/B sky130_fd_sc_hd__buf_1
XFILLER_68_222 VGND VGND VPWR VPWR sky130_fd_sc_hd__decap_3
X_5172_ _5170_/X _5171_/X _7653_/A VGND VGND VPWR VPWR _5172_/X sky130_fd_sc_hd__mux2_2
X_4123_ _4123_/A VGND VGND VPWR VPWR _7999_/D sky130_fd_sc_hd__buf_1
XFILLER_110_363 VGND VGND VPWR VPWR sky130_fd_sc_hd__fill_1
XFILLER_110_385 VGND VGND VPWR VPWR sky130_fd_sc_hd__decap_3
XFILLER_56_439 VGND VGND VPWR VPWR sky130_fd_sc_hd__decap_3
XFILLER_68_266 VGND VGND VPWR VPWR sky130_fd_sc_hd__decap_3
Xinput2 cmd[0] VGND VGND VPWR VPWR input2/X sky130_fd_sc_hd__clkdlybuf4s25_1
X_4054_ _7930_/B _8368_/Q VGND VGND VPWR VPWR _4055_/A sky130_fd_sc_hd__and2_2
XFILLER_83_225 VGND VGND VPWR VPWR sky130_fd_sc_hd__decap_3
XFILLER_83_247 VGND VGND VPWR VPWR sky130_fd_sc_hd__decap_3
XFILLER_36_141 VGND VGND VPWR VPWR sky130_fd_sc_hd__decap_3
XFILLER_52_601 VGND VGND VPWR VPWR sky130_fd_sc_hd__decap_3
XTAP_TAPCELL_ROW_65_1104 VGND VPWR sky130_fd_sc_hd__tapvpwrvgnd_1
XFILLER_24_325 VGND VGND VPWR VPWR sky130_fd_sc_hd__decap_3
XFILLER_64_483 VGND VGND VPWR VPWR sky130_fd_sc_hd__decap_3
X_7813_ _5363_/X _8164_/Q _7655_/A _7811_/Y _7812_/X VGND VGND VPWR VPWR _7822_/B
+ sky130_fd_sc_hd__a311o_2
XFILLER_51_122 VGND VGND VPWR VPWR sky130_fd_sc_hd__decap_3
XFILLER_51_155 VGND VGND VPWR VPWR sky130_fd_sc_hd__decap_3
X_7744_ _7652_/Y _7715_/X _7724_/X _7743_/X VGND VGND VPWR VPWR _7744_/X sky130_fd_sc_hd__a31o_2
X_4956_ _8163_/Q VGND VGND VPWR VPWR _5417_/A sky130_fd_sc_hd__inv_2
XFILLER_20_531 VGND VGND VPWR VPWR sky130_fd_sc_hd__fill_1
XFILLER_20_542 VGND VGND VPWR VPWR sky130_fd_sc_hd__fill_1
XFILLER_51_199 VGND VGND VPWR VPWR sky130_fd_sc_hd__decap_3
X_7675_ _7797_/A1 _7665_/X _7668_/Y _5363_/X _7674_/Y VGND VGND VPWR VPWR _7675_/X
+ sky130_fd_sc_hd__o221a_2
X_4887_ _4887_/A _6563_/B VGND VGND VPWR VPWR _6411_/A sky130_fd_sc_hd__nor2_2
XTAP_TAPCELL_ROW_22_548 VGND VPWR sky130_fd_sc_hd__tapvpwrvgnd_1
X_6626_ _5626_/A _6622_/X _6687_/A VGND VGND VPWR VPWR _6626_/X sky130_fd_sc_hd__a21o_2
X_6557_ _5966_/X _6522_/X _6523_/Y _6556_/X _7930_/B VGND VGND VPWR VPWR _8324_/D
+ sky130_fd_sc_hd__o311a_2
XFILLER_106_614 VGND VGND VPWR VPWR sky130_fd_sc_hd__fill_1
X_5508_ _5508_/A VGND VGND VPWR VPWR _5508_/X sky130_fd_sc_hd__clkbuf_1
XFILLER_105_113 VGND VGND VPWR VPWR sky130_fd_sc_hd__decap_3
X_6488_ _8187_/Q _7694_/B _6434_/A _6487_/Y VGND VGND VPWR VPWR _6488_/X sky130_fd_sc_hd__o31a_2
XTAP_TAPCELL_ROW_76_1244 VGND VPWR sky130_fd_sc_hd__tapvpwrvgnd_1
X_8227_ _8229_/CLK _8227_/D VGND VGND VPWR VPWR _8227_/Q sky130_fd_sc_hd__dfxtp_4
X_5439_ _5579_/S _5822_/B VGND VGND VPWR VPWR _5439_/X sky130_fd_sc_hd__or2b_2
XFILLER_59_222 VGND VGND VPWR VPWR sky130_fd_sc_hd__fill_2
XFILLER_87_520 VGND VGND VPWR VPWR sky130_fd_sc_hd__decap_3
X_8158_ clkload6/A _8158_/D VGND VGND VPWR VPWR _8158_/Q sky130_fd_sc_hd__dfxtp_2
XFILLER_101_341 VGND VGND VPWR VPWR sky130_fd_sc_hd__fill_1
XFILLER_99_391 VGND VGND VPWR VPWR sky130_fd_sc_hd__fill_1
X_7109_ _8271_/Q _5296_/X _7453_/A _7104_/X _7108_/Y VGND VGND VPWR VPWR _7109_/X
+ sky130_fd_sc_hd__a2111o_2
XFILLER_19_119 VGND VGND VPWR VPWR sky130_fd_sc_hd__decap_3
XFILLER_19_43 VGND VGND VPWR VPWR sky130_fd_sc_hd__decap_3
XFILLER_47_417 VGND VGND VPWR VPWR sky130_fd_sc_hd__decap_3
XFILLER_59_277 VGND VGND VPWR VPWR sky130_fd_sc_hd__decap_3
XFILLER_74_203 VGND VGND VPWR VPWR sky130_fd_sc_hd__decap_3
XFILLER_75_715 VGND VGND VPWR VPWR sky130_fd_sc_hd__fill_2
XFILLER_87_586 VGND VGND VPWR VPWR sky130_fd_sc_hd__decap_3
X_8089_ _8229_/CLK _8089_/D VGND VGND VPWR VPWR _8089_/Q sky130_fd_sc_hd__dfxtp_2
XFILLER_101_396 VGND VGND VPWR VPWR sky130_fd_sc_hd__decap_3
XFILLER_19_87 VGND VGND VPWR VPWR sky130_fd_sc_hd__fill_2
XFILLER_74_236 VGND VGND VPWR VPWR sky130_fd_sc_hd__decap_3
XFILLER_27_130 VGND VGND VPWR VPWR sky130_fd_sc_hd__decap_3
XFILLER_55_461 VGND VGND VPWR VPWR sky130_fd_sc_hd__decap_3
XFILLER_62_409 VGND VGND VPWR VPWR sky130_fd_sc_hd__decap_3
XFILLER_90_707 VGND VGND VPWR VPWR sky130_fd_sc_hd__decap_3
XFILLER_15_303 VGND VGND VPWR VPWR sky130_fd_sc_hd__decap_3
XFILLER_27_163 VGND VGND VPWR VPWR sky130_fd_sc_hd__decap_3
XFILLER_28_697 VGND VGND VPWR VPWR sky130_fd_sc_hd__decap_3
XFILLER_43_612 VGND VGND VPWR VPWR sky130_fd_sc_hd__decap_3
XFILLER_43_623 VGND VGND VPWR VPWR sky130_fd_sc_hd__fill_1
XFILLER_82_280 VGND VGND VPWR VPWR sky130_fd_sc_hd__decap_3
XTAP_TAPCELL_ROW_87_1395 VGND VPWR sky130_fd_sc_hd__tapvpwrvgnd_1
XTAP_TAPCELL_ROW_87_1384 VGND VPWR sky130_fd_sc_hd__tapvpwrvgnd_1
XTAP_TAPCELL_ROW_2_284 VGND VPWR sky130_fd_sc_hd__tapvpwrvgnd_1
XFILLER_15_347 VGND VGND VPWR VPWR sky130_fd_sc_hd__decap_3
XFILLER_42_122 VGND VGND VPWR VPWR sky130_fd_sc_hd__decap_3
XFILLER_43_678 VGND VGND VPWR VPWR sky130_fd_sc_hd__decap_3
XFILLER_70_431 VGND VGND VPWR VPWR sky130_fd_sc_hd__decap_3
XFILLER_30_306 VGND VGND VPWR VPWR sky130_fd_sc_hd__fill_2
XFILLER_35_97 VGND VGND VPWR VPWR sky130_fd_sc_hd__decap_3
XFILLER_70_486 VGND VGND VPWR VPWR sky130_fd_sc_hd__decap_3
XFILLER_11_520 VGND VGND VPWR VPWR sky130_fd_sc_hd__decap_3
XFILLER_23_391 VGND VGND VPWR VPWR sky130_fd_sc_hd__fill_1
XFILLER_11_553 VGND VGND VPWR VPWR sky130_fd_sc_hd__decap_3
XFILLER_11_575 VGND VGND VPWR VPWR sky130_fd_sc_hd__decap_3
XFILLER_51_63 VGND VGND VPWR VPWR sky130_fd_sc_hd__decap_3
XFILLER_7_502 VGND VGND VPWR VPWR sky130_fd_sc_hd__fill_2
XFILLER_11_586 VGND VGND VPWR VPWR sky130_fd_sc_hd__decap_3
XFILLER_11_597 VGND VGND VPWR VPWR sky130_fd_sc_hd__decap_3
XFILLER_7_535 VGND VGND VPWR VPWR sky130_fd_sc_hd__decap_3
XFILLER_109_474 VGND VGND VPWR VPWR sky130_fd_sc_hd__decap_3
XFILLER_7_579 VGND VGND VPWR VPWR sky130_fd_sc_hd__decap_3
XFILLER_109_485 VGND VGND VPWR VPWR sky130_fd_sc_hd__decap_3
XFILLER_78_520 VGND VGND VPWR VPWR sky130_fd_sc_hd__decap_3
XFILLER_66_704 VGND VGND VPWR VPWR sky130_fd_sc_hd__decap_3
XFILLER_78_542 VGND VGND VPWR VPWR sky130_fd_sc_hd__decap_3
XFILLER_78_564 VGND VGND VPWR VPWR sky130_fd_sc_hd__fill_1
XFILLER_93_523 VGND VGND VPWR VPWR sky130_fd_sc_hd__decap_3
Xclone323 _6353_/A VGND VGND VPWR VPWR _7825_/A sky130_fd_sc_hd__clkbuf_16
XTAP_TAPCELL_ROW_49_902 VGND VPWR sky130_fd_sc_hd__tapvpwrvgnd_1
XFILLER_19_620 VGND VGND VPWR VPWR sky130_fd_sc_hd__decap_3
XFILLER_19_642 VGND VGND VPWR VPWR sky130_fd_sc_hd__decap_3
XFILLER_65_225 VGND VGND VPWR VPWR sky130_fd_sc_hd__decap_3
XFILLER_93_556 VGND VGND VPWR VPWR sky130_fd_sc_hd__decap_3
XFILLER_18_141 VGND VGND VPWR VPWR sky130_fd_sc_hd__decap_3
XFILLER_80_206 VGND VGND VPWR VPWR sky130_fd_sc_hd__decap_3
XFILLER_81_707 VGND VGND VPWR VPWR sky130_fd_sc_hd__decap_3
XFILLER_81_729 VGND VGND VPWR VPWR sky130_fd_sc_hd__decap_3
XFILLER_18_174 VGND VGND VPWR VPWR sky130_fd_sc_hd__decap_3
XFILLER_33_100 VGND VGND VPWR VPWR sky130_fd_sc_hd__decap_3
XFILLER_34_612 VGND VGND VPWR VPWR sky130_fd_sc_hd__fill_2
XFILLER_34_634 VGND VGND VPWR VPWR sky130_fd_sc_hd__fill_2
XFILLER_46_472 VGND VGND VPWR VPWR sky130_fd_sc_hd__decap_3
XFILLER_46_483 VGND VGND VPWR VPWR sky130_fd_sc_hd__decap_3
XFILLER_61_420 VGND VGND VPWR VPWR sky130_fd_sc_hd__decap_3
XFILLER_33_122 VGND VGND VPWR VPWR sky130_fd_sc_hd__decap_3
X_4810_ _6903_/S _8264_/Q VGND VGND VPWR VPWR _6958_/A sky130_fd_sc_hd__and2_2
XFILLER_21_328 VGND VGND VPWR VPWR sky130_fd_sc_hd__decap_3
XFILLER_33_188 VGND VGND VPWR VPWR sky130_fd_sc_hd__fill_1
X_5790_ _5026_/B _5757_/Y _5789_/X VGND VGND VPWR VPWR _5791_/A sky130_fd_sc_hd__o21ai_2
XFILLER_14_391 VGND VGND VPWR VPWR sky130_fd_sc_hd__decap_3
X_4741_ _4741_/A _4741_/B VGND VGND VPWR VPWR _7407_/A sky130_fd_sc_hd__or2_2
XTAP_TAPCELL_ROW_60_1034 VGND VPWR sky130_fd_sc_hd__tapvpwrvgnd_1
X_7460_ _7463_/A _7460_/B VGND VGND VPWR VPWR _7460_/Y sky130_fd_sc_hd__xnor2_2
X_4672_ _7930_/B _8140_/Q VGND VGND VPWR VPWR _4673_/A sky130_fd_sc_hd__and2_2
XTAP_TAPCELL_ROW_60_1045 VGND VPWR sky130_fd_sc_hd__tapvpwrvgnd_1
X_6411_ _6411_/A _6411_/B VGND VGND VPWR VPWR _6411_/X sky130_fd_sc_hd__xor2_2
X_7391_ _7193_/A _7390_/X _6529_/A VGND VGND VPWR VPWR _7391_/Y sky130_fd_sc_hd__o21ai_2
XFILLER_115_422 VGND VGND VPWR VPWR sky130_fd_sc_hd__decap_3
X_6342_ _8288_/Q _4880_/A _6341_/X _5601_/X _4882_/A VGND VGND VPWR VPWR _6342_/X
+ sky130_fd_sc_hd__o32a_2
XFILLER_103_617 VGND VGND VPWR VPWR sky130_fd_sc_hd__decap_3
XFILLER_115_444 VGND VGND VPWR VPWR sky130_fd_sc_hd__decap_3
XTAP_TAPCELL_ROW_112_1709 VGND VPWR sky130_fd_sc_hd__tapvpwrvgnd_1
X_6273_ _5641_/X _6426_/B _6272_/Y VGND VGND VPWR VPWR _6273_/Y sky130_fd_sc_hd__o21ai_2
XFILLER_102_105 VGND VGND VPWR VPWR sky130_fd_sc_hd__decap_3
XFILLER_69_520 VGND VGND VPWR VPWR sky130_fd_sc_hd__decap_3
X_8012_ _8355_/CLK _8012_/D VGND VGND VPWR VPWR _8012_/Q sky130_fd_sc_hd__dfxtp_2
X_5224_ _5222_/X _5223_/X _5451_/S VGND VGND VPWR VPWR _5224_/X sky130_fd_sc_hd__mux2_2
XFILLER_69_553 VGND VGND VPWR VPWR sky130_fd_sc_hd__decap_3
XFILLER_29_417 VGND VGND VPWR VPWR sky130_fd_sc_hd__decap_3
XFILLER_56_203 VGND VGND VPWR VPWR sky130_fd_sc_hd__decap_3
XFILLER_57_715 VGND VGND VPWR VPWR sky130_fd_sc_hd__fill_2
XFILLER_69_564 VGND VGND VPWR VPWR sky130_fd_sc_hd__decap_3
XFILLER_69_586 VGND VGND VPWR VPWR sky130_fd_sc_hd__decap_3
X_5155_ _8206_/Q _7228_/B _5484_/S VGND VGND VPWR VPWR _5155_/X sky130_fd_sc_hd__mux2_2
XTAP_TAPCELL_ROW_71_1185 VGND VPWR sky130_fd_sc_hd__tapvpwrvgnd_1
XFILLER_111_694 VGND VGND VPWR VPWR sky130_fd_sc_hd__decap_3
XFILLER_56_236 VGND VGND VPWR VPWR sky130_fd_sc_hd__decap_3
XFILLER_84_545 VGND VGND VPWR VPWR sky130_fd_sc_hd__decap_3
XFILLER_96_383 VGND VGND VPWR VPWR sky130_fd_sc_hd__decap_3
X_5086_ _7787_/A _5085_/Y _6763_/B VGND VGND VPWR VPWR _5086_/X sky130_fd_sc_hd__o21a_2
X_4106_ _7930_/B _8394_/Q VGND VGND VPWR VPWR _4107_/A sky130_fd_sc_hd__and2_2
XFILLER_37_461 VGND VGND VPWR VPWR sky130_fd_sc_hd__decap_3
XFILLER_71_206 VGND VGND VPWR VPWR sky130_fd_sc_hd__decap_3
XFILLER_72_707 VGND VGND VPWR VPWR sky130_fd_sc_hd__decap_3
XFILLER_84_589 VGND VGND VPWR VPWR sky130_fd_sc_hd__decap_3
X_4037_ _4037_/A VGND VGND VPWR VPWR _7956_/D sky130_fd_sc_hd__buf_1
XTAP_TAPCELL_ROW_27_607 VGND VPWR sky130_fd_sc_hd__tapvpwrvgnd_1
XFILLER_37_483 VGND VGND VPWR VPWR sky130_fd_sc_hd__decap_3
XFILLER_71_228 VGND VGND VPWR VPWR sky130_fd_sc_hd__decap_3
XFILLER_24_133 VGND VGND VPWR VPWR sky130_fd_sc_hd__decap_3
XFILLER_24_144 VGND VGND VPWR VPWR sky130_fd_sc_hd__decap_3
XFILLER_52_442 VGND VGND VPWR VPWR sky130_fd_sc_hd__decap_3
XFILLER_64_291 VGND VGND VPWR VPWR sky130_fd_sc_hd__decap_3
XFILLER_72_29 VGND VGND VPWR VPWR sky130_fd_sc_hd__decap_3
XFILLER_24_177 VGND VGND VPWR VPWR sky130_fd_sc_hd__decap_3
XFILLER_40_626 VGND VGND VPWR VPWR sky130_fd_sc_hd__decap_3
XFILLER_52_475 VGND VGND VPWR VPWR sky130_fd_sc_hd__fill_1
X_5988_ _5637_/X _5638_/X _5645_/X _5635_/X _5671_/A _6321_/B VGND VGND VPWR VPWR
+ _5988_/X sky130_fd_sc_hd__mux4_2
XFILLER_12_328 VGND VGND VPWR VPWR sky130_fd_sc_hd__decap_3
XFILLER_40_659 VGND VGND VPWR VPWR sky130_fd_sc_hd__decap_3
X_7727_ _5684_/S _5121_/A _7725_/Y _7726_/Y VGND VGND VPWR VPWR _7727_/X sky130_fd_sc_hd__a31o_2
X_4939_ _5027_/B _4939_/B VGND VGND VPWR VPWR _5868_/A sky130_fd_sc_hd__or2_4
X_7658_ _7812_/A _8217_/Q _7820_/B VGND VGND VPWR VPWR _7658_/X sky130_fd_sc_hd__and3_2
XFILLER_20_383 VGND VGND VPWR VPWR sky130_fd_sc_hd__decap_3
XFILLER_21_11 VGND VGND VPWR VPWR sky130_fd_sc_hd__fill_1
X_6609_ _8255_/Q _6568_/B _6608_/X VGND VGND VPWR VPWR _6610_/B sky130_fd_sc_hd__o21a_4
XFILLER_21_44 VGND VGND VPWR VPWR sky130_fd_sc_hd__fill_1
XFILLER_4_516 VGND VGND VPWR VPWR sky130_fd_sc_hd__decap_3
X_7589_ _6099_/A _6717_/A _7563_/A _7563_/B _8221_/Q _5951_/A VGND VGND VPWR VPWR
+ _7590_/A sky130_fd_sc_hd__mux4_2
XFILLER_4_538 VGND VGND VPWR VPWR sky130_fd_sc_hd__decap_3
XFILLER_106_444 VGND VGND VPWR VPWR sky130_fd_sc_hd__decap_3
XFILLER_106_499 VGND VGND VPWR VPWR sky130_fd_sc_hd__decap_3
XFILLER_79_317 VGND VGND VPWR VPWR sky130_fd_sc_hd__decap_3
Xoutput191 _8015_/Q VGND VGND VPWR VPWR result[57] sky130_fd_sc_hd__clkdlybuf4s25_1
Xoutput180 _8005_/Q VGND VGND VPWR VPWR result[47] sky130_fd_sc_hd__clkdlybuf4s25_1
XTAP_TAPCELL_ROW_7_354 VGND VPWR sky130_fd_sc_hd__tapvpwrvgnd_1
XFILLER_48_704 VGND VGND VPWR VPWR sky130_fd_sc_hd__fill_2
XFILLER_48_715 VGND VGND VPWR VPWR sky130_fd_sc_hd__fill_2
XTAP_TAPCELL_ROW_89_1413 VGND VPWR sky130_fd_sc_hd__tapvpwrvgnd_1
XFILLER_47_225 VGND VGND VPWR VPWR sky130_fd_sc_hd__fill_2
XFILLER_75_523 VGND VGND VPWR VPWR sky130_fd_sc_hd__decap_3
XFILLER_101_193 VGND VGND VPWR VPWR sky130_fd_sc_hd__decap_3
XFILLER_46_41 VGND VGND VPWR VPWR sky130_fd_sc_hd__fill_1
XFILLER_62_206 VGND VGND VPWR VPWR sky130_fd_sc_hd__decap_3
XFILLER_63_729 VGND VGND VPWR VPWR sky130_fd_sc_hd__decap_3
XFILLER_16_612 VGND VGND VPWR VPWR sky130_fd_sc_hd__decap_3
XFILLER_28_461 VGND VGND VPWR VPWR sky130_fd_sc_hd__decap_3
XFILLER_46_74 VGND VGND VPWR VPWR sky130_fd_sc_hd__decap_3
XFILLER_90_526 VGND VGND VPWR VPWR sky130_fd_sc_hd__decap_3
XFILLER_90_548 VGND VGND VPWR VPWR sky130_fd_sc_hd__decap_3
XFILLER_16_645 VGND VGND VPWR VPWR sky130_fd_sc_hd__decap_3
XFILLER_43_420 VGND VGND VPWR VPWR sky130_fd_sc_hd__decap_3
XFILLER_15_155 VGND VGND VPWR VPWR sky130_fd_sc_hd__decap_3
XFILLER_43_475 VGND VGND VPWR VPWR sky130_fd_sc_hd__decap_3
XTAP_TAPCELL_ROW_54_960 VGND VPWR sky130_fd_sc_hd__tapvpwrvgnd_1
XFILLER_30_147 VGND VGND VPWR VPWR sky130_fd_sc_hd__decap_3
XFILLER_11_372 VGND VGND VPWR VPWR sky130_fd_sc_hd__decap_3
XFILLER_7_332 VGND VGND VPWR VPWR sky130_fd_sc_hd__decap_3
XFILLER_7_35 VGND VGND VPWR VPWR sky130_fd_sc_hd__decap_3
XFILLER_7_343 VGND VGND VPWR VPWR sky130_fd_sc_hd__decap_3
XFILLER_7_365 VGND VGND VPWR VPWR sky130_fd_sc_hd__decap_3
XFILLER_7_57 VGND VGND VPWR VPWR sky130_fd_sc_hd__decap_3
XFILLER_98_604 VGND VGND VPWR VPWR sky130_fd_sc_hd__decap_3
XFILLER_98_648 VGND VGND VPWR VPWR sky130_fd_sc_hd__decap_3
XFILLER_112_458 VGND VGND VPWR VPWR sky130_fd_sc_hd__decap_3
XFILLER_97_147 VGND VGND VPWR VPWR sky130_fd_sc_hd__decap_3
XFILLER_38_203 VGND VGND VPWR VPWR sky130_fd_sc_hd__decap_3
XFILLER_66_501 VGND VGND VPWR VPWR sky130_fd_sc_hd__decap_3
XFILLER_87_81 VGND VGND VPWR VPWR sky130_fd_sc_hd__fill_1
XFILLER_97_169 VGND VGND VPWR VPWR sky130_fd_sc_hd__decap_3
XFILLER_38_236 VGND VGND VPWR VPWR sky130_fd_sc_hd__fill_2
XFILLER_66_523 VGND VGND VPWR VPWR sky130_fd_sc_hd__decap_3
XFILLER_66_545 VGND VGND VPWR VPWR sky130_fd_sc_hd__decap_3
XFILLER_78_383 VGND VGND VPWR VPWR sky130_fd_sc_hd__decap_3
XFILLER_66_567 VGND VGND VPWR VPWR sky130_fd_sc_hd__decap_3
XFILLER_66_589 VGND VGND VPWR VPWR sky130_fd_sc_hd__decap_3
XFILLER_93_364 VGND VGND VPWR VPWR sky130_fd_sc_hd__decap_3
X_6960_ _7078_/A _6960_/B VGND VGND VPWR VPWR _7154_/A sky130_fd_sc_hd__nand2_2
XFILLER_19_472 VGND VGND VPWR VPWR sky130_fd_sc_hd__decap_3
XFILLER_53_217 VGND VGND VPWR VPWR sky130_fd_sc_hd__decap_3
XTAP_TAPCELL_ROW_109_1671 VGND VPWR sky130_fd_sc_hd__tapvpwrvgnd_1
XTAP_TAPCELL_ROW_109_1682 VGND VPWR sky130_fd_sc_hd__tapvpwrvgnd_1
X_5911_ _6130_/B _5911_/B VGND VGND VPWR VPWR _5911_/Y sky130_fd_sc_hd__nand2_2
XFILLER_34_442 VGND VGND VPWR VPWR sky130_fd_sc_hd__fill_1
XFILLER_81_559 VGND VGND VPWR VPWR sky130_fd_sc_hd__fill_1
X_6891_ _6323_/X _6890_/X _6013_/X _6617_/X _7298_/S0 _7745_/A VGND VGND VPWR VPWR
+ _6891_/X sky130_fd_sc_hd__mux4_2
XFILLER_34_475 VGND VGND VPWR VPWR sky130_fd_sc_hd__fill_1
XFILLER_34_486 VGND VGND VPWR VPWR sky130_fd_sc_hd__decap_3
XFILLER_61_250 VGND VGND VPWR VPWR sky130_fd_sc_hd__decap_3
X_5842_ _8172_/Q _8236_/Q _6086_/A VGND VGND VPWR VPWR _5842_/X sky130_fd_sc_hd__a21o_2
XFILLER_21_136 VGND VGND VPWR VPWR sky130_fd_sc_hd__decap_3
XFILLER_22_648 VGND VGND VPWR VPWR sky130_fd_sc_hd__decap_3
X_5773_ _7783_/A _7623_/S _6353_/B VGND VGND VPWR VPWR _5773_/Y sky130_fd_sc_hd__a21oi_2
XFILLER_21_169 VGND VGND VPWR VPWR sky130_fd_sc_hd__decap_3
X_7512_ _7930_/B _7512_/B VGND VGND VPWR VPWR _7513_/A sky130_fd_sc_hd__and2_4
X_4724_ _5951_/A _8286_/Q VGND VGND VPWR VPWR _4725_/B sky130_fd_sc_hd__nand2_2
XTAP_TAPCELL_ROW_32_676 VGND VPWR sky130_fd_sc_hd__tapvpwrvgnd_1
XFILLER_107_208 VGND VGND VPWR VPWR sky130_fd_sc_hd__decap_3
X_7443_ _8217_/Q _8281_/Q _7619_/A VGND VGND VPWR VPWR _7444_/S sky130_fd_sc_hd__a21oi_2
X_4655_ _4655_/A VGND VGND VPWR VPWR _8265_/D sky130_fd_sc_hd__buf_1
X_7374_ _7394_/C _7374_/B VGND VGND VPWR VPWR _7374_/Y sky130_fd_sc_hd__nand2_2
Xinput82 operand_b[20] VGND VGND VPWR VPWR _4344_/B sky130_fd_sc_hd__clkdlybuf4s25_1
Xinput71 operand_b[10] VGND VGND VPWR VPWR _4324_/B sky130_fd_sc_hd__clkdlybuf4s25_1
Xinput60 operand_a[59] VGND VGND VPWR VPWR _4294_/B sky130_fd_sc_hd__clkdlybuf4s25_1
X_4586_ _7898_/B _8097_/Q VGND VGND VPWR VPWR _4587_/A sky130_fd_sc_hd__and2_2
Xinput93 operand_b[30] VGND VGND VPWR VPWR _4364_/B sky130_fd_sc_hd__clkdlybuf4s25_1
X_6325_ _7825_/A _6325_/B VGND VGND VPWR VPWR _6325_/Y sky130_fd_sc_hd__nor2_2
XTAP_TAPCELL_ROW_73_1214 VGND VPWR sky130_fd_sc_hd__tapvpwrvgnd_1
XTAP_TAPCELL_ROW_73_1203 VGND VPWR sky130_fd_sc_hd__tapvpwrvgnd_1
XFILLER_107_25 VGND VGND VPWR VPWR sky130_fd_sc_hd__decap_3
XFILLER_88_103 VGND VGND VPWR VPWR sky130_fd_sc_hd__decap_3
XFILLER_89_626 VGND VGND VPWR VPWR sky130_fd_sc_hd__decap_3
XFILLER_89_648 VGND VGND VPWR VPWR sky130_fd_sc_hd__decap_3
XFILLER_103_447 VGND VGND VPWR VPWR sky130_fd_sc_hd__fill_1
XFILLER_103_458 VGND VGND VPWR VPWR sky130_fd_sc_hd__decap_3
XFILLER_88_136 VGND VGND VPWR VPWR sky130_fd_sc_hd__decap_3
XFILLER_88_147 VGND VGND VPWR VPWR sky130_fd_sc_hd__fill_2
XFILLER_88_158 VGND VGND VPWR VPWR sky130_fd_sc_hd__fill_1
X_6256_ _6256_/A _6297_/D VGND VGND VPWR VPWR _6256_/Y sky130_fd_sc_hd__xnor2_2
XFILLER_57_512 VGND VGND VPWR VPWR sky130_fd_sc_hd__decap_3
XFILLER_69_372 VGND VGND VPWR VPWR sky130_fd_sc_hd__decap_3
X_6187_ _8245_/Q _5399_/X wire225/X VGND VGND VPWR VPWR _6187_/Y sky130_fd_sc_hd__o21ai_2
X_5207_ _5365_/S VGND VGND VPWR VPWR _5384_/S sky130_fd_sc_hd__buf_1
XTAP_TAPCELL_ROW_4_313 VGND VPWR sky130_fd_sc_hd__tapvpwrvgnd_1
XFILLER_29_225 VGND VGND VPWR VPWR sky130_fd_sc_hd__decap_3
X_5138_ _8216_/Q _8217_/Q _5484_/S VGND VGND VPWR VPWR _5138_/X sky130_fd_sc_hd__mux2_2
XFILLER_17_409 VGND VGND VPWR VPWR sky130_fd_sc_hd__decap_3
XFILLER_29_247 VGND VGND VPWR VPWR sky130_fd_sc_hd__decap_3
XFILLER_57_567 VGND VGND VPWR VPWR sky130_fd_sc_hd__decap_3
XFILLER_84_342 VGND VGND VPWR VPWR sky130_fd_sc_hd__decap_3
XFILLER_44_206 VGND VGND VPWR VPWR sky130_fd_sc_hd__decap_3
XFILLER_45_729 VGND VGND VPWR VPWR sky130_fd_sc_hd__decap_3
X_5069_ _5069_/A _5069_/B VGND VGND VPWR VPWR _5069_/Y sky130_fd_sc_hd__nor2_2
XFILLER_13_604 VGND VGND VPWR VPWR sky130_fd_sc_hd__decap_3
XFILLER_25_486 VGND VGND VPWR VPWR sky130_fd_sc_hd__decap_3
XFILLER_52_250 VGND VGND VPWR VPWR sky130_fd_sc_hd__fill_2
XTAP_TAPCELL_ROW_84_1354 VGND VPWR sky130_fd_sc_hd__tapvpwrvgnd_1
XFILLER_13_648 VGND VGND VPWR VPWR sky130_fd_sc_hd__decap_3
XFILLER_16_88 VGND VGND VPWR VPWR sky130_fd_sc_hd__fill_2
XFILLER_40_412 VGND VGND VPWR VPWR sky130_fd_sc_hd__decap_3
XFILLER_40_445 VGND VGND VPWR VPWR sky130_fd_sc_hd__decap_3
XFILLER_52_272 VGND VGND VPWR VPWR sky130_fd_sc_hd__decap_3
XFILLER_80_581 VGND VGND VPWR VPWR sky130_fd_sc_hd__decap_3
XFILLER_80_592 VGND VGND VPWR VPWR sky130_fd_sc_hd__decap_3
XFILLER_12_147 VGND VGND VPWR VPWR sky130_fd_sc_hd__decap_3
XFILLER_8_118 VGND VGND VPWR VPWR sky130_fd_sc_hd__decap_3
XFILLER_32_32 VGND VGND VPWR VPWR sky130_fd_sc_hd__decap_3
XFILLER_32_65 VGND VGND VPWR VPWR sky130_fd_sc_hd__decap_3
XFILLER_40_489 VGND VGND VPWR VPWR sky130_fd_sc_hd__decap_3
XFILLER_20_180 VGND VGND VPWR VPWR sky130_fd_sc_hd__decap_3
XFILLER_4_324 VGND VGND VPWR VPWR sky130_fd_sc_hd__decap_3
XFILLER_106_230 VGND VGND VPWR VPWR sky130_fd_sc_hd__decap_3
XFILLER_106_274 VGND VGND VPWR VPWR sky130_fd_sc_hd__decap_3
XFILLER_4_368 VGND VGND VPWR VPWR sky130_fd_sc_hd__decap_3
XTAP_TAPCELL_ROW_95_1494 VGND VPWR sky130_fd_sc_hd__tapvpwrvgnd_1
XFILLER_0_585 VGND VGND VPWR VPWR sky130_fd_sc_hd__decap_3
XFILLER_102_480 VGND VGND VPWR VPWR sky130_fd_sc_hd__decap_3
XFILLER_48_523 VGND VGND VPWR VPWR sky130_fd_sc_hd__decap_3
XFILLER_48_545 VGND VGND VPWR VPWR sky130_fd_sc_hd__decap_3
XFILLER_75_320 VGND VGND VPWR VPWR sky130_fd_sc_hd__decap_3
XFILLER_75_353 VGND VGND VPWR VPWR sky130_fd_sc_hd__decap_3
XFILLER_48_589 VGND VGND VPWR VPWR sky130_fd_sc_hd__decap_3
XFILLER_63_515 VGND VGND VPWR VPWR sky130_fd_sc_hd__decap_3
XFILLER_90_312 VGND VGND VPWR VPWR sky130_fd_sc_hd__decap_3
XFILLER_16_442 VGND VGND VPWR VPWR sky130_fd_sc_hd__decap_3
XFILLER_31_401 VGND VGND VPWR VPWR sky130_fd_sc_hd__decap_3
X_4440_ _7898_/B input1/X VGND VGND VPWR VPWR _4441_/A sky130_fd_sc_hd__and2_2
XFILLER_98_80 VGND VGND VPWR VPWR sky130_fd_sc_hd__decap_3
X_6110_ _6650_/B _6107_/X _6109_/Y _7827_/A VGND VGND VPWR VPWR _6110_/X sky130_fd_sc_hd__o22a_2
X_4371_ _4371_/A VGND VGND VPWR VPWR _8123_/D sky130_fd_sc_hd__buf_1
XFILLER_3_390 VGND VGND VPWR VPWR sky130_fd_sc_hd__fill_2
X_7090_ _7166_/D _7098_/S VGND VGND VPWR VPWR _7090_/Y sky130_fd_sc_hd__xnor2_2
XFILLER_58_309 VGND VGND VPWR VPWR sky130_fd_sc_hd__decap_3
XFILLER_86_629 VGND VGND VPWR VPWR sky130_fd_sc_hd__decap_3
X_6041_ _5037_/A _6040_/Y _6039_/A VGND VGND VPWR VPWR _6138_/C sky130_fd_sc_hd__o21bai_2
XFILLER_39_534 VGND VGND VPWR VPWR sky130_fd_sc_hd__decap_3
XFILLER_39_578 VGND VGND VPWR VPWR sky130_fd_sc_hd__fill_1
XFILLER_54_504 VGND VGND VPWR VPWR sky130_fd_sc_hd__decap_3
XFILLER_94_662 VGND VGND VPWR VPWR sky130_fd_sc_hd__decap_3
XFILLER_26_206 VGND VGND VPWR VPWR sky130_fd_sc_hd__decap_3
XFILLER_27_729 VGND VGND VPWR VPWR sky130_fd_sc_hd__decap_3
XFILLER_93_150 VGND VGND VPWR VPWR sky130_fd_sc_hd__decap_3
XFILLER_93_172 VGND VGND VPWR VPWR sky130_fd_sc_hd__decap_3
X_7992_ _8400_/CLK _7992_/D VGND VGND VPWR VPWR _7992_/Q sky130_fd_sc_hd__dfxtp_2
XFILLER_81_334 VGND VGND VPWR VPWR sky130_fd_sc_hd__fill_2
X_6943_ _8201_/Q _6943_/B VGND VGND VPWR VPWR _6988_/B sky130_fd_sc_hd__or2_4
XTAP_TAPCELL_ROW_37_746 VGND VPWR sky130_fd_sc_hd__tapvpwrvgnd_1
XTAP_TAPCELL_ROW_37_735 VGND VPWR sky130_fd_sc_hd__tapvpwrvgnd_1
XFILLER_41_209 VGND VGND VPWR VPWR sky130_fd_sc_hd__decap_3
XFILLER_81_367 VGND VGND VPWR VPWR sky130_fd_sc_hd__decap_3
X_6874_ _6874_/A _6874_/B _6874_/C _6874_/D VGND VGND VPWR VPWR _6874_/X sky130_fd_sc_hd__and4_2
XFILLER_62_581 VGND VGND VPWR VPWR sky130_fd_sc_hd__decap_3
XFILLER_62_592 VGND VGND VPWR VPWR sky130_fd_sc_hd__decap_3
X_5825_ _6130_/A _5822_/Y _5824_/Y _7135_/B VGND VGND VPWR VPWR _5825_/X sky130_fd_sc_hd__a31o_2
XTAP_TAPCELL_ROW_17_481 VGND VPWR sky130_fd_sc_hd__tapvpwrvgnd_1
XFILLER_22_445 VGND VGND VPWR VPWR sky130_fd_sc_hd__decap_3
XFILLER_22_467 VGND VGND VPWR VPWR sky130_fd_sc_hd__decap_3
XFILLER_22_489 VGND VGND VPWR VPWR sky130_fd_sc_hd__decap_3
X_5756_ _8232_/Q _5715_/B _5755_/X VGND VGND VPWR VPWR _5756_/X sky130_fd_sc_hd__a21o_2
X_5687_ _7193_/A _5674_/X _5677_/X _5683_/X _5686_/Y VGND VGND VPWR VPWR _5687_/X
+ sky130_fd_sc_hd__a32o_2
X_4707_ _4707_/A VGND VGND VPWR VPWR _8291_/D sky130_fd_sc_hd__buf_1
XFILLER_118_24 VGND VGND VPWR VPWR sky130_fd_sc_hd__decap_3
X_7426_ _6368_/B _7424_/X _7426_/B1 _7195_/B VGND VGND VPWR VPWR _7426_/X sky130_fd_sc_hd__o2bb2a_2
Xrebuffer259 clone455/A VGND VGND VPWR VPWR _7765_/A sky130_fd_sc_hd__buf_2
X_4638_ _7930_/B _8123_/Q VGND VGND VPWR VPWR _4639_/A sky130_fd_sc_hd__and2_2
XFILLER_118_35 VGND VGND VPWR VPWR sky130_fd_sc_hd__decap_3
XFILLER_116_561 VGND VGND VPWR VPWR sky130_fd_sc_hd__decap_3
XFILLER_89_401 VGND VGND VPWR VPWR sky130_fd_sc_hd__decap_3
X_7357_ _8214_/Q _7353_/Y _5601_/A _7356_/X VGND VGND VPWR VPWR _7357_/X sky130_fd_sc_hd__o31a_2
X_4569_ _4569_/A VGND VGND VPWR VPWR _8222_/D sky130_fd_sc_hd__buf_1
XFILLER_103_211 VGND VGND VPWR VPWR sky130_fd_sc_hd__decap_3
XFILLER_89_434 VGND VGND VPWR VPWR sky130_fd_sc_hd__decap_3
X_7288_ _4786_/B _4789_/A _4974_/Y VGND VGND VPWR VPWR _7289_/B sky130_fd_sc_hd__o21a_2
X_6308_ _8184_/Q _8248_/Q _6086_/A VGND VGND VPWR VPWR _6308_/X sky130_fd_sc_hd__a21o_2
XFILLER_103_255 VGND VGND VPWR VPWR sky130_fd_sc_hd__decap_3
XFILLER_49_309 VGND VGND VPWR VPWR sky130_fd_sc_hd__decap_3
X_6239_ _7725_/B _7732_/B _6380_/S VGND VGND VPWR VPWR _6239_/X sky130_fd_sc_hd__mux2_2
XFILLER_76_128 VGND VGND VPWR VPWR sky130_fd_sc_hd__decap_3
XFILLER_18_718 VGND VGND VPWR VPWR sky130_fd_sc_hd__decap_3
XFILLER_27_10 VGND VGND VPWR VPWR sky130_fd_sc_hd__fill_1
XFILLER_85_640 VGND VGND VPWR VPWR sky130_fd_sc_hd__fill_1
XFILLER_91_109 VGND VGND VPWR VPWR sky130_fd_sc_hd__decap_3
XFILLER_94_49 VGND VGND VPWR VPWR sky130_fd_sc_hd__decap_3
XFILLER_17_206 VGND VGND VPWR VPWR sky130_fd_sc_hd__decap_3
XFILLER_17_228 VGND VGND VPWR VPWR sky130_fd_sc_hd__decap_3
XFILLER_27_32 VGND VGND VPWR VPWR sky130_fd_sc_hd__decap_3
XFILLER_27_54 VGND VGND VPWR VPWR sky130_fd_sc_hd__fill_2
XFILLER_45_526 VGND VGND VPWR VPWR sky130_fd_sc_hd__decap_3
XFILLER_57_364 VGND VGND VPWR VPWR sky130_fd_sc_hd__decap_3
XFILLER_72_312 VGND VGND VPWR VPWR sky130_fd_sc_hd__decap_3
XFILLER_84_161 VGND VGND VPWR VPWR sky130_fd_sc_hd__decap_3
XFILLER_85_695 VGND VGND VPWR VPWR sky130_fd_sc_hd__fill_1
XFILLER_45_559 VGND VGND VPWR VPWR sky130_fd_sc_hd__fill_1
XFILLER_72_345 VGND VGND VPWR VPWR sky130_fd_sc_hd__decap_3
XFILLER_13_412 VGND VGND VPWR VPWR sky130_fd_sc_hd__decap_3
XFILLER_25_272 VGND VGND VPWR VPWR sky130_fd_sc_hd__decap_3
XFILLER_41_732 VGND VGND VPWR VPWR sky130_fd_sc_hd__fill_1
XFILLER_43_20 VGND VGND VPWR VPWR sky130_fd_sc_hd__decap_3
XFILLER_53_581 VGND VGND VPWR VPWR sky130_fd_sc_hd__fill_1
XFILLER_40_231 VGND VGND VPWR VPWR sky130_fd_sc_hd__decap_3
XFILLER_40_253 VGND VGND VPWR VPWR sky130_fd_sc_hd__fill_2
XFILLER_43_42 VGND VGND VPWR VPWR sky130_fd_sc_hd__decap_3
XFILLER_9_416 VGND VGND VPWR VPWR sky130_fd_sc_hd__decap_3
XFILLER_9_449 VGND VGND VPWR VPWR sky130_fd_sc_hd__fill_2
XTAP_TAPCELL_ROW_97_1523 VGND VPWR sky130_fd_sc_hd__tapvpwrvgnd_1
XFILLER_5_611 VGND VGND VPWR VPWR sky130_fd_sc_hd__decap_3
XFILLER_99_209 VGND VGND VPWR VPWR sky130_fd_sc_hd__decap_3
Xrebuffer793 _5029_/X VGND VGND VPWR VPWR _5891_/B1 sky130_fd_sc_hd__buf_2
XFILLER_107_561 VGND VGND VPWR VPWR sky130_fd_sc_hd__decap_3
XFILLER_4_187 VGND VGND VPWR VPWR sky130_fd_sc_hd__decap_3
XFILLER_67_106 VGND VGND VPWR VPWR sky130_fd_sc_hd__decap_3
XFILLER_0_360 VGND VGND VPWR VPWR sky130_fd_sc_hd__decap_3
XFILLER_67_128 VGND VGND VPWR VPWR sky130_fd_sc_hd__fill_1
XFILLER_68_94 VGND VGND VPWR VPWR sky130_fd_sc_hd__decap_3
XFILLER_95_426 VGND VGND VPWR VPWR sky130_fd_sc_hd__decap_3
XFILLER_0_393 VGND VGND VPWR VPWR sky130_fd_sc_hd__decap_3
XFILLER_36_515 VGND VGND VPWR VPWR sky130_fd_sc_hd__decap_3
XFILLER_48_375 VGND VGND VPWR VPWR sky130_fd_sc_hd__decap_3
XFILLER_75_172 VGND VGND VPWR VPWR sky130_fd_sc_hd__fill_2
XFILLER_76_684 VGND VGND VPWR VPWR sky130_fd_sc_hd__decap_3
XFILLER_91_632 VGND VGND VPWR VPWR sky130_fd_sc_hd__decap_3
XFILLER_63_367 VGND VGND VPWR VPWR sky130_fd_sc_hd__decap_3
XFILLER_91_676 VGND VGND VPWR VPWR sky130_fd_sc_hd__decap_3
XTAP_TAPCELL_ROW_106_1641 VGND VPWR sky130_fd_sc_hd__tapvpwrvgnd_1
XTAP_TAPCELL_ROW_34_705 VGND VPWR sky130_fd_sc_hd__tapvpwrvgnd_1
XFILLER_32_732 VGND VGND VPWR VPWR sky130_fd_sc_hd__fill_1
XFILLER_31_231 VGND VGND VPWR VPWR sky130_fd_sc_hd__decap_3
XTAP_TAPCELL_ROW_14_440 VGND VPWR sky130_fd_sc_hd__tapvpwrvgnd_1
X_6590_ _7930_/B _6590_/B VGND VGND VPWR VPWR _6591_/A sky130_fd_sc_hd__and2_2
X_5610_ _5854_/B VGND VGND VPWR VPWR _7135_/B sky130_fd_sc_hd__buf_1
X_5541_ _8165_/Q _5540_/Y _7619_/A VGND VGND VPWR VPWR _5542_/B sky130_fd_sc_hd__a21oi_2
X_8260_ _8397_/CLK _8260_/D VGND VGND VPWR VPWR _8260_/Q sky130_fd_sc_hd__dfxtp_2
XFILLER_117_358 VGND VGND VPWR VPWR sky130_fd_sc_hd__decap_3
X_7211_ _8272_/Q _7180_/B _7210_/X VGND VGND VPWR VPWR _7213_/B sky130_fd_sc_hd__o21ai_2
X_5472_ _5472_/A VGND VGND VPWR VPWR _5472_/Y sky130_fd_sc_hd__inv_2
XTAP_TAPCELL_ROW_57_1006 VGND VPWR sky130_fd_sc_hd__tapvpwrvgnd_1
XTAP_TAPCELL_ROW_117_1781 VGND VPWR sky130_fd_sc_hd__tapvpwrvgnd_1
X_8191_ clkload4/A _8191_/D VGND VGND VPWR VPWR _8191_/Q sky130_fd_sc_hd__dfxtp_4
X_4423_ _4423_/A VGND VGND VPWR VPWR _8149_/D sky130_fd_sc_hd__buf_1
XFILLER_113_531 VGND VGND VPWR VPWR sky130_fd_sc_hd__decap_3
XFILLER_113_542 VGND VGND VPWR VPWR sky130_fd_sc_hd__decap_3
XFILLER_98_220 VGND VGND VPWR VPWR sky130_fd_sc_hd__decap_3
XFILLER_98_231 VGND VGND VPWR VPWR sky130_fd_sc_hd__decap_3
XFILLER_99_732 VGND VGND VPWR VPWR sky130_fd_sc_hd__fill_1
X_7142_ _7122_/Y _7127_/X _7132_/Y _7133_/X _7141_/X VGND VGND VPWR VPWR _7142_/X
+ sky130_fd_sc_hd__a221o_2
X_4354_ _7898_/B _4354_/B VGND VGND VPWR VPWR _4355_/A sky130_fd_sc_hd__and2_2
XFILLER_86_404 VGND VGND VPWR VPWR sky130_fd_sc_hd__decap_3
XFILLER_98_253 VGND VGND VPWR VPWR sky130_fd_sc_hd__decap_3
X_7073_ _7562_/A _7228_/C VGND VGND VPWR VPWR _7074_/B sky130_fd_sc_hd__and2_2
XFILLER_100_214 VGND VGND VPWR VPWR sky130_fd_sc_hd__decap_3
XFILLER_58_128 VGND VGND VPWR VPWR sky130_fd_sc_hd__decap_3
XFILLER_86_448 VGND VGND VPWR VPWR sky130_fd_sc_hd__decap_3
X_6024_ _6024_/A _6024_/B VGND VGND VPWR VPWR _6192_/B sky130_fd_sc_hd__nand2_2
X_4285_ _4285_/A VGND VGND VPWR VPWR _8080_/D sky130_fd_sc_hd__buf_1
XFILLER_100_236 VGND VGND VPWR VPWR sky130_fd_sc_hd__decap_3
XFILLER_54_312 VGND VGND VPWR VPWR sky130_fd_sc_hd__decap_3
XFILLER_66_161 VGND VGND VPWR VPWR sky130_fd_sc_hd__decap_3
XFILLER_67_673 VGND VGND VPWR VPWR sky130_fd_sc_hd__decap_3
XFILLER_82_621 VGND VGND VPWR VPWR sky130_fd_sc_hd__decap_3
XFILLER_27_559 VGND VGND VPWR VPWR sky130_fd_sc_hd__fill_1
XFILLER_66_183 VGND VGND VPWR VPWR sky130_fd_sc_hd__decap_3
XFILLER_81_131 VGND VGND VPWR VPWR sky130_fd_sc_hd__decap_3
XFILLER_82_654 VGND VGND VPWR VPWR sky130_fd_sc_hd__decap_3
XFILLER_94_492 VGND VGND VPWR VPWR sky130_fd_sc_hd__decap_3
X_7975_ _8380_/CLK _7975_/D VGND VGND VPWR VPWR _7975_/Q sky130_fd_sc_hd__dfxtp_2
XTAP_TAPCELL_ROW_68_1146 VGND VPWR sky130_fd_sc_hd__tapvpwrvgnd_1
XFILLER_54_356 VGND VGND VPWR VPWR sky130_fd_sc_hd__decap_3
XFILLER_82_676 VGND VGND VPWR VPWR sky130_fd_sc_hd__decap_3
X_6926_ _8200_/Q _6926_/B VGND VGND VPWR VPWR _6943_/B sky130_fd_sc_hd__or2_4
XFILLER_23_732 VGND VGND VPWR VPWR sky130_fd_sc_hd__fill_1
XFILLER_35_570 VGND VGND VPWR VPWR sky130_fd_sc_hd__decap_3
XTAP_TAPCELL_ROW_81_1313 VGND VPWR sky130_fd_sc_hd__tapvpwrvgnd_1
XFILLER_22_242 VGND VGND VPWR VPWR sky130_fd_sc_hd__decap_3
XFILLER_80_29 VGND VGND VPWR VPWR sky130_fd_sc_hd__decap_3
X_6857_ _6857_/A _6856_/X VGND VGND VPWR VPWR _6857_/X sky130_fd_sc_hd__or2b_2
XFILLER_22_253 VGND VGND VPWR VPWR sky130_fd_sc_hd__decap_3
XFILLER_50_584 VGND VGND VPWR VPWR sky130_fd_sc_hd__decap_3
X_6788_ _7193_/A _5524_/X _6770_/X _6780_/X _6787_/Y VGND VGND VPWR VPWR _6788_/X
+ sky130_fd_sc_hd__o2111a_2
X_5808_ _7631_/A _5897_/A _5807_/Y _6121_/B _5884_/B VGND VGND VPWR VPWR _5808_/X
+ sky130_fd_sc_hd__a32o_2
X_5739_ _5235_/X _5220_/B _6648_/A VGND VGND VPWR VPWR _5739_/X sky130_fd_sc_hd__mux2_2
XFILLER_6_419 VGND VGND VPWR VPWR sky130_fd_sc_hd__fill_1
XFILLER_108_336 VGND VGND VPWR VPWR sky130_fd_sc_hd__decap_3
XFILLER_108_358 VGND VGND VPWR VPWR sky130_fd_sc_hd__decap_3
XTAP_TAPCELL_ROW_79_1286 VGND VPWR sky130_fd_sc_hd__tapvpwrvgnd_1
X_7409_ _7409_/A _7409_/B VGND VGND VPWR VPWR _7409_/Y sky130_fd_sc_hd__nor2_2
X_8389_ _8389_/CLK _8389_/D VGND VGND VPWR VPWR _8389_/Q sky130_fd_sc_hd__dfxtp_2
XFILLER_116_380 VGND VGND VPWR VPWR sky130_fd_sc_hd__decap_3
XFILLER_89_220 VGND VGND VPWR VPWR sky130_fd_sc_hd__decap_3
XFILLER_89_231 VGND VGND VPWR VPWR sky130_fd_sc_hd__decap_3
XTAP_TAPCELL_ROW_92_1453 VGND VPWR sky130_fd_sc_hd__tapvpwrvgnd_1
XFILLER_49_128 VGND VGND VPWR VPWR sky130_fd_sc_hd__decap_3
XFILLER_92_407 VGND VGND VPWR VPWR sky130_fd_sc_hd__decap_3
XFILLER_18_504 VGND VGND VPWR VPWR sky130_fd_sc_hd__decap_3
XFILLER_38_64 VGND VGND VPWR VPWR sky130_fd_sc_hd__decap_3
XFILLER_38_97 VGND VGND VPWR VPWR sky130_fd_sc_hd__decap_3
XFILLER_58_662 VGND VGND VPWR VPWR sky130_fd_sc_hd__fill_2
XFILLER_18_548 VGND VGND VPWR VPWR sky130_fd_sc_hd__fill_1
XFILLER_57_172 VGND VGND VPWR VPWR sky130_fd_sc_hd__decap_3
XFILLER_54_41 VGND VGND VPWR VPWR sky130_fd_sc_hd__decap_3
XFILLER_73_676 VGND VGND VPWR VPWR sky130_fd_sc_hd__decap_3
XFILLER_14_721 VGND VGND VPWR VPWR sky130_fd_sc_hd__decap_3
XFILLER_26_570 VGND VGND VPWR VPWR sky130_fd_sc_hd__decap_3
XFILLER_33_529 VGND VGND VPWR VPWR sky130_fd_sc_hd__decap_3
XFILLER_45_389 VGND VGND VPWR VPWR sky130_fd_sc_hd__decap_3
XFILLER_54_74 VGND VGND VPWR VPWR sky130_fd_sc_hd__decap_3
XFILLER_60_337 VGND VGND VPWR VPWR sky130_fd_sc_hd__decap_3
XFILLER_72_175 VGND VGND VPWR VPWR sky130_fd_sc_hd__decap_3
XFILLER_72_197 VGND VGND VPWR VPWR sky130_fd_sc_hd__decap_3
XFILLER_13_231 VGND VGND VPWR VPWR sky130_fd_sc_hd__fill_1
XFILLER_60_359 VGND VGND VPWR VPWR sky130_fd_sc_hd__decap_3
XFILLER_13_253 VGND VGND VPWR VPWR sky130_fd_sc_hd__decap_3
XFILLER_41_573 VGND VGND VPWR VPWR sky130_fd_sc_hd__fill_2
XFILLER_41_595 VGND VGND VPWR VPWR sky130_fd_sc_hd__fill_1
XFILLER_70_62 VGND VGND VPWR VPWR sky130_fd_sc_hd__decap_3
XFILLER_9_235 VGND VGND VPWR VPWR sky130_fd_sc_hd__decap_3
XTAP_TAPCELL_ROW_101_1571 VGND VPWR sky130_fd_sc_hd__tapvpwrvgnd_1
Xclkload16 _8359_/CLK VGND VGND VPWR VPWR clkload16/X sky130_fd_sc_hd__clkbuf_4
Xclkload27 _8380_/CLK VGND VGND VPWR VPWR clkload27/X sky130_fd_sc_hd__clkbuf_4
XFILLER_114_317 VGND VGND VPWR VPWR sky130_fd_sc_hd__decap_3
XFILLER_5_452 VGND VGND VPWR VPWR sky130_fd_sc_hd__decap_3
XFILLER_5_474 VGND VGND VPWR VPWR sky130_fd_sc_hd__decap_3
XFILLER_79_60 VGND VGND VPWR VPWR sky130_fd_sc_hd__decap_3
XFILLER_110_512 VGND VGND VPWR VPWR sky130_fd_sc_hd__decap_3
XFILLER_68_415 VGND VGND VPWR VPWR sky130_fd_sc_hd__decap_3
XFILLER_95_201 VGND VGND VPWR VPWR sky130_fd_sc_hd__decap_3
XFILLER_96_724 VGND VGND VPWR VPWR sky130_fd_sc_hd__fill_1
XFILLER_110_545 VGND VGND VPWR VPWR sky130_fd_sc_hd__decap_3
XFILLER_49_640 VGND VGND VPWR VPWR sky130_fd_sc_hd__decap_3
XFILLER_68_448 VGND VGND VPWR VPWR sky130_fd_sc_hd__decap_3
XFILLER_95_245 VGND VGND VPWR VPWR sky130_fd_sc_hd__decap_3
X_4070_ _7898_/B _8376_/Q VGND VGND VPWR VPWR _4071_/A sky130_fd_sc_hd__and2_2
XFILLER_110_589 VGND VGND VPWR VPWR sky130_fd_sc_hd__decap_3
XFILLER_49_673 VGND VGND VPWR VPWR sky130_fd_sc_hd__decap_3
XFILLER_55_109 VGND VGND VPWR VPWR sky130_fd_sc_hd__decap_3
XFILLER_64_610 VGND VGND VPWR VPWR sky130_fd_sc_hd__fill_1
XFILLER_95_278 VGND VGND VPWR VPWR sky130_fd_sc_hd__fill_2
XFILLER_95_81 VGND VGND VPWR VPWR sky130_fd_sc_hd__decap_3
XFILLER_36_312 VGND VGND VPWR VPWR sky130_fd_sc_hd__decap_3
XFILLER_36_345 VGND VGND VPWR VPWR sky130_fd_sc_hd__decap_3
XFILLER_64_621 VGND VGND VPWR VPWR sky130_fd_sc_hd__decap_3
XFILLER_64_654 VGND VGND VPWR VPWR sky130_fd_sc_hd__decap_3
XTAP_TAPCELL_ROW_19_510 VGND VPWR sky130_fd_sc_hd__tapvpwrvgnd_1
XFILLER_24_518 VGND VGND VPWR VPWR sky130_fd_sc_hd__decap_3
XFILLER_63_131 VGND VGND VPWR VPWR sky130_fd_sc_hd__decap_3
XTAP_TAPCELL_ROW_47_874 VGND VPWR sky130_fd_sc_hd__tapvpwrvgnd_1
XFILLER_17_581 VGND VGND VPWR VPWR sky130_fd_sc_hd__decap_3
XFILLER_51_337 VGND VGND VPWR VPWR sky130_fd_sc_hd__decap_3
X_7760_ _5579_/S _5785_/A _7758_/Y _7759_/Y VGND VGND VPWR VPWR _7760_/X sky130_fd_sc_hd__a31o_2
X_4972_ _7619_/A _4972_/B VGND VGND VPWR VPWR _4972_/Y sky130_fd_sc_hd__nand2_2
X_7691_ _8191_/Q _7672_/X _7681_/X VGND VGND VPWR VPWR _7691_/Y sky130_fd_sc_hd__o21ai_2
X_6711_ _8194_/Q _6711_/B _6711_/C VGND VGND VPWR VPWR _6771_/C sky130_fd_sc_hd__or3_4
XFILLER_32_573 VGND VGND VPWR VPWR sky130_fd_sc_hd__decap_3
X_6642_ _6642_/A VGND VGND VPWR VPWR _7453_/A sky130_fd_sc_hd__buf_1
XTAP_TAPCELL_ROW_63_1076 VGND VPWR sky130_fd_sc_hd__tapvpwrvgnd_1
XFILLER_32_595 VGND VGND VPWR VPWR sky130_fd_sc_hd__decap_3
XTAP_TAPCELL_ROW_119_1810 VGND VPWR sky130_fd_sc_hd__tapvpwrvgnd_1
XTAP_TAPCELL_ROW_119_1821 VGND VPWR sky130_fd_sc_hd__tapvpwrvgnd_1
X_8312_ _8380_/CLK _8312_/D VGND VGND VPWR VPWR _8312_/Q sky130_fd_sc_hd__dfxtp_2
X_6573_ _6572_/X _6419_/X _6706_/S VGND VGND VPWR VPWR _6573_/X sky130_fd_sc_hd__mux2_2
XFILLER_117_122 VGND VGND VPWR VPWR sky130_fd_sc_hd__decap_3
XFILLER_8_290 VGND VGND VPWR VPWR sky130_fd_sc_hd__decap_3
X_5524_ _6277_/A _5519_/Y _5523_/Y _7827_/A VGND VGND VPWR VPWR _5524_/X sky130_fd_sc_hd__a211o_2
XFILLER_105_317 VGND VGND VPWR VPWR sky130_fd_sc_hd__decap_3
X_8243_ _8380_/CLK _8243_/D VGND VGND VPWR VPWR _8243_/Q sky130_fd_sc_hd__dfxtp_2
X_5455_ _5857_/A _5454_/X _7825_/A VGND VGND VPWR VPWR _6721_/C sky130_fd_sc_hd__a21o_2
X_8174_ _8187_/CLK _8174_/D VGND VGND VPWR VPWR _8174_/Q sky130_fd_sc_hd__dfxtp_4
X_4406_ _7930_/B _4406_/B VGND VGND VPWR VPWR _4407_/A sky130_fd_sc_hd__and2_2
XFILLER_87_702 VGND VGND VPWR VPWR sky130_fd_sc_hd__decap_3
XFILLER_99_540 VGND VGND VPWR VPWR sky130_fd_sc_hd__decap_3
X_7125_ _6617_/X _7124_/X _6323_/X _6890_/X _6708_/A _6818_/S VGND VGND VPWR VPWR
+ _7126_/B sky130_fd_sc_hd__mux4_2
X_5386_ _5375_/X _5378_/X _5381_/X _5385_/X _5270_/X _7745_/A VGND VGND VPWR VPWR
+ _5386_/X sky130_fd_sc_hd__mux4_2
XFILLER_101_523 VGND VGND VPWR VPWR sky130_fd_sc_hd__decap_3
XFILLER_115_36 VGND VGND VPWR VPWR sky130_fd_sc_hd__decap_3
XFILLER_59_426 VGND VGND VPWR VPWR sky130_fd_sc_hd__decap_3
X_4337_ _4337_/A VGND VGND VPWR VPWR _8106_/D sky130_fd_sc_hd__buf_1
XFILLER_101_556 VGND VGND VPWR VPWR sky130_fd_sc_hd__decap_3
XFILLER_115_69 VGND VGND VPWR VPWR sky130_fd_sc_hd__decap_3
XFILLER_75_18 VGND VGND VPWR VPWR sky130_fd_sc_hd__decap_3
XFILLER_86_245 VGND VGND VPWR VPWR sky130_fd_sc_hd__decap_3
X_7056_ _8288_/Q _8270_/Q _5323_/Y _7631_/B _8206_/Q VGND VGND VPWR VPWR _7056_/X
+ sky130_fd_sc_hd__o2111a_2
X_4268_ _7898_/B _4268_/B VGND VGND VPWR VPWR _4269_/A sky130_fd_sc_hd__and2_2
XFILLER_101_589 VGND VGND VPWR VPWR sky130_fd_sc_hd__fill_2
XFILLER_74_407 VGND VGND VPWR VPWR sky130_fd_sc_hd__decap_3
X_6007_ _6007_/A _6007_/B VGND VGND VPWR VPWR _6007_/Y sky130_fd_sc_hd__xnor2_2
XFILLER_67_492 VGND VGND VPWR VPWR sky130_fd_sc_hd__decap_3
X_4199_ _4199_/A VGND VGND VPWR VPWR _8037_/D sky130_fd_sc_hd__buf_1
XFILLER_27_367 VGND VGND VPWR VPWR sky130_fd_sc_hd__decap_3
XFILLER_54_153 VGND VGND VPWR VPWR sky130_fd_sc_hd__fill_2
XFILLER_82_451 VGND VGND VPWR VPWR sky130_fd_sc_hd__decap_3
XFILLER_15_529 VGND VGND VPWR VPWR sky130_fd_sc_hd__decap_3
XFILLER_54_186 VGND VGND VPWR VPWR sky130_fd_sc_hd__decap_3
XFILLER_54_197 VGND VGND VPWR VPWR sky130_fd_sc_hd__decap_3
XFILLER_55_698 VGND VGND VPWR VPWR sky130_fd_sc_hd__decap_3
X_7958_ _8387_/CLK _7958_/D VGND VGND VPWR VPWR _7958_/Q sky130_fd_sc_hd__dfxtp_2
XFILLER_42_348 VGND VGND VPWR VPWR sky130_fd_sc_hd__decap_3
X_7889_ _7889_/A VGND VGND VPWR VPWR _8381_/D sky130_fd_sc_hd__buf_1
X_6909_ _7167_/B _6909_/B VGND VGND VPWR VPWR _6910_/C sky130_fd_sc_hd__or2_2
XFILLER_11_702 VGND VGND VPWR VPWR sky130_fd_sc_hd__decap_3
XFILLER_11_724 VGND VGND VPWR VPWR sky130_fd_sc_hd__decap_3
XFILLER_24_55 VGND VGND VPWR VPWR sky130_fd_sc_hd__fill_2
XTAP_TAPCELL_ROW_25_579 VGND VPWR sky130_fd_sc_hd__tapvpwrvgnd_1
XFILLER_23_595 VGND VGND VPWR VPWR sky130_fd_sc_hd__decap_3
XFILLER_24_88 VGND VGND VPWR VPWR sky130_fd_sc_hd__decap_3
XFILLER_109_601 VGND VGND VPWR VPWR sky130_fd_sc_hd__decap_3
XFILLER_6_216 VGND VGND VPWR VPWR sky130_fd_sc_hd__fill_2
XFILLER_6_238 VGND VGND VPWR VPWR sky130_fd_sc_hd__decap_3
XFILLER_108_144 VGND VGND VPWR VPWR sky130_fd_sc_hd__decap_3
XFILLER_111_309 VGND VGND VPWR VPWR sky130_fd_sc_hd__decap_3
XFILLER_2_488 VGND VGND VPWR VPWR sky130_fd_sc_hd__decap_3
XFILLER_49_63 VGND VGND VPWR VPWR sky130_fd_sc_hd__decap_3
XFILLER_77_212 VGND VGND VPWR VPWR sky130_fd_sc_hd__decap_3
XFILLER_104_394 VGND VGND VPWR VPWR sky130_fd_sc_hd__decap_3
XFILLER_49_85 VGND VGND VPWR VPWR sky130_fd_sc_hd__decap_3
XFILLER_77_234 VGND VGND VPWR VPWR sky130_fd_sc_hd__fill_1
XFILLER_18_301 VGND VGND VPWR VPWR sky130_fd_sc_hd__decap_3
XFILLER_65_429 VGND VGND VPWR VPWR sky130_fd_sc_hd__decap_3
XFILLER_77_267 VGND VGND VPWR VPWR sky130_fd_sc_hd__decap_3
XFILLER_92_215 VGND VGND VPWR VPWR sky130_fd_sc_hd__fill_1
XFILLER_93_716 VGND VGND VPWR VPWR sky130_fd_sc_hd__decap_3
XFILLER_18_312 VGND VGND VPWR VPWR sky130_fd_sc_hd__decap_3
XFILLER_18_334 VGND VGND VPWR VPWR sky130_fd_sc_hd__decap_3
XFILLER_46_632 VGND VGND VPWR VPWR sky130_fd_sc_hd__decap_3
XFILLER_58_492 VGND VGND VPWR VPWR sky130_fd_sc_hd__fill_1
XFILLER_92_237 VGND VGND VPWR VPWR sky130_fd_sc_hd__decap_3
XFILLER_45_142 VGND VGND VPWR VPWR sky130_fd_sc_hd__decap_3
XFILLER_65_84 VGND VGND VPWR VPWR sky130_fd_sc_hd__decap_3
XFILLER_18_389 VGND VGND VPWR VPWR sky130_fd_sc_hd__decap_3
XFILLER_33_315 VGND VGND VPWR VPWR sky130_fd_sc_hd__decap_3
XFILLER_33_337 VGND VGND VPWR VPWR sky130_fd_sc_hd__decap_3
XFILLER_45_175 VGND VGND VPWR VPWR sky130_fd_sc_hd__fill_1
XFILLER_61_613 VGND VGND VPWR VPWR sky130_fd_sc_hd__decap_3
XFILLER_61_635 VGND VGND VPWR VPWR sky130_fd_sc_hd__decap_3
XFILLER_73_473 VGND VGND VPWR VPWR sky130_fd_sc_hd__decap_3
XTAP_TAPCELL_ROW_103_1600 VGND VPWR sky130_fd_sc_hd__tapvpwrvgnd_1
XTAP_TAPCELL_ROW_44_833 VGND VPWR sky130_fd_sc_hd__tapvpwrvgnd_1
XFILLER_60_134 VGND VGND VPWR VPWR sky130_fd_sc_hd__decap_3
XFILLER_61_657 VGND VGND VPWR VPWR sky130_fd_sc_hd__decap_3
XFILLER_61_679 VGND VGND VPWR VPWR sky130_fd_sc_hd__decap_3
XFILLER_60_156 VGND VGND VPWR VPWR sky130_fd_sc_hd__decap_3
XFILLER_60_189 VGND VGND VPWR VPWR sky130_fd_sc_hd__decap_3
XFILLER_81_72 VGND VGND VPWR VPWR sky130_fd_sc_hd__decap_3
XFILLER_14_595 VGND VGND VPWR VPWR sky130_fd_sc_hd__decap_3
XTAP_TAPCELL_ROW_114_1740 VGND VPWR sky130_fd_sc_hd__tapvpwrvgnd_1
X_5240_ _6070_/B _5477_/A VGND VGND VPWR VPWR _7661_/B sky130_fd_sc_hd__nor2_2
XFILLER_102_309 VGND VGND VPWR VPWR sky130_fd_sc_hd__decap_3
XFILLER_114_147 VGND VGND VPWR VPWR sky130_fd_sc_hd__decap_3
XFILLER_5_293 VGND VGND VPWR VPWR sky130_fd_sc_hd__decap_3
XFILLER_69_702 VGND VGND VPWR VPWR sky130_fd_sc_hd__decap_3
XFILLER_68_212 VGND VGND VPWR VPWR sky130_fd_sc_hd__decap_3
XFILLER_96_521 VGND VGND VPWR VPWR sky130_fd_sc_hd__decap_3
XPHY_EDGE_ROW_18_Right_18 VGND VGND VPWR VPWR sky130_fd_sc_hd__decap_3
X_5171_ _8188_/Q _6712_/B _5484_/S VGND VGND VPWR VPWR _5171_/X sky130_fd_sc_hd__mux2_2
XFILLER_110_331 VGND VGND VPWR VPWR sky130_fd_sc_hd__fill_2
XFILLER_110_342 VGND VGND VPWR VPWR sky130_fd_sc_hd__decap_3
XFILLER_68_245 VGND VGND VPWR VPWR sky130_fd_sc_hd__decap_3
XFILLER_96_565 VGND VGND VPWR VPWR sky130_fd_sc_hd__decap_3
X_4122_ _7930_/B _8402_/Q VGND VGND VPWR VPWR _4123_/A sky130_fd_sc_hd__and2_2
XFILLER_28_109 VGND VGND VPWR VPWR sky130_fd_sc_hd__decap_3
XFILLER_56_407 VGND VGND VPWR VPWR sky130_fd_sc_hd__decap_3
XFILLER_68_278 VGND VGND VPWR VPWR sky130_fd_sc_hd__decap_3
X_4053_ _4053_/A VGND VGND VPWR VPWR _7964_/D sky130_fd_sc_hd__buf_1
XFILLER_49_470 VGND VGND VPWR VPWR sky130_fd_sc_hd__decap_3
Xinput3 cmd[1] VGND VGND VPWR VPWR input3/X sky130_fd_sc_hd__clkdlybuf4s25_1
XFILLER_36_153 VGND VGND VPWR VPWR sky130_fd_sc_hd__decap_3
XFILLER_64_440 VGND VGND VPWR VPWR sky130_fd_sc_hd__decap_3
XFILLER_64_462 VGND VGND VPWR VPWR sky130_fd_sc_hd__decap_3
XFILLER_83_259 VGND VGND VPWR VPWR sky130_fd_sc_hd__decap_3
XFILLER_64_495 VGND VGND VPWR VPWR sky130_fd_sc_hd__decap_3
X_7812_ _7812_/A _8165_/Q _7812_/C VGND VGND VPWR VPWR _7812_/X sky130_fd_sc_hd__and3_2
XTAP_TAPCELL_ROW_65_1105 VGND VPWR sky130_fd_sc_hd__tapvpwrvgnd_1
XFILLER_101_27 VGND VGND VPWR VPWR sky130_fd_sc_hd__decap_3
XFILLER_24_337 VGND VGND VPWR VPWR sky130_fd_sc_hd__decap_3
XFILLER_24_359 VGND VGND VPWR VPWR sky130_fd_sc_hd__decap_3
XFILLER_51_134 VGND VGND VPWR VPWR sky130_fd_sc_hd__decap_3
XFILLER_91_292 VGND VGND VPWR VPWR sky130_fd_sc_hd__fill_2
XPHY_EDGE_ROW_27_Right_27 VGND VGND VPWR VPWR sky130_fd_sc_hd__decap_3
X_7743_ _7652_/Y _7743_/B _7743_/C VGND VGND VPWR VPWR _7743_/X sky130_fd_sc_hd__and3b_2
X_4955_ _5886_/A _5566_/A _5548_/A _5506_/A VGND VGND VPWR VPWR _4970_/B sky130_fd_sc_hd__or4b_2
XFILLER_51_167 VGND VGND VPWR VPWR sky130_fd_sc_hd__fill_1
XFILLER_32_381 VGND VGND VPWR VPWR sky130_fd_sc_hd__decap_3
X_7674_ _7754_/A _7674_/B VGND VGND VPWR VPWR _7674_/Y sky130_fd_sc_hd__nand2_2
X_4886_ _8186_/Q _4886_/B VGND VGND VPWR VPWR _6563_/B sky130_fd_sc_hd__nor2_2
XTAP_TAPCELL_ROW_22_549 VGND VPWR sky130_fd_sc_hd__tapvpwrvgnd_1
XFILLER_20_576 VGND VGND VPWR VPWR sky130_fd_sc_hd__decap_3
X_6625_ _6625_/A VGND VGND VPWR VPWR _6687_/A sky130_fd_sc_hd__buf_1
XFILLER_20_598 VGND VGND VPWR VPWR sky130_fd_sc_hd__decap_3
X_6556_ _7209_/A _6528_/X _6555_/X VGND VGND VPWR VPWR _6556_/X sky130_fd_sc_hd__a21o_2
XFILLER_117_9 VGND VGND VPWR VPWR sky130_fd_sc_hd__decap_3
X_5507_ _5507_/A VGND VGND VPWR VPWR _5507_/X sky130_fd_sc_hd__clkbuf_1
XFILLER_106_626 VGND VGND VPWR VPWR sky130_fd_sc_hd__fill_1
XFILLER_10_35 VGND VGND VPWR VPWR sky130_fd_sc_hd__decap_3
XFILLER_10_46 VGND VGND VPWR VPWR sky130_fd_sc_hd__decap_3
X_8226_ _8226_/CLK _8226_/D VGND VGND VPWR VPWR _8226_/Q sky130_fd_sc_hd__dfxtp_4
X_6487_ _7694_/B _7182_/B VGND VGND VPWR VPWR _6487_/Y sky130_fd_sc_hd__nand2_2
XTAP_TAPCELL_ROW_76_1245 VGND VPWR sky130_fd_sc_hd__tapvpwrvgnd_1
XFILLER_105_136 VGND VGND VPWR VPWR sky130_fd_sc_hd__decap_3
XFILLER_105_169 VGND VGND VPWR VPWR sky130_fd_sc_hd__decap_3
XFILLER_10_68 VGND VGND VPWR VPWR sky130_fd_sc_hd__decap_3
XPHY_EDGE_ROW_36_Right_36 VGND VGND VPWR VPWR sky130_fd_sc_hd__decap_3
X_5438_ _5205_/X _5201_/X _5452_/S VGND VGND VPWR VPWR _5822_/B sky130_fd_sc_hd__mux2_2
XFILLER_114_681 VGND VGND VPWR VPWR sky130_fd_sc_hd__fill_2
XFILLER_59_201 VGND VGND VPWR VPWR sky130_fd_sc_hd__decap_3
X_8157_ _8359_/CLK _8157_/D VGND VGND VPWR VPWR _8157_/Q sky130_fd_sc_hd__dfxtp_2
X_5369_ _5363_/X _5854_/B _5364_/Y _5774_/B _6421_/S VGND VGND VPWR VPWR _5369_/X
+ sky130_fd_sc_hd__o311a_2
XFILLER_59_245 VGND VGND VPWR VPWR sky130_fd_sc_hd__decap_3
XFILLER_86_39 VGND VGND VPWR VPWR sky130_fd_sc_hd__decap_3
XFILLER_87_532 VGND VGND VPWR VPWR sky130_fd_sc_hd__decap_3
XFILLER_87_554 VGND VGND VPWR VPWR sky130_fd_sc_hd__decap_3
X_8088_ _8229_/CLK _8088_/D VGND VGND VPWR VPWR _8088_/Q sky130_fd_sc_hd__dfxtp_2
X_7108_ _8291_/Q _7108_/B VGND VGND VPWR VPWR _7108_/Y sky130_fd_sc_hd__nor2_2
XFILLER_19_109 VGND VGND VPWR VPWR sky130_fd_sc_hd__decap_3
XFILLER_19_55 VGND VGND VPWR VPWR sky130_fd_sc_hd__fill_1
XFILLER_87_576 VGND VGND VPWR VPWR sky130_fd_sc_hd__fill_2
XFILLER_87_598 VGND VGND VPWR VPWR sky130_fd_sc_hd__decap_3
X_7039_ _6506_/X _7038_/X _6200_/X _6782_/X _6708_/A _7745_/A VGND VGND VPWR VPWR
+ _7039_/X sky130_fd_sc_hd__mux4_2
XFILLER_19_66 VGND VGND VPWR VPWR sky130_fd_sc_hd__decap_3
XFILLER_28_621 VGND VGND VPWR VPWR sky130_fd_sc_hd__decap_3
XFILLER_74_215 VGND VGND VPWR VPWR sky130_fd_sc_hd__decap_3
XFILLER_74_248 VGND VGND VPWR VPWR sky130_fd_sc_hd__decap_3
XFILLER_27_142 VGND VGND VPWR VPWR sky130_fd_sc_hd__decap_3
XFILLER_28_654 VGND VGND VPWR VPWR sky130_fd_sc_hd__fill_1
XFILLER_74_259 VGND VGND VPWR VPWR sky130_fd_sc_hd__decap_3
XFILLER_15_315 VGND VGND VPWR VPWR sky130_fd_sc_hd__decap_3
XFILLER_35_21 VGND VGND VPWR VPWR sky130_fd_sc_hd__decap_3
XFILLER_55_484 VGND VGND VPWR VPWR sky130_fd_sc_hd__decap_3
XFILLER_70_410 VGND VGND VPWR VPWR sky130_fd_sc_hd__decap_3
XFILLER_70_421 VGND VGND VPWR VPWR sky130_fd_sc_hd__decap_3
XPHY_EDGE_ROW_45_Right_45 VGND VGND VPWR VPWR sky130_fd_sc_hd__decap_3
XTAP_TAPCELL_ROW_87_1396 VGND VPWR sky130_fd_sc_hd__tapvpwrvgnd_1
XTAP_TAPCELL_ROW_87_1385 VGND VPWR sky130_fd_sc_hd__tapvpwrvgnd_1
XTAP_TAPCELL_ROW_2_285 VGND VPWR sky130_fd_sc_hd__tapvpwrvgnd_1
XFILLER_15_337 VGND VGND VPWR VPWR sky130_fd_sc_hd__decap_3
XFILLER_35_54 VGND VGND VPWR VPWR sky130_fd_sc_hd__fill_2
XFILLER_35_76 VGND VGND VPWR VPWR sky130_fd_sc_hd__decap_3
XFILLER_82_292 VGND VGND VPWR VPWR sky130_fd_sc_hd__decap_3
XFILLER_30_329 VGND VGND VPWR VPWR sky130_fd_sc_hd__decap_3
XFILLER_51_20 VGND VGND VPWR VPWR sky130_fd_sc_hd__decap_3
XFILLER_51_42 VGND VGND VPWR VPWR sky130_fd_sc_hd__decap_3
XFILLER_109_431 VGND VGND VPWR VPWR sky130_fd_sc_hd__decap_3
XFILLER_7_547 VGND VGND VPWR VPWR sky130_fd_sc_hd__decap_3
XFILLER_109_497 VGND VGND VPWR VPWR sky130_fd_sc_hd__decap_3
XPHY_EDGE_ROW_54_Right_54 VGND VGND VPWR VPWR sky130_fd_sc_hd__decap_3
XPHY_EDGE_ROW_29_Left_149 VGND VGND VPWR VPWR sky130_fd_sc_hd__decap_3
XFILLER_38_429 VGND VGND VPWR VPWR sky130_fd_sc_hd__decap_3
XFILLER_76_50 VGND VGND VPWR VPWR sky130_fd_sc_hd__decap_3
XFILLER_65_237 VGND VGND VPWR VPWR sky130_fd_sc_hd__decap_3
XFILLER_76_83 VGND VGND VPWR VPWR sky130_fd_sc_hd__fill_1
XFILLER_93_535 VGND VGND VPWR VPWR sky130_fd_sc_hd__decap_3
XFILLER_18_120 VGND VGND VPWR VPWR sky130_fd_sc_hd__decap_3
XFILLER_19_654 VGND VGND VPWR VPWR sky130_fd_sc_hd__decap_3
XFILLER_19_676 VGND VGND VPWR VPWR sky130_fd_sc_hd__decap_3
XFILLER_46_451 VGND VGND VPWR VPWR sky130_fd_sc_hd__decap_3
XFILLER_65_259 VGND VGND VPWR VPWR sky130_fd_sc_hd__decap_3
XFILLER_93_579 VGND VGND VPWR VPWR sky130_fd_sc_hd__decap_3
XPHY_EDGE_ROW_63_Right_63 VGND VGND VPWR VPWR sky130_fd_sc_hd__decap_3
XFILLER_18_153 VGND VGND VPWR VPWR sky130_fd_sc_hd__fill_1
XFILLER_18_186 VGND VGND VPWR VPWR sky130_fd_sc_hd__fill_1
XFILLER_73_270 VGND VGND VPWR VPWR sky130_fd_sc_hd__decap_3
XFILLER_34_657 VGND VGND VPWR VPWR sky130_fd_sc_hd__fill_1
XFILLER_73_281 VGND VGND VPWR VPWR sky130_fd_sc_hd__decap_3
XFILLER_33_156 VGND VGND VPWR VPWR sky130_fd_sc_hd__decap_3
XFILLER_61_476 VGND VGND VPWR VPWR sky130_fd_sc_hd__decap_3
XFILLER_92_82 VGND VGND VPWR VPWR sky130_fd_sc_hd__fill_2
XPHY_EDGE_ROW_1_Left_121 VGND VGND VPWR VPWR sky130_fd_sc_hd__decap_3
XPHY_EDGE_ROW_38_Left_158 VGND VGND VPWR VPWR sky130_fd_sc_hd__decap_3
X_4740_ _8280_/Q _8216_/Q VGND VGND VPWR VPWR _4741_/B sky130_fd_sc_hd__and2b_2
X_4671_ _4671_/A VGND VGND VPWR VPWR _8273_/D sky130_fd_sc_hd__buf_1
XTAP_TAPCELL_ROW_60_1035 VGND VPWR sky130_fd_sc_hd__tapvpwrvgnd_1
X_7390_ _6866_/X _7389_/X _6573_/X _7113_/X _6536_/A _6507_/S VGND VGND VPWR VPWR
+ _7390_/X sky130_fd_sc_hd__mux4_2
X_6410_ _6359_/B _6599_/A _6409_/X VGND VGND VPWR VPWR _6411_/B sky130_fd_sc_hd__o21a_2
XPHY_EDGE_ROW_72_Right_72 VGND VGND VPWR VPWR sky130_fd_sc_hd__decap_3
X_6341_ _8249_/Q _5399_/X wire225/X VGND VGND VPWR VPWR _6341_/X sky130_fd_sc_hd__o21a_2
XFILLER_115_434 VGND VGND VPWR VPWR sky130_fd_sc_hd__fill_1
XFILLER_6_580 VGND VGND VPWR VPWR sky130_fd_sc_hd__decap_3
X_6272_ _7646_/A _6426_/B _5854_/B VGND VGND VPWR VPWR _6272_/Y sky130_fd_sc_hd__a21oi_2
XFILLER_102_117 VGND VGND VPWR VPWR sky130_fd_sc_hd__decap_3
XFILLER_103_629 VGND VGND VPWR VPWR sky130_fd_sc_hd__decap_3
XFILLER_88_329 VGND VGND VPWR VPWR sky130_fd_sc_hd__fill_2
XPHY_EDGE_ROW_47_Left_167 VGND VGND VPWR VPWR sky130_fd_sc_hd__decap_3
X_8011_ _8390_/CLK _8011_/D VGND VGND VPWR VPWR _8011_/Q sky130_fd_sc_hd__dfxtp_2
X_5223_ _8193_/Q _8194_/Q _5678_/S VGND VGND VPWR VPWR _5223_/X sky130_fd_sc_hd__mux2_2
X_5154_ _5152_/X _5153_/X _5634_/S VGND VGND VPWR VPWR _5154_/X sky130_fd_sc_hd__mux2_2
XFILLER_110_150 VGND VGND VPWR VPWR sky130_fd_sc_hd__decap_3
XFILLER_111_673 VGND VGND VPWR VPWR sky130_fd_sc_hd__decap_3
XFILLER_96_351 VGND VGND VPWR VPWR sky130_fd_sc_hd__decap_3
X_4105_ _4105_/A VGND VGND VPWR VPWR _7990_/D sky130_fd_sc_hd__buf_1
XTAP_TAPCELL_ROW_71_1186 VGND VPWR sky130_fd_sc_hd__tapvpwrvgnd_1
XFILLER_29_429 VGND VGND VPWR VPWR sky130_fd_sc_hd__fill_2
XFILLER_2_80 VGND VGND VPWR VPWR sky130_fd_sc_hd__decap_3
XFILLER_56_215 VGND VGND VPWR VPWR sky130_fd_sc_hd__decap_3
XFILLER_69_598 VGND VGND VPWR VPWR sky130_fd_sc_hd__fill_2
XFILLER_84_524 VGND VGND VPWR VPWR sky130_fd_sc_hd__decap_3
XPHY_EDGE_ROW_81_Right_81 VGND VGND VPWR VPWR sky130_fd_sc_hd__decap_3
X_5085_ split/X _5333_/A _7617_/A VGND VGND VPWR VPWR _5085_/Y sky130_fd_sc_hd__a21boi_2
XFILLER_2_91 VGND VGND VPWR VPWR sky130_fd_sc_hd__decap_3
XFILLER_56_248 VGND VGND VPWR VPWR sky130_fd_sc_hd__decap_3
XFILLER_84_557 VGND VGND VPWR VPWR sky130_fd_sc_hd__decap_3
X_4036_ _7843_/A _8359_/Q VGND VGND VPWR VPWR _4037_/A sky130_fd_sc_hd__and2_2
XTAP_TAPCELL_ROW_27_608 VGND VPWR sky130_fd_sc_hd__tapvpwrvgnd_1
XFILLER_37_473 VGND VGND VPWR VPWR sky130_fd_sc_hd__fill_2
XFILLER_52_410 VGND VGND VPWR VPWR sky130_fd_sc_hd__decap_3
XFILLER_64_270 VGND VGND VPWR VPWR sky130_fd_sc_hd__decap_3
XFILLER_24_112 VGND VGND VPWR VPWR sky130_fd_sc_hd__fill_1
XFILLER_25_657 VGND VGND VPWR VPWR sky130_fd_sc_hd__decap_3
XFILLER_37_495 VGND VGND VPWR VPWR sky130_fd_sc_hd__fill_1
XFILLER_52_421 VGND VGND VPWR VPWR sky130_fd_sc_hd__decap_3
XFILLER_80_730 VGND VGND VPWR VPWR sky130_fd_sc_hd__decap_3
XPHY_EDGE_ROW_56_Left_176 VGND VGND VPWR VPWR sky130_fd_sc_hd__decap_3
XFILLER_24_156 VGND VGND VPWR VPWR sky130_fd_sc_hd__decap_3
X_5987_ _7202_/A _5987_/B VGND VGND VPWR VPWR _5987_/Y sky130_fd_sc_hd__nand2_2
XFILLER_24_189 VGND VGND VPWR VPWR sky130_fd_sc_hd__decap_3
X_7726_ _7776_/A _7725_/B _7670_/B _5596_/S VGND VGND VPWR VPWR _7726_/Y sky130_fd_sc_hd__a211oi_2
X_4938_ _8234_/Q _8170_/Q VGND VGND VPWR VPWR _4939_/B sky130_fd_sc_hd__and2b_2
XANTENNA_30 _8209_/Q VGND VGND VPWR VPWR sky130_fd_sc_hd__diode_2
XFILLER_20_351 VGND VGND VPWR VPWR sky130_fd_sc_hd__decap_3
X_7657_ _7812_/C VGND VGND VPWR VPWR _7820_/B sky130_fd_sc_hd__buf_1
X_4869_ _8190_/Q _8254_/Q VGND VGND VPWR VPWR _6592_/D sky130_fd_sc_hd__xnor2_2
XPHY_EDGE_ROW_90_Right_90 VGND VGND VPWR VPWR sky130_fd_sc_hd__decap_3
X_6608_ _8255_/Q _6567_/A _6567_/B _6605_/A VGND VGND VPWR VPWR _6608_/X sky130_fd_sc_hd__a31o_2
XFILLER_115_6 VGND VGND VPWR VPWR sky130_fd_sc_hd__decap_3
XFILLER_118_250 VGND VGND VPWR VPWR sky130_fd_sc_hd__fill_2
XFILLER_20_395 VGND VGND VPWR VPWR sky130_fd_sc_hd__decap_3
XFILLER_4_506 VGND VGND VPWR VPWR sky130_fd_sc_hd__fill_1
X_7588_ _7588_/A _7588_/B VGND VGND VPWR VPWR _7588_/Y sky130_fd_sc_hd__xnor2_2
XFILLER_106_401 VGND VGND VPWR VPWR sky130_fd_sc_hd__decap_3
XFILLER_4_528 VGND VGND VPWR VPWR sky130_fd_sc_hd__decap_3
XPHY_EDGE_ROW_65_Left_185 VGND VGND VPWR VPWR sky130_fd_sc_hd__decap_3
X_6539_ _5574_/A _6355_/X _6538_/Y _7135_/B _7193_/A VGND VGND VPWR VPWR _6539_/X
+ sky130_fd_sc_hd__o221a_2
XFILLER_106_456 VGND VGND VPWR VPWR sky130_fd_sc_hd__fill_1
XFILLER_106_467 VGND VGND VPWR VPWR sky130_fd_sc_hd__decap_3
XFILLER_97_38 VGND VGND VPWR VPWR sky130_fd_sc_hd__decap_3
XFILLER_0_701 VGND VGND VPWR VPWR sky130_fd_sc_hd__decap_3
XFILLER_0_723 VGND VGND VPWR VPWR sky130_fd_sc_hd__decap_3
X_8209_ _8359_/CLK _8209_/D VGND VGND VPWR VPWR _8209_/Q sky130_fd_sc_hd__dfxtp_2
Xoutput170 _7996_/Q VGND VGND VPWR VPWR result[38] sky130_fd_sc_hd__clkdlybuf4s25_1
Xoutput192 _8016_/Q VGND VGND VPWR VPWR result[58] sky130_fd_sc_hd__clkdlybuf4s25_1
Xoutput181 _8006_/Q VGND VGND VPWR VPWR result[48] sky130_fd_sc_hd__clkdlybuf4s25_1
XTAP_TAPCELL_ROW_7_355 VGND VPWR sky130_fd_sc_hd__tapvpwrvgnd_1
XTAP_TAPCELL_ROW_7_344 VGND VPWR sky130_fd_sc_hd__tapvpwrvgnd_1
XFILLER_101_150 VGND VGND VPWR VPWR sky130_fd_sc_hd__decap_3
XFILLER_75_502 VGND VGND VPWR VPWR sky130_fd_sc_hd__fill_2
XTAP_TAPCELL_ROW_89_1414 VGND VPWR sky130_fd_sc_hd__tapvpwrvgnd_1
XFILLER_101_172 VGND VGND VPWR VPWR sky130_fd_sc_hd__fill_2
XFILLER_47_215 VGND VGND VPWR VPWR sky130_fd_sc_hd__fill_1
XFILLER_75_535 VGND VGND VPWR VPWR sky130_fd_sc_hd__decap_3
XFILLER_46_20 VGND VGND VPWR VPWR sky130_fd_sc_hd__decap_3
XFILLER_63_719 VGND VGND VPWR VPWR sky130_fd_sc_hd__fill_1
XFILLER_90_505 VGND VGND VPWR VPWR sky130_fd_sc_hd__decap_3
XFILLER_16_624 VGND VGND VPWR VPWR sky130_fd_sc_hd__decap_3
XFILLER_62_229 VGND VGND VPWR VPWR sky130_fd_sc_hd__decap_3
XPHY_EDGE_ROW_74_Left_194 VGND VGND VPWR VPWR sky130_fd_sc_hd__decap_3
XFILLER_15_134 VGND VGND VPWR VPWR sky130_fd_sc_hd__decap_3
XFILLER_16_657 VGND VGND VPWR VPWR sky130_fd_sc_hd__decap_3
XFILLER_55_281 VGND VGND VPWR VPWR sky130_fd_sc_hd__decap_3
XFILLER_15_167 VGND VGND VPWR VPWR sky130_fd_sc_hd__fill_1
XFILLER_31_627 VGND VGND VPWR VPWR sky130_fd_sc_hd__decap_3
XFILLER_43_487 VGND VGND VPWR VPWR sky130_fd_sc_hd__decap_3
XFILLER_70_251 VGND VGND VPWR VPWR sky130_fd_sc_hd__fill_1
XFILLER_70_262 VGND VGND VPWR VPWR sky130_fd_sc_hd__decap_3
XTAP_TAPCELL_ROW_54_961 VGND VPWR sky130_fd_sc_hd__tapvpwrvgnd_1
XFILLER_30_126 VGND VGND VPWR VPWR sky130_fd_sc_hd__decap_3
XFILLER_62_41 VGND VGND VPWR VPWR sky130_fd_sc_hd__decap_3
XFILLER_70_284 VGND VGND VPWR VPWR sky130_fd_sc_hd__decap_3
XFILLER_70_295 VGND VGND VPWR VPWR sky130_fd_sc_hd__decap_3
XFILLER_62_85 VGND VGND VPWR VPWR sky130_fd_sc_hd__decap_3
XFILLER_11_351 VGND VGND VPWR VPWR sky130_fd_sc_hd__decap_3
XFILLER_11_384 VGND VGND VPWR VPWR sky130_fd_sc_hd__decap_3
XFILLER_7_300 VGND VGND VPWR VPWR sky130_fd_sc_hd__decap_3
XFILLER_7_47 VGND VGND VPWR VPWR sky130_fd_sc_hd__decap_3
XFILLER_7_69 VGND VGND VPWR VPWR sky130_fd_sc_hd__decap_3
XFILLER_109_261 VGND VGND VPWR VPWR sky130_fd_sc_hd__decap_3
XFILLER_7_377 VGND VGND VPWR VPWR sky130_fd_sc_hd__decap_3
XFILLER_7_399 VGND VGND VPWR VPWR sky130_fd_sc_hd__decap_3
XFILLER_30_6 VGND VGND VPWR VPWR sky130_fd_sc_hd__decap_3
XFILLER_78_351 VGND VGND VPWR VPWR sky130_fd_sc_hd__decap_3
XFILLER_38_215 VGND VGND VPWR VPWR sky130_fd_sc_hd__decap_3
XFILLER_78_395 VGND VGND VPWR VPWR sky130_fd_sc_hd__decap_3
XFILLER_93_310 VGND VGND VPWR VPWR sky130_fd_sc_hd__decap_3
XFILLER_19_440 VGND VGND VPWR VPWR sky130_fd_sc_hd__decap_3
XFILLER_81_505 VGND VGND VPWR VPWR sky130_fd_sc_hd__fill_1
XFILLER_93_343 VGND VGND VPWR VPWR sky130_fd_sc_hd__decap_3
XFILLER_19_484 VGND VGND VPWR VPWR sky130_fd_sc_hd__decap_3
XFILLER_81_527 VGND VGND VPWR VPWR sky130_fd_sc_hd__decap_3
XFILLER_93_376 VGND VGND VPWR VPWR sky130_fd_sc_hd__decap_3
XTAP_TAPCELL_ROW_109_1672 VGND VPWR sky130_fd_sc_hd__tapvpwrvgnd_1
X_5910_ _5521_/X _5515_/B _6421_/S VGND VGND VPWR VPWR _5910_/X sky130_fd_sc_hd__mux2_2
XFILLER_34_421 VGND VGND VPWR VPWR sky130_fd_sc_hd__decap_3
XFILLER_46_270 VGND VGND VPWR VPWR sky130_fd_sc_hd__decap_3
XFILLER_46_292 VGND VGND VPWR VPWR sky130_fd_sc_hd__fill_2
X_6890_ _6889_/X _6816_/X _6741_/X _6676_/X _7812_/A _7670_/A VGND VGND VPWR VPWR
+ _6890_/X sky130_fd_sc_hd__mux4_2
XFILLER_61_262 VGND VGND VPWR VPWR sky130_fd_sc_hd__decap_3
X_5841_ _5876_/A _5841_/B VGND VGND VPWR VPWR _5841_/Y sky130_fd_sc_hd__xnor2_2
XFILLER_61_284 VGND VGND VPWR VPWR sky130_fd_sc_hd__fill_2
XFILLER_61_295 VGND VGND VPWR VPWR sky130_fd_sc_hd__decap_3
X_5772_ _5728_/Y _5730_/Y _7610_/B _7613_/B _7783_/B _7776_/B VGND VGND VPWR VPWR
+ _5788_/C sky130_fd_sc_hd__mux4_2
XFILLER_21_148 VGND VGND VPWR VPWR sky130_fd_sc_hd__decap_3
X_7511_ _7640_/A1 _7494_/X _7497_/Y _6220_/A _7510_/X VGND VGND VPWR VPWR _7512_/B
+ sky130_fd_sc_hd__a221o_2
X_4723_ _8222_/Q VGND VGND VPWR VPWR _5951_/A sky130_fd_sc_hd__inv_2
XFILLER_30_660 VGND VGND VPWR VPWR sky130_fd_sc_hd__decap_3
X_7442_ _8217_/Q _7442_/B VGND VGND VPWR VPWR _7442_/Y sky130_fd_sc_hd__nor2_2
XTAP_TAPCELL_ROW_32_677 VGND VPWR sky130_fd_sc_hd__tapvpwrvgnd_1
X_4654_ _7930_/B _8131_/Q VGND VGND VPWR VPWR _4655_/A sky130_fd_sc_hd__and2_2
XFILLER_116_710 VGND VGND VPWR VPWR sky130_fd_sc_hd__decap_3
X_7373_ _8214_/Q _8278_/Q _7338_/X _8213_/Q _7337_/X VGND VGND VPWR VPWR _7374_/B
+ sky130_fd_sc_hd__o221a_2
Xinput72 operand_b[11] VGND VGND VPWR VPWR _4326_/B sky130_fd_sc_hd__clkdlybuf4s25_1
Xinput61 operand_a[5] VGND VGND VPWR VPWR _4186_/B sky130_fd_sc_hd__clkdlybuf4s25_1
Xinput50 operand_a[4] VGND VGND VPWR VPWR _4184_/B sky130_fd_sc_hd__clkdlybuf4s25_1
X_4585_ _4585_/A VGND VGND VPWR VPWR _8230_/D sky130_fd_sc_hd__buf_1
XFILLER_115_220 VGND VGND VPWR VPWR sky130_fd_sc_hd__decap_3
XFILLER_115_231 VGND VGND VPWR VPWR sky130_fd_sc_hd__decap_3
XFILLER_89_605 VGND VGND VPWR VPWR sky130_fd_sc_hd__decap_3
Xinput94 operand_b[31] VGND VGND VPWR VPWR _4366_/B sky130_fd_sc_hd__clkdlybuf4s25_1
Xinput83 operand_b[21] VGND VGND VPWR VPWR _4346_/B sky130_fd_sc_hd__clkdlybuf4s25_1
X_6324_ _6323_/X _6013_/X _7745_/A VGND VGND VPWR VPWR _6325_/B sky130_fd_sc_hd__mux2_2
XTAP_TAPCELL_ROW_73_1204 VGND VPWR sky130_fd_sc_hd__tapvpwrvgnd_1
XFILLER_107_37 VGND VGND VPWR VPWR sky130_fd_sc_hd__decap_3
XFILLER_115_264 VGND VGND VPWR VPWR sky130_fd_sc_hd__decap_3
XFILLER_88_115 VGND VGND VPWR VPWR sky130_fd_sc_hd__decap_3
X_6255_ _8246_/Q _6255_/A2 _6254_/X VGND VGND VPWR VPWR _6256_/A sky130_fd_sc_hd__o21ai_4
XFILLER_103_426 VGND VGND VPWR VPWR sky130_fd_sc_hd__decap_3
XFILLER_115_297 VGND VGND VPWR VPWR sky130_fd_sc_hd__decap_3
X_5206_ _8217_/Q _8218_/Q _5484_/S VGND VGND VPWR VPWR _5206_/X sky130_fd_sc_hd__mux2_2
XFILLER_57_502 VGND VGND VPWR VPWR sky130_fd_sc_hd__fill_2
XFILLER_97_671 VGND VGND VPWR VPWR sky130_fd_sc_hd__fill_1
X_6186_ _7732_/B _5399_/X _5718_/X _8245_/Q VGND VGND VPWR VPWR _6186_/X sky130_fd_sc_hd__a2bb2o_2
XTAP_TAPCELL_ROW_4_314 VGND VPWR sky130_fd_sc_hd__tapvpwrvgnd_1
XFILLER_111_481 VGND VGND VPWR VPWR sky130_fd_sc_hd__fill_1
XFILLER_69_384 VGND VGND VPWR VPWR sky130_fd_sc_hd__decap_3
XFILLER_84_321 VGND VGND VPWR VPWR sky130_fd_sc_hd__decap_3
X_5137_ _8218_/Q _8219_/Q _5484_/S VGND VGND VPWR VPWR _5137_/X sky130_fd_sc_hd__mux2_2
XFILLER_29_259 VGND VGND VPWR VPWR sky130_fd_sc_hd__decap_3
XFILLER_57_546 VGND VGND VPWR VPWR sky130_fd_sc_hd__decap_3
XFILLER_57_579 VGND VGND VPWR VPWR sky130_fd_sc_hd__decap_3
XFILLER_84_354 VGND VGND VPWR VPWR sky130_fd_sc_hd__decap_3
XFILLER_96_192 VGND VGND VPWR VPWR sky130_fd_sc_hd__decap_3
X_5068_ _4855_/A _5008_/X _4971_/B _5057_/X _5067_/X VGND VGND VPWR VPWR _5069_/B
+ sky130_fd_sc_hd__o221a_2
XFILLER_44_218 VGND VGND VPWR VPWR sky130_fd_sc_hd__fill_2
XFILLER_72_527 VGND VGND VPWR VPWR sky130_fd_sc_hd__decap_3
X_4019_ _8331_/Q _8357_/Q VGND VGND VPWR VPWR _4021_/C sky130_fd_sc_hd__or2_2
XFILLER_25_432 VGND VGND VPWR VPWR sky130_fd_sc_hd__fill_2
XFILLER_25_443 VGND VGND VPWR VPWR sky130_fd_sc_hd__decap_3
XFILLER_37_270 VGND VGND VPWR VPWR sky130_fd_sc_hd__decap_3
XFILLER_37_281 VGND VGND VPWR VPWR sky130_fd_sc_hd__decap_3
XFILLER_25_465 VGND VGND VPWR VPWR sky130_fd_sc_hd__decap_3
XFILLER_52_262 VGND VGND VPWR VPWR sky130_fd_sc_hd__fill_2
XFILLER_80_560 VGND VGND VPWR VPWR sky130_fd_sc_hd__decap_3
XPHY_EDGE_ROW_0_Right_0 VGND VGND VPWR VPWR sky130_fd_sc_hd__decap_3
XTAP_TAPCELL_ROW_84_1355 VGND VPWR sky130_fd_sc_hd__tapvpwrvgnd_1
XFILLER_12_126 VGND VGND VPWR VPWR sky130_fd_sc_hd__decap_3
XFILLER_40_424 VGND VGND VPWR VPWR sky130_fd_sc_hd__decap_3
XFILLER_52_284 VGND VGND VPWR VPWR sky130_fd_sc_hd__decap_3
XTAP_TAPCELL_ROW_51_920 VGND VPWR sky130_fd_sc_hd__tapvpwrvgnd_1
XFILLER_12_137 VGND VGND VPWR VPWR sky130_fd_sc_hd__decap_3
XFILLER_12_159 VGND VGND VPWR VPWR sky130_fd_sc_hd__decap_3
XFILLER_40_457 VGND VGND VPWR VPWR sky130_fd_sc_hd__decap_3
X_7709_ _5579_/S _5785_/A _7707_/Y _7708_/Y VGND VGND VPWR VPWR _7709_/X sky130_fd_sc_hd__a31o_2
XFILLER_32_44 VGND VGND VPWR VPWR sky130_fd_sc_hd__decap_3
XFILLER_32_88 VGND VGND VPWR VPWR sky130_fd_sc_hd__decap_3
XFILLER_107_732 VGND VGND VPWR VPWR sky130_fd_sc_hd__fill_1
XFILLER_113_3 VGND VGND VPWR VPWR sky130_fd_sc_hd__decap_3
XFILLER_119_581 VGND VGND VPWR VPWR sky130_fd_sc_hd__decap_3
XFILLER_119_592 VGND VGND VPWR VPWR sky130_fd_sc_hd__decap_3
XFILLER_106_242 VGND VGND VPWR VPWR sky130_fd_sc_hd__decap_3
XFILLER_4_336 VGND VGND VPWR VPWR sky130_fd_sc_hd__decap_3
XFILLER_106_253 VGND VGND VPWR VPWR sky130_fd_sc_hd__decap_3
XTAP_TAPCELL_ROW_95_1495 VGND VPWR sky130_fd_sc_hd__tapvpwrvgnd_1
XFILLER_0_553 VGND VGND VPWR VPWR sky130_fd_sc_hd__decap_3
XFILLER_57_30 VGND VGND VPWR VPWR sky130_fd_sc_hd__decap_3
XFILLER_36_708 VGND VGND VPWR VPWR sky130_fd_sc_hd__fill_2
XFILLER_48_557 VGND VGND VPWR VPWR sky130_fd_sc_hd__decap_3
XFILLER_57_63 VGND VGND VPWR VPWR sky130_fd_sc_hd__decap_3
XFILLER_57_74 VGND VGND VPWR VPWR sky130_fd_sc_hd__decap_3
XFILLER_57_96 VGND VGND VPWR VPWR sky130_fd_sc_hd__decap_3
XFILLER_75_332 VGND VGND VPWR VPWR sky130_fd_sc_hd__decap_3
XPHY_EDGE_ROW_82_Left_202 VGND VGND VPWR VPWR sky130_fd_sc_hd__decap_3
XFILLER_63_527 VGND VGND VPWR VPWR sky130_fd_sc_hd__decap_3
XFILLER_75_365 VGND VGND VPWR VPWR sky130_fd_sc_hd__decap_3
XFILLER_75_376 VGND VGND VPWR VPWR sky130_fd_sc_hd__fill_1
XFILLER_113_80 VGND VGND VPWR VPWR sky130_fd_sc_hd__decap_3
XFILLER_16_421 VGND VGND VPWR VPWR sky130_fd_sc_hd__decap_3
XFILLER_63_549 VGND VGND VPWR VPWR sky130_fd_sc_hd__fill_2
XFILLER_90_335 VGND VGND VPWR VPWR sky130_fd_sc_hd__decap_3
XFILLER_16_454 VGND VGND VPWR VPWR sky130_fd_sc_hd__decap_3
XFILLER_16_465 VGND VGND VPWR VPWR sky130_fd_sc_hd__fill_1
XFILLER_73_51 VGND VGND VPWR VPWR sky130_fd_sc_hd__decap_3
XFILLER_90_368 VGND VGND VPWR VPWR sky130_fd_sc_hd__decap_3
XFILLER_31_413 VGND VGND VPWR VPWR sky130_fd_sc_hd__fill_1
XFILLER_31_424 VGND VGND VPWR VPWR sky130_fd_sc_hd__decap_3
XFILLER_43_284 VGND VGND VPWR VPWR sky130_fd_sc_hd__decap_3
XFILLER_71_582 VGND VGND VPWR VPWR sky130_fd_sc_hd__fill_2
XFILLER_31_446 VGND VGND VPWR VPWR sky130_fd_sc_hd__fill_2
XFILLER_31_479 VGND VGND VPWR VPWR sky130_fd_sc_hd__decap_3
XPHY_EDGE_ROW_91_Left_211 VGND VGND VPWR VPWR sky130_fd_sc_hd__decap_3
XFILLER_7_141 VGND VGND VPWR VPWR sky130_fd_sc_hd__fill_2
XFILLER_7_163 VGND VGND VPWR VPWR sky130_fd_sc_hd__decap_3
XFILLER_8_675 VGND VGND VPWR VPWR sky130_fd_sc_hd__decap_3
XFILLER_8_686 VGND VGND VPWR VPWR sky130_fd_sc_hd__decap_3
X_4370_ _7930_/B _4370_/B VGND VGND VPWR VPWR _4371_/A sky130_fd_sc_hd__and2_2
XFILLER_98_402 VGND VGND VPWR VPWR sky130_fd_sc_hd__decap_3
XFILLER_98_468 VGND VGND VPWR VPWR sky130_fd_sc_hd__fill_1
X_6040_ _4923_/X _4931_/X _6039_/B VGND VGND VPWR VPWR _6040_/Y sky130_fd_sc_hd__a21oi_2
XFILLER_66_321 VGND VGND VPWR VPWR sky130_fd_sc_hd__decap_3
XFILLER_79_682 VGND VGND VPWR VPWR sky130_fd_sc_hd__decap_3
XFILLER_94_630 VGND VGND VPWR VPWR sky130_fd_sc_hd__decap_3
XFILLER_66_343 VGND VGND VPWR VPWR sky130_fd_sc_hd__decap_3
XFILLER_78_181 VGND VGND VPWR VPWR sky130_fd_sc_hd__decap_3
XFILLER_54_527 VGND VGND VPWR VPWR sky130_fd_sc_hd__decap_3
XFILLER_66_365 VGND VGND VPWR VPWR sky130_fd_sc_hd__decap_3
XFILLER_66_387 VGND VGND VPWR VPWR sky130_fd_sc_hd__decap_3
XFILLER_81_313 VGND VGND VPWR VPWR sky130_fd_sc_hd__decap_3
XFILLER_94_674 VGND VGND VPWR VPWR sky130_fd_sc_hd__decap_3
X_7991_ _8397_/CLK _7991_/D VGND VGND VPWR VPWR _7991_/Q sky130_fd_sc_hd__dfxtp_2
XFILLER_19_281 VGND VGND VPWR VPWR sky130_fd_sc_hd__decap_3
XFILLER_81_346 VGND VGND VPWR VPWR sky130_fd_sc_hd__decap_3
XFILLER_93_184 VGND VGND VPWR VPWR sky130_fd_sc_hd__decap_3
X_6942_ _8266_/Q _5422_/X _6939_/Y _8290_/Q _6941_/X VGND VGND VPWR VPWR _6955_/A
+ sky130_fd_sc_hd__a221o_2
XTAP_TAPCELL_ROW_37_736 VGND VPWR sky130_fd_sc_hd__tapvpwrvgnd_1
XFILLER_81_379 VGND VGND VPWR VPWR sky130_fd_sc_hd__decap_3
X_6873_ _6873_/A _6958_/A VGND VGND VPWR VPWR _6885_/A sky130_fd_sc_hd__nor2_2
XFILLER_22_413 VGND VGND VPWR VPWR sky130_fd_sc_hd__decap_3
XFILLER_22_424 VGND VGND VPWR VPWR sky130_fd_sc_hd__decap_3
X_5824_ _8223_/Q _5855_/S VGND VGND VPWR VPWR _5824_/Y sky130_fd_sc_hd__nand2_2
XTAP_TAPCELL_ROW_17_482 VGND VPWR sky130_fd_sc_hd__tapvpwrvgnd_1
XFILLER_10_608 VGND VGND VPWR VPWR sky130_fd_sc_hd__decap_3
X_5755_ _8232_/Q _5715_/B _5695_/S VGND VGND VPWR VPWR _5755_/X sky130_fd_sc_hd__o21a_2
X_5686_ _5528_/A _5685_/X _5186_/A VGND VGND VPWR VPWR _5686_/Y sky130_fd_sc_hd__o21ai_2
X_4706_ _7843_/A _8157_/Q VGND VGND VPWR VPWR _4707_/A sky130_fd_sc_hd__and2_2
X_7425_ _8214_/Q _8215_/Q _7425_/C VGND VGND VPWR VPWR _7439_/B sky130_fd_sc_hd__or3_4
X_4637_ _4637_/A VGND VGND VPWR VPWR _8256_/D sky130_fd_sc_hd__buf_1
XFILLER_104_724 VGND VGND VPWR VPWR sky130_fd_sc_hd__fill_1
XFILLER_116_551 VGND VGND VPWR VPWR sky130_fd_sc_hd__fill_1
XFILLER_78_29 VGND VGND VPWR VPWR sky130_fd_sc_hd__decap_3
XFILLER_89_413 VGND VGND VPWR VPWR sky130_fd_sc_hd__decap_3
X_7356_ _7619_/A _7356_/B _8214_/Q VGND VGND VPWR VPWR _7356_/X sky130_fd_sc_hd__or3b_2
X_4568_ _7843_/A _8088_/Q VGND VGND VPWR VPWR _4569_/A sky130_fd_sc_hd__and2_2
XFILLER_103_223 VGND VGND VPWR VPWR sky130_fd_sc_hd__fill_1
XFILLER_103_234 VGND VGND VPWR VPWR sky130_fd_sc_hd__decap_3
XFILLER_116_595 VGND VGND VPWR VPWR sky130_fd_sc_hd__decap_3
X_7287_ _8210_/Q _4783_/B _4789_/A _7225_/A _7225_/B VGND VGND VPWR VPWR _7289_/A
+ sky130_fd_sc_hd__a2111o_2
X_6307_ _6307_/A _6307_/B VGND VGND VPWR VPWR _6307_/Y sky130_fd_sc_hd__xnor2_2
X_4499_ _4499_/A VGND VGND VPWR VPWR _8187_/D sky130_fd_sc_hd__buf_1
XFILLER_103_267 VGND VGND VPWR VPWR sky130_fd_sc_hd__decap_3
XFILLER_89_479 VGND VGND VPWR VPWR sky130_fd_sc_hd__decap_3
X_6238_ _6236_/X _6237_/X _7725_/B VGND VGND VPWR VPWR _6251_/B sky130_fd_sc_hd__mux2_2
XFILLER_103_289 VGND VGND VPWR VPWR sky130_fd_sc_hd__decap_3
X_6169_ _6787_/A _6169_/B VGND VGND VPWR VPWR _6169_/Y sky130_fd_sc_hd__nand2_2
XFILLER_69_181 VGND VGND VPWR VPWR sky130_fd_sc_hd__decap_3
XFILLER_57_387 VGND VGND VPWR VPWR sky130_fd_sc_hd__decap_3
XFILLER_45_538 VGND VGND VPWR VPWR sky130_fd_sc_hd__decap_3
XFILLER_72_324 VGND VGND VPWR VPWR sky130_fd_sc_hd__decap_3
XFILLER_84_184 VGND VGND VPWR VPWR sky130_fd_sc_hd__decap_3
XFILLER_25_251 VGND VGND VPWR VPWR sky130_fd_sc_hd__decap_3
XFILLER_60_508 VGND VGND VPWR VPWR sky130_fd_sc_hd__decap_3
XFILLER_72_368 VGND VGND VPWR VPWR sky130_fd_sc_hd__fill_2
XFILLER_13_435 VGND VGND VPWR VPWR sky130_fd_sc_hd__decap_3
XFILLER_13_468 VGND VGND VPWR VPWR sky130_fd_sc_hd__decap_3
XFILLER_43_54 VGND VGND VPWR VPWR sky130_fd_sc_hd__fill_2
XFILLER_40_276 VGND VGND VPWR VPWR sky130_fd_sc_hd__decap_3
XFILLER_9_428 VGND VGND VPWR VPWR sky130_fd_sc_hd__decap_3
Xclkbuf_leaf_20_clk clkload2/A VGND VGND VPWR VPWR _8402_/CLK sky130_fd_sc_hd__clkbuf_8
XTAP_TAPCELL_ROW_97_1524 VGND VPWR sky130_fd_sc_hd__tapvpwrvgnd_1
XFILLER_5_623 VGND VGND VPWR VPWR sky130_fd_sc_hd__fill_1
XFILLER_4_100 VGND VGND VPWR VPWR sky130_fd_sc_hd__decap_3
XFILLER_5_656 VGND VGND VPWR VPWR sky130_fd_sc_hd__fill_2
Xrebuffer794 _6181_/X VGND VGND VPWR VPWR _6183_/B sky130_fd_sc_hd__buf_2
XFILLER_107_551 VGND VGND VPWR VPWR sky130_fd_sc_hd__fill_2
XFILLER_4_144 VGND VGND VPWR VPWR sky130_fd_sc_hd__decap_3
XFILLER_5_667 VGND VGND VPWR VPWR sky130_fd_sc_hd__decap_3
XFILLER_68_619 VGND VGND VPWR VPWR sky130_fd_sc_hd__fill_2
XFILLER_95_405 VGND VGND VPWR VPWR sky130_fd_sc_hd__decap_3
XFILLER_95_438 VGND VGND VPWR VPWR sky130_fd_sc_hd__decap_3
XFILLER_0_383 VGND VGND VPWR VPWR sky130_fd_sc_hd__decap_3
XFILLER_48_387 VGND VGND VPWR VPWR sky130_fd_sc_hd__decap_3
XFILLER_76_696 VGND VGND VPWR VPWR sky130_fd_sc_hd__decap_3
XFILLER_29_590 VGND VGND VPWR VPWR sky130_fd_sc_hd__decap_3
XFILLER_36_549 VGND VGND VPWR VPWR sky130_fd_sc_hd__decap_3
XFILLER_63_324 VGND VGND VPWR VPWR sky130_fd_sc_hd__decap_3
XFILLER_63_346 VGND VGND VPWR VPWR sky130_fd_sc_hd__decap_3
XFILLER_91_644 VGND VGND VPWR VPWR sky130_fd_sc_hd__decap_3
XFILLER_91_655 VGND VGND VPWR VPWR sky130_fd_sc_hd__decap_3
XFILLER_16_251 VGND VGND VPWR VPWR sky130_fd_sc_hd__fill_1
XFILLER_51_508 VGND VGND VPWR VPWR sky130_fd_sc_hd__decap_3
XFILLER_63_379 VGND VGND VPWR VPWR sky130_fd_sc_hd__decap_3
XFILLER_91_666 VGND VGND VPWR VPWR sky130_fd_sc_hd__decap_3
XTAP_TAPCELL_ROW_106_1631 VGND VPWR sky130_fd_sc_hd__tapvpwrvgnd_1
XTAP_TAPCELL_ROW_106_1642 VGND VPWR sky130_fd_sc_hd__tapvpwrvgnd_1
XTAP_TAPCELL_ROW_34_706 VGND VPWR sky130_fd_sc_hd__tapvpwrvgnd_1
XFILLER_16_262 VGND VGND VPWR VPWR sky130_fd_sc_hd__decap_3
XFILLER_31_243 VGND VGND VPWR VPWR sky130_fd_sc_hd__decap_3
XTAP_TAPCELL_ROW_14_441 VGND VPWR sky130_fd_sc_hd__tapvpwrvgnd_1
XFILLER_31_287 VGND VGND VPWR VPWR sky130_fd_sc_hd__decap_3
XFILLER_76_3 VGND VGND VPWR VPWR sky130_fd_sc_hd__decap_3
Xclkbuf_leaf_11_clk clkload2/A VGND VGND VPWR VPWR _8280_/CLK sky130_fd_sc_hd__clkbuf_8
X_5540_ _7193_/A _5398_/A _5338_/A VGND VGND VPWR VPWR _5540_/Y sky130_fd_sc_hd__o21ai_2
X_5471_ _5135_/X _5139_/X _5579_/S VGND VGND VPWR VPWR _5472_/A sky130_fd_sc_hd__mux2_2
XFILLER_117_337 VGND VGND VPWR VPWR sky130_fd_sc_hd__decap_3
XFILLER_8_483 VGND VGND VPWR VPWR sky130_fd_sc_hd__decap_3
X_7210_ _8272_/Q _7180_/B _8208_/Q VGND VGND VPWR VPWR _7210_/X sky130_fd_sc_hd__a21o_2
X_4422_ _7843_/A _4422_/B VGND VGND VPWR VPWR _4423_/A sky130_fd_sc_hd__and2_2
XTAP_TAPCELL_ROW_117_1782 VGND VPWR sky130_fd_sc_hd__tapvpwrvgnd_1
X_8190_ clkload4/A _8190_/D VGND VGND VPWR VPWR _8190_/Q sky130_fd_sc_hd__dfxtp_2
XFILLER_113_521 VGND VGND VPWR VPWR sky130_fd_sc_hd__fill_1
X_7141_ _8208_/Q _7134_/X _7135_/Y _7136_/X _7140_/X VGND VGND VPWR VPWR _7141_/X
+ sky130_fd_sc_hd__a221o_2
X_4353_ _4353_/A VGND VGND VPWR VPWR _8114_/D sky130_fd_sc_hd__buf_1
XFILLER_113_565 VGND VGND VPWR VPWR sky130_fd_sc_hd__decap_3
X_7072_ _8201_/Q _7072_/B _7072_/C VGND VGND VPWR VPWR _7228_/C sky130_fd_sc_hd__and3_2
X_4284_ _7843_/A _4284_/B VGND VGND VPWR VPWR _4285_/A sky130_fd_sc_hd__and2_2
XFILLER_113_598 VGND VGND VPWR VPWR sky130_fd_sc_hd__decap_3
XFILLER_58_107 VGND VGND VPWR VPWR sky130_fd_sc_hd__decap_3
XFILLER_86_427 VGND VGND VPWR VPWR sky130_fd_sc_hd__decap_3
X_6023_ _6023_/A _6023_/B VGND VGND VPWR VPWR _6027_/A sky130_fd_sc_hd__or2_2
XFILLER_100_259 VGND VGND VPWR VPWR sky130_fd_sc_hd__decap_3
XFILLER_67_652 VGND VGND VPWR VPWR sky130_fd_sc_hd__decap_3
XFILLER_104_38 VGND VGND VPWR VPWR sky130_fd_sc_hd__fill_1
XFILLER_39_354 VGND VGND VPWR VPWR sky130_fd_sc_hd__decap_3
XFILLER_39_376 VGND VGND VPWR VPWR sky130_fd_sc_hd__decap_3
XFILLER_94_471 VGND VGND VPWR VPWR sky130_fd_sc_hd__decap_3
XFILLER_27_538 VGND VGND VPWR VPWR sky130_fd_sc_hd__decap_3
XFILLER_54_324 VGND VGND VPWR VPWR sky130_fd_sc_hd__decap_3
XFILLER_66_195 VGND VGND VPWR VPWR sky130_fd_sc_hd__fill_1
XFILLER_67_696 VGND VGND VPWR VPWR sky130_fd_sc_hd__fill_1
XFILLER_81_110 VGND VGND VPWR VPWR sky130_fd_sc_hd__fill_2
X_7974_ _8382_/CLK _7974_/D VGND VGND VPWR VPWR _7974_/Q sky130_fd_sc_hd__dfxtp_2
XTAP_TAPCELL_ROW_68_1147 VGND VPWR sky130_fd_sc_hd__tapvpwrvgnd_1
XFILLER_54_379 VGND VGND VPWR VPWR sky130_fd_sc_hd__decap_3
XFILLER_82_688 VGND VGND VPWR VPWR sky130_fd_sc_hd__decap_3
X_6925_ _5744_/Y _6923_/Y _6924_/X VGND VGND VPWR VPWR _6925_/Y sky130_fd_sc_hd__a21oi_2
XFILLER_35_582 VGND VGND VPWR VPWR sky130_fd_sc_hd__decap_3
XFILLER_81_187 VGND VGND VPWR VPWR sky130_fd_sc_hd__decap_3
XFILLER_82_699 VGND VGND VPWR VPWR sky130_fd_sc_hd__fill_1
XTAP_TAPCELL_ROW_81_1314 VGND VPWR sky130_fd_sc_hd__tapvpwrvgnd_1
X_6856_ _6148_/A _6856_/A2 _6854_/X _5817_/A _8199_/Q VGND VGND VPWR VPWR _6856_/X
+ sky130_fd_sc_hd__a221o_2
XFILLER_10_405 VGND VGND VPWR VPWR sky130_fd_sc_hd__decap_3
XFILLER_22_265 VGND VGND VPWR VPWR sky130_fd_sc_hd__decap_3
X_6787_ _6787_/A _6787_/B VGND VGND VPWR VPWR _6787_/Y sky130_fd_sc_hd__nand2_2
X_5807_ _8235_/Q _5601_/X wire225/X VGND VGND VPWR VPWR _5807_/Y sky130_fd_sc_hd__o21ai_2
X_3999_ _3999_/A VGND VGND VPWR VPWR _7948_/D sky130_fd_sc_hd__buf_1
XFILLER_10_427 VGND VGND VPWR VPWR sky130_fd_sc_hd__decap_3
XFILLER_22_287 VGND VGND VPWR VPWR sky130_fd_sc_hd__fill_2
XFILLER_22_298 VGND VGND VPWR VPWR sky130_fd_sc_hd__decap_3
X_5738_ _7825_/A _7827_/A VGND VGND VPWR VPWR _6008_/B sky130_fd_sc_hd__nor2_2
XFILLER_108_315 VGND VGND VPWR VPWR sky130_fd_sc_hd__decap_3
X_5669_ _5629_/X _5650_/Y _5668_/X _7898_/B VGND VGND VPWR VPWR _8301_/D sky130_fd_sc_hd__o31a_2
X_7408_ _7407_/B _7407_/C _7407_/A VGND VGND VPWR VPWR _7409_/B sky130_fd_sc_hd__a21oi_2
X_8388_ _8388_/CLK _8388_/D VGND VGND VPWR VPWR _8388_/Q sky130_fd_sc_hd__dfxtp_2
XTAP_TAPCELL_ROW_79_1287 VGND VPWR sky130_fd_sc_hd__tapvpwrvgnd_1
XFILLER_104_521 VGND VGND VPWR VPWR sky130_fd_sc_hd__decap_3
XFILLER_116_392 VGND VGND VPWR VPWR sky130_fd_sc_hd__decap_3
X_7339_ _8213_/Q _7337_/X _7338_/X VGND VGND VPWR VPWR _7340_/B sky130_fd_sc_hd__a21o_4
XTAP_TAPCELL_ROW_92_1454 VGND VPWR sky130_fd_sc_hd__tapvpwrvgnd_1
XFILLER_104_543 VGND VGND VPWR VPWR sky130_fd_sc_hd__fill_2
XFILLER_89_243 VGND VGND VPWR VPWR sky130_fd_sc_hd__fill_2
XFILLER_89_265 VGND VGND VPWR VPWR sky130_fd_sc_hd__decap_3
XFILLER_104_598 VGND VGND VPWR VPWR sky130_fd_sc_hd__decap_3
XFILLER_1_169 VGND VGND VPWR VPWR sky130_fd_sc_hd__fill_2
XFILLER_49_107 VGND VGND VPWR VPWR sky130_fd_sc_hd__decap_3
XFILLER_89_298 VGND VGND VPWR VPWR sky130_fd_sc_hd__decap_3
XFILLER_38_32 VGND VGND VPWR VPWR sky130_fd_sc_hd__decap_3
XFILLER_77_449 VGND VGND VPWR VPWR sky130_fd_sc_hd__decap_3
XFILLER_18_516 VGND VGND VPWR VPWR sky130_fd_sc_hd__decap_3
XFILLER_38_76 VGND VGND VPWR VPWR sky130_fd_sc_hd__decap_3
XFILLER_57_140 VGND VGND VPWR VPWR sky130_fd_sc_hd__decap_3
XFILLER_73_600 VGND VGND VPWR VPWR sky130_fd_sc_hd__decap_3
XFILLER_92_419 VGND VGND VPWR VPWR sky130_fd_sc_hd__fill_1
XFILLER_18_527 VGND VGND VPWR VPWR sky130_fd_sc_hd__decap_3
XFILLER_57_184 VGND VGND VPWR VPWR sky130_fd_sc_hd__fill_2
XFILLER_73_633 VGND VGND VPWR VPWR sky130_fd_sc_hd__decap_3
XFILLER_33_508 VGND VGND VPWR VPWR sky130_fd_sc_hd__decap_3
XFILLER_54_53 VGND VGND VPWR VPWR sky130_fd_sc_hd__decap_3
XFILLER_72_187 VGND VGND VPWR VPWR sky130_fd_sc_hd__decap_3
XFILLER_13_221 VGND VGND VPWR VPWR sky130_fd_sc_hd__decap_3
XFILLER_13_265 VGND VGND VPWR VPWR sky130_fd_sc_hd__decap_3
XFILLER_9_225 VGND VGND VPWR VPWR sky130_fd_sc_hd__fill_1
XFILLER_110_81 VGND VGND VPWR VPWR sky130_fd_sc_hd__decap_3
XFILLER_70_41 VGND VGND VPWR VPWR sky130_fd_sc_hd__decap_3
XFILLER_9_247 VGND VGND VPWR VPWR sky130_fd_sc_hd__decap_3
XTAP_TAPCELL_ROW_101_1572 VGND VPWR sky130_fd_sc_hd__tapvpwrvgnd_1
XTAP_TAPCELL_ROW_11_400 VGND VPWR sky130_fd_sc_hd__tapvpwrvgnd_1
XFILLER_70_74 VGND VGND VPWR VPWR sky130_fd_sc_hd__decap_3
Xclkload17 _8287_/CLK VGND VGND VPWR VPWR clkload17/Y sky130_fd_sc_hd__clkinv_2
Xclkload28 _8379_/CLK VGND VGND VPWR VPWR clkload28/X sky130_fd_sc_hd__clkbuf_4
XFILLER_5_442 VGND VGND VPWR VPWR sky130_fd_sc_hd__decap_3
XFILLER_5_464 VGND VGND VPWR VPWR sky130_fd_sc_hd__fill_2
XFILLER_107_381 VGND VGND VPWR VPWR sky130_fd_sc_hd__decap_3
XFILLER_79_83 VGND VGND VPWR VPWR sky130_fd_sc_hd__fill_1
XFILLER_79_94 VGND VGND VPWR VPWR sky130_fd_sc_hd__decap_3
XFILLER_110_524 VGND VGND VPWR VPWR sky130_fd_sc_hd__decap_3
XFILLER_1_670 VGND VGND VPWR VPWR sky130_fd_sc_hd__fill_2
XFILLER_68_427 VGND VGND VPWR VPWR sky130_fd_sc_hd__decap_3
XFILLER_95_213 VGND VGND VPWR VPWR sky130_fd_sc_hd__decap_3
XFILLER_49_652 VGND VGND VPWR VPWR sky130_fd_sc_hd__decap_3
XFILLER_95_257 VGND VGND VPWR VPWR sky130_fd_sc_hd__decap_3
XFILLER_110_568 VGND VGND VPWR VPWR sky130_fd_sc_hd__decap_3
XFILLER_76_471 VGND VGND VPWR VPWR sky130_fd_sc_hd__decap_3
XFILLER_95_60 VGND VGND VPWR VPWR sky130_fd_sc_hd__decap_3
XFILLER_95_93 VGND VGND VPWR VPWR sky130_fd_sc_hd__decap_3
Xclkbuf_leaf_0_clk clkload0/A VGND VGND VPWR VPWR clkload3/A sky130_fd_sc_hd__clkbuf_8
XFILLER_36_324 VGND VGND VPWR VPWR sky130_fd_sc_hd__decap_3
XFILLER_63_110 VGND VGND VPWR VPWR sky130_fd_sc_hd__fill_2
XFILLER_64_633 VGND VGND VPWR VPWR sky130_fd_sc_hd__decap_3
XTAP_TAPCELL_ROW_19_511 VGND VPWR sky130_fd_sc_hd__tapvpwrvgnd_1
XTAP_TAPCELL_ROW_19_500 VGND VPWR sky130_fd_sc_hd__tapvpwrvgnd_1
XFILLER_36_368 VGND VGND VPWR VPWR sky130_fd_sc_hd__decap_3
XFILLER_63_143 VGND VGND VPWR VPWR sky130_fd_sc_hd__decap_3
XFILLER_91_452 VGND VGND VPWR VPWR sky130_fd_sc_hd__decap_3
XTAP_TAPCELL_ROW_47_875 VGND VPWR sky130_fd_sc_hd__tapvpwrvgnd_1
XTAP_TAPCELL_ROW_47_864 VGND VPWR sky130_fd_sc_hd__tapvpwrvgnd_1
XFILLER_51_305 VGND VGND VPWR VPWR sky130_fd_sc_hd__decap_3
XFILLER_51_316 VGND VGND VPWR VPWR sky130_fd_sc_hd__decap_3
XFILLER_64_699 VGND VGND VPWR VPWR sky130_fd_sc_hd__fill_1
XFILLER_91_485 VGND VGND VPWR VPWR sky130_fd_sc_hd__decap_3
X_4971_ _5069_/A _4971_/B _4971_/C _4971_/D VGND VGND VPWR VPWR _4972_/B sky130_fd_sc_hd__or4_4
XFILLER_63_198 VGND VGND VPWR VPWR sky130_fd_sc_hd__decap_3
X_7690_ _8191_/Q _7663_/B _7660_/X VGND VGND VPWR VPWR _7690_/Y sky130_fd_sc_hd__o21ai_2
X_6710_ _6109_/A _6130_/C _6641_/C _6709_/X VGND VGND VPWR VPWR _6710_/X sky130_fd_sc_hd__a31o_2
XFILLER_32_585 VGND VGND VPWR VPWR sky130_fd_sc_hd__decap_3
X_6641_ _7193_/A _7626_/A _6641_/C VGND VGND VPWR VPWR _6641_/X sky130_fd_sc_hd__and3_2
XTAP_TAPCELL_ROW_63_1077 VGND VPWR sky130_fd_sc_hd__tapvpwrvgnd_1
XTAP_TAPCELL_ROW_119_1800 VGND VPWR sky130_fd_sc_hd__tapvpwrvgnd_1
XTAP_TAPCELL_ROW_119_1811 VGND VPWR sky130_fd_sc_hd__tapvpwrvgnd_1
XTAP_TAPCELL_ROW_119_1822 VGND VPWR sky130_fd_sc_hd__tapvpwrvgnd_1
X_8311_ _8380_/CLK _8311_/D VGND VGND VPWR VPWR _8311_/Q sky130_fd_sc_hd__dfxtp_2
X_6572_ _8191_/Q _8190_/Q _6712_/B _8188_/Q _6380_/S _5452_/S VGND VGND VPWR VPWR
+ _6572_/X sky130_fd_sc_hd__mux4_2
X_5523_ _6277_/A _5523_/B VGND VGND VPWR VPWR _5523_/Y sky130_fd_sc_hd__nor2_2
XFILLER_117_167 VGND VGND VPWR VPWR sky130_fd_sc_hd__fill_1
X_8242_ _8380_/CLK _8242_/D VGND VGND VPWR VPWR _8242_/Q sky130_fd_sc_hd__dfxtp_2
X_5454_ _5450_/X _5453_/X _6421_/S VGND VGND VPWR VPWR _5454_/X sky130_fd_sc_hd__mux2_2
XFILLER_105_329 VGND VGND VPWR VPWR sky130_fd_sc_hd__decap_3
X_8173_ _8360_/CLK _8173_/D VGND VGND VPWR VPWR _8173_/Q sky130_fd_sc_hd__dfxtp_2
X_5385_ _5382_/X _5384_/X _5596_/S VGND VGND VPWR VPWR _5385_/X sky130_fd_sc_hd__mux2_2
X_4405_ _4405_/A VGND VGND VPWR VPWR _8140_/D sky130_fd_sc_hd__buf_1
XFILLER_113_340 VGND VGND VPWR VPWR sky130_fd_sc_hd__decap_3
XFILLER_99_552 VGND VGND VPWR VPWR sky130_fd_sc_hd__decap_3
X_7124_ _7123_/X _7059_/X _7019_/X _6949_/X _7812_/A _7670_/A VGND VGND VPWR VPWR
+ _7124_/X sky130_fd_sc_hd__mux4_2
X_4336_ _7898_/B _4336_/B VGND VGND VPWR VPWR _4337_/A sky130_fd_sc_hd__and2_2
XFILLER_113_373 VGND VGND VPWR VPWR sky130_fd_sc_hd__decap_3
XFILLER_115_15 VGND VGND VPWR VPWR sky130_fd_sc_hd__decap_3
XFILLER_59_405 VGND VGND VPWR VPWR sky130_fd_sc_hd__decap_3
XFILLER_59_438 VGND VGND VPWR VPWR sky130_fd_sc_hd__decap_3
XFILLER_99_585 VGND VGND VPWR VPWR sky130_fd_sc_hd__decap_3
XFILLER_101_535 VGND VGND VPWR VPWR sky130_fd_sc_hd__decap_3
XFILLER_115_48 VGND VGND VPWR VPWR sky130_fd_sc_hd__fill_2
XFILLER_59_449 VGND VGND VPWR VPWR sky130_fd_sc_hd__decap_3
XFILLER_86_224 VGND VGND VPWR VPWR sky130_fd_sc_hd__decap_3
X_7055_ _7631_/A _7052_/X _7054_/X VGND VGND VPWR VPWR _7055_/Y sky130_fd_sc_hd__o21ai_2
X_4267_ _4267_/A VGND VGND VPWR VPWR _8071_/D sky130_fd_sc_hd__buf_1
X_6006_ _8239_/Q _5995_/X _6005_/X VGND VGND VPWR VPWR _6007_/B sky130_fd_sc_hd__a21oi_2
X_4198_ _7898_/B input8/X VGND VGND VPWR VPWR _4199_/A sky130_fd_sc_hd__and2_2
XFILLER_27_335 VGND VGND VPWR VPWR sky130_fd_sc_hd__fill_1
XFILLER_39_184 VGND VGND VPWR VPWR sky130_fd_sc_hd__decap_3
XFILLER_54_121 VGND VGND VPWR VPWR sky130_fd_sc_hd__decap_3
XFILLER_55_633 VGND VGND VPWR VPWR sky130_fd_sc_hd__fill_1
XFILLER_82_430 VGND VGND VPWR VPWR sky130_fd_sc_hd__decap_3
XFILLER_15_508 VGND VGND VPWR VPWR sky130_fd_sc_hd__decap_3
XFILLER_27_346 VGND VGND VPWR VPWR sky130_fd_sc_hd__decap_3
XFILLER_82_463 VGND VGND VPWR VPWR sky130_fd_sc_hd__decap_3
XFILLER_27_379 VGND VGND VPWR VPWR sky130_fd_sc_hd__decap_3
XFILLER_54_165 VGND VGND VPWR VPWR sky130_fd_sc_hd__decap_3
X_7957_ _8360_/CLK _7957_/D VGND VGND VPWR VPWR _7957_/Q sky130_fd_sc_hd__dfxtp_2
XFILLER_23_530 VGND VGND VPWR VPWR sky130_fd_sc_hd__decap_3
X_7888_ _8314_/Q _7898_/B VGND VGND VPWR VPWR _7889_/A sky130_fd_sc_hd__and2_2
X_6908_ _7167_/B _6909_/B VGND VGND VPWR VPWR _6910_/B sky130_fd_sc_hd__nand2_2
XFILLER_11_714 VGND VGND VPWR VPWR sky130_fd_sc_hd__decap_3
X_6839_ _8197_/Q _6839_/B VGND VGND VPWR VPWR _6900_/C sky130_fd_sc_hd__or2_2
XFILLER_109_613 VGND VGND VPWR VPWR sky130_fd_sc_hd__decap_3
XFILLER_7_718 VGND VGND VPWR VPWR sky130_fd_sc_hd__decap_3
XFILLER_7_729 VGND VGND VPWR VPWR sky130_fd_sc_hd__decap_3
XFILLER_108_156 VGND VGND VPWR VPWR sky130_fd_sc_hd__decap_3
XFILLER_40_88 VGND VGND VPWR VPWR sky130_fd_sc_hd__decap_3
XFILLER_6_3 VGND VGND VPWR VPWR sky130_fd_sc_hd__fill_2
XFILLER_78_725 VGND VGND VPWR VPWR sky130_fd_sc_hd__decap_3
XFILLER_77_246 VGND VGND VPWR VPWR sky130_fd_sc_hd__decap_3
XFILLER_58_460 VGND VGND VPWR VPWR sky130_fd_sc_hd__decap_3
XFILLER_65_408 VGND VGND VPWR VPWR sky130_fd_sc_hd__decap_3
XFILLER_77_279 VGND VGND VPWR VPWR sky130_fd_sc_hd__fill_1
XFILLER_18_324 VGND VGND VPWR VPWR sky130_fd_sc_hd__fill_1
XFILLER_65_41 VGND VGND VPWR VPWR sky130_fd_sc_hd__decap_3
XFILLER_92_249 VGND VGND VPWR VPWR sky130_fd_sc_hd__decap_3
XFILLER_45_154 VGND VGND VPWR VPWR sky130_fd_sc_hd__fill_2
XFILLER_65_63 VGND VGND VPWR VPWR sky130_fd_sc_hd__decap_3
XFILLER_73_430 VGND VGND VPWR VPWR sky130_fd_sc_hd__decap_3
XFILLER_85_290 VGND VGND VPWR VPWR sky130_fd_sc_hd__decap_3
XFILLER_33_327 VGND VGND VPWR VPWR sky130_fd_sc_hd__decap_3
XFILLER_45_165 VGND VGND VPWR VPWR sky130_fd_sc_hd__decap_3
XFILLER_46_699 VGND VGND VPWR VPWR sky130_fd_sc_hd__fill_1
XFILLER_60_113 VGND VGND VPWR VPWR sky130_fd_sc_hd__decap_3
XFILLER_65_96 VGND VGND VPWR VPWR sky130_fd_sc_hd__decap_3
XFILLER_73_485 VGND VGND VPWR VPWR sky130_fd_sc_hd__decap_3
XTAP_TAPCELL_ROW_103_1601 VGND VPWR sky130_fd_sc_hd__tapvpwrvgnd_1
XFILLER_33_349 VGND VGND VPWR VPWR sky130_fd_sc_hd__decap_3
XFILLER_61_647 VGND VGND VPWR VPWR sky130_fd_sc_hd__fill_2
XTAP_TAPCELL_ROW_44_834 VGND VPWR sky130_fd_sc_hd__tapvpwrvgnd_1
XFILLER_81_40 VGND VGND VPWR VPWR sky130_fd_sc_hd__decap_3
XFILLER_14_585 VGND VGND VPWR VPWR sky130_fd_sc_hd__decap_3
XFILLER_41_371 VGND VGND VPWR VPWR sky130_fd_sc_hd__decap_3
XFILLER_41_393 VGND VGND VPWR VPWR sky130_fd_sc_hd__decap_3
XFILLER_108_690 VGND VGND VPWR VPWR sky130_fd_sc_hd__decap_3
XFILLER_114_104 VGND VGND VPWR VPWR sky130_fd_sc_hd__decap_3
XFILLER_114_115 VGND VGND VPWR VPWR sky130_fd_sc_hd__decap_3
XTAP_TAPCELL_ROW_114_1741 VGND VPWR sky130_fd_sc_hd__tapvpwrvgnd_1
X_5170_ _8190_/Q _8191_/Q _5484_/S VGND VGND VPWR VPWR _5170_/X sky130_fd_sc_hd__mux2_2
XFILLER_96_533 VGND VGND VPWR VPWR sky130_fd_sc_hd__decap_3
X_4121_ _4121_/A VGND VGND VPWR VPWR _7998_/D sky130_fd_sc_hd__buf_1
XFILLER_37_600 VGND VGND VPWR VPWR sky130_fd_sc_hd__fill_2
XFILLER_56_419 VGND VGND VPWR VPWR sky130_fd_sc_hd__fill_1
XFILLER_83_205 VGND VGND VPWR VPWR sky130_fd_sc_hd__decap_3
XFILLER_84_728 VGND VGND VPWR VPWR sky130_fd_sc_hd__decap_3
X_4052_ _7930_/B _8367_/Q VGND VGND VPWR VPWR _4053_/A sky130_fd_sc_hd__and2_2
XFILLER_37_611 VGND VGND VPWR VPWR sky130_fd_sc_hd__decap_3
XFILLER_49_493 VGND VGND VPWR VPWR sky130_fd_sc_hd__decap_3
XFILLER_83_216 VGND VGND VPWR VPWR sky130_fd_sc_hd__decap_3
XFILLER_83_238 VGND VGND VPWR VPWR sky130_fd_sc_hd__decap_3
Xinput4 cmd[2] VGND VGND VPWR VPWR input4/X sky130_fd_sc_hd__clkdlybuf4s25_1
XFILLER_37_666 VGND VGND VPWR VPWR sky130_fd_sc_hd__decap_3
XFILLER_64_452 VGND VGND VPWR VPWR sky130_fd_sc_hd__fill_1
XFILLER_76_290 VGND VGND VPWR VPWR sky130_fd_sc_hd__decap_3
XFILLER_24_305 VGND VGND VPWR VPWR sky130_fd_sc_hd__decap_3
XFILLER_36_187 VGND VGND VPWR VPWR sky130_fd_sc_hd__decap_3
XFILLER_37_688 VGND VGND VPWR VPWR sky130_fd_sc_hd__decap_3
XFILLER_91_260 VGND VGND VPWR VPWR sky130_fd_sc_hd__decap_3
X_7811_ _7812_/A _7807_/X _7810_/X VGND VGND VPWR VPWR _7811_/Y sky130_fd_sc_hd__a21oi_2
Xclkbuf_2_1__f_clk clkbuf_0_clk/X VGND VGND VPWR VPWR clkload1/A sky130_fd_sc_hd__clkbuf_16
XTAP_TAPCELL_ROW_65_1106 VGND VPWR sky130_fd_sc_hd__tapvpwrvgnd_1
XFILLER_101_17 VGND VGND VPWR VPWR sky130_fd_sc_hd__fill_1
XFILLER_51_113 VGND VGND VPWR VPWR sky130_fd_sc_hd__decap_3
XFILLER_51_146 VGND VGND VPWR VPWR sky130_fd_sc_hd__decap_3
X_7742_ _5363_/X _6097_/A _7655_/A _7740_/Y _7741_/X VGND VGND VPWR VPWR _7743_/C
+ sky130_fd_sc_hd__a311o_2
X_4954_ _4954_/A VGND VGND VPWR VPWR _5506_/A sky130_fd_sc_hd__buf_1
XFILLER_20_511 VGND VGND VPWR VPWR sky130_fd_sc_hd__fill_1
XFILLER_32_393 VGND VGND VPWR VPWR sky130_fd_sc_hd__decap_3
X_7673_ _8219_/Q _7680_/B _7672_/X VGND VGND VPWR VPWR _7674_/B sky130_fd_sc_hd__o21ai_2
X_4885_ _8250_/Q VGND VGND VPWR VPWR _4886_/B sky130_fd_sc_hd__inv_2
XTAP_TAPCELL_ROW_22_539 VGND VPWR sky130_fd_sc_hd__tapvpwrvgnd_1
X_6624_ _6624_/A _6642_/A VGND VGND VPWR VPWR _6625_/A sky130_fd_sc_hd__or2_2
X_6555_ _6555_/A _6555_/B _6555_/C VGND VGND VPWR VPWR _6555_/X sky130_fd_sc_hd__or3_4
X_5506_ _5506_/A _5506_/B VGND VGND VPWR VPWR _5506_/Y sky130_fd_sc_hd__xnor2_2
X_8225_ _8226_/CLK _8225_/D VGND VGND VPWR VPWR _8225_/Q sky130_fd_sc_hd__dfxtp_4
X_6486_ _6486_/A _6486_/B VGND VGND VPWR VPWR _6486_/Y sky130_fd_sc_hd__xnor2_2
XTAP_TAPCELL_ROW_76_1246 VGND VPWR sky130_fd_sc_hd__tapvpwrvgnd_1
X_5437_ _4969_/A _5434_/X _5436_/X VGND VGND VPWR VPWR _5437_/X sky130_fd_sc_hd__o21ba_2
XFILLER_59_213 VGND VGND VPWR VPWR sky130_fd_sc_hd__decap_3
XFILLER_86_29 VGND VGND VPWR VPWR sky130_fd_sc_hd__decap_3
XFILLER_87_511 VGND VGND VPWR VPWR sky130_fd_sc_hd__decap_3
X_8156_ _8285_/CLK _8156_/D VGND VGND VPWR VPWR _8156_/Q sky130_fd_sc_hd__dfxtp_2
X_5368_ _5366_/Y _5573_/B _7555_/S VGND VGND VPWR VPWR _5774_/B sky130_fd_sc_hd__mux2_2
XFILLER_87_544 VGND VGND VPWR VPWR sky130_fd_sc_hd__fill_2
XFILLER_99_382 VGND VGND VPWR VPWR sky130_fd_sc_hd__decap_3
XFILLER_99_393 VGND VGND VPWR VPWR sky130_fd_sc_hd__decap_3
X_8087_ _8226_/CLK _8087_/D VGND VGND VPWR VPWR _8087_/Q sky130_fd_sc_hd__dfxtp_2
X_7107_ _7102_/C _7551_/B _7106_/Y _5076_/Y VGND VGND VPWR VPWR _7108_/B sky130_fd_sc_hd__o22a_2
X_5299_ _7562_/A VGND VGND VPWR VPWR _5299_/X sky130_fd_sc_hd__clkbuf_1
X_4319_ _4319_/A VGND VGND VPWR VPWR _8097_/D sky130_fd_sc_hd__buf_1
XFILLER_101_365 VGND VGND VPWR VPWR sky130_fd_sc_hd__decap_3
XFILLER_47_408 VGND VGND VPWR VPWR sky130_fd_sc_hd__decap_3
XFILLER_59_268 VGND VGND VPWR VPWR sky130_fd_sc_hd__decap_3
X_7038_ _7037_/X _6920_/X _7670_/A VGND VGND VPWR VPWR _7038_/X sky130_fd_sc_hd__mux2_2
XFILLER_27_110 VGND VGND VPWR VPWR sky130_fd_sc_hd__fill_2
XFILLER_74_227 VGND VGND VPWR VPWR sky130_fd_sc_hd__decap_3
XFILLER_15_327 VGND VGND VPWR VPWR sky130_fd_sc_hd__decap_3
XFILLER_27_154 VGND VGND VPWR VPWR sky130_fd_sc_hd__decap_3
XFILLER_55_474 VGND VGND VPWR VPWR sky130_fd_sc_hd__fill_1
XTAP_TAPCELL_ROW_87_1386 VGND VPWR sky130_fd_sc_hd__tapvpwrvgnd_1
XTAP_TAPCELL_ROW_2_286 VGND VPWR sky130_fd_sc_hd__tapvpwrvgnd_1
XFILLER_35_44 VGND VGND VPWR VPWR sky130_fd_sc_hd__fill_2
XFILLER_42_113 VGND VGND VPWR VPWR sky130_fd_sc_hd__decap_3
XFILLER_35_88 VGND VGND VPWR VPWR sky130_fd_sc_hd__decap_3
XFILLER_42_179 VGND VGND VPWR VPWR sky130_fd_sc_hd__decap_3
XFILLER_23_393 VGND VGND VPWR VPWR sky130_fd_sc_hd__decap_3
XFILLER_11_544 VGND VGND VPWR VPWR sky130_fd_sc_hd__decap_3
XFILLER_51_54 VGND VGND VPWR VPWR sky130_fd_sc_hd__fill_2
XFILLER_7_526 VGND VGND VPWR VPWR sky130_fd_sc_hd__decap_3
XFILLER_109_443 VGND VGND VPWR VPWR sky130_fd_sc_hd__decap_3
XFILLER_109_465 VGND VGND VPWR VPWR sky130_fd_sc_hd__decap_3
XFILLER_7_559 VGND VGND VPWR VPWR sky130_fd_sc_hd__fill_1
XFILLER_2_220 VGND VGND VPWR VPWR sky130_fd_sc_hd__fill_1
XFILLER_3_732 VGND VGND VPWR VPWR sky130_fd_sc_hd__fill_1
XFILLER_111_107 VGND VGND VPWR VPWR sky130_fd_sc_hd__decap_3
XFILLER_2_253 VGND VGND VPWR VPWR sky130_fd_sc_hd__decap_3
XFILLER_105_693 VGND VGND VPWR VPWR sky130_fd_sc_hd__decap_3
XFILLER_111_129 VGND VGND VPWR VPWR sky130_fd_sc_hd__fill_1
XFILLER_78_533 VGND VGND VPWR VPWR sky130_fd_sc_hd__decap_3
XFILLER_78_555 VGND VGND VPWR VPWR sky130_fd_sc_hd__decap_3
XFILLER_116_91 VGND VGND VPWR VPWR sky130_fd_sc_hd__decap_3
XFILLER_19_600 VGND VGND VPWR VPWR sky130_fd_sc_hd__decap_3
XFILLER_93_514 VGND VGND VPWR VPWR sky130_fd_sc_hd__decap_3
XFILLER_93_547 VGND VGND VPWR VPWR sky130_fd_sc_hd__decap_3
Xclone325 _6355_/A VGND VGND VPWR VPWR _6818_/S sky130_fd_sc_hd__clkbuf_16
XFILLER_19_666 VGND VGND VPWR VPWR sky130_fd_sc_hd__decap_3
XFILLER_46_430 VGND VGND VPWR VPWR sky130_fd_sc_hd__decap_3
XFILLER_18_165 VGND VGND VPWR VPWR sky130_fd_sc_hd__decap_3
XFILLER_19_688 VGND VGND VPWR VPWR sky130_fd_sc_hd__fill_1
XFILLER_46_463 VGND VGND VPWR VPWR sky130_fd_sc_hd__decap_3
XFILLER_61_411 VGND VGND VPWR VPWR sky130_fd_sc_hd__decap_3
XFILLER_73_260 VGND VGND VPWR VPWR sky130_fd_sc_hd__fill_2
XFILLER_33_113 VGND VGND VPWR VPWR sky130_fd_sc_hd__decap_3
XFILLER_61_444 VGND VGND VPWR VPWR sky130_fd_sc_hd__decap_3
XFILLER_33_146 VGND VGND VPWR VPWR sky130_fd_sc_hd__fill_1
XFILLER_61_455 VGND VGND VPWR VPWR sky130_fd_sc_hd__decap_3
XFILLER_61_488 VGND VGND VPWR VPWR sky130_fd_sc_hd__decap_3
XFILLER_92_94 VGND VGND VPWR VPWR sky130_fd_sc_hd__decap_3
XFILLER_41_190 VGND VGND VPWR VPWR sky130_fd_sc_hd__decap_3
X_4670_ _7930_/B _8139_/Q VGND VGND VPWR VPWR _4671_/A sky130_fd_sc_hd__and2_2
XTAP_TAPCELL_ROW_60_1036 VGND VPWR sky130_fd_sc_hd__tapvpwrvgnd_1
X_6340_ _8249_/Q _5718_/X _5601_/X _8185_/Q VGND VGND VPWR VPWR _6340_/X sky130_fd_sc_hd__o2bb2a_2
XFILLER_115_413 VGND VGND VPWR VPWR sky130_fd_sc_hd__decap_3
XFILLER_103_608 VGND VGND VPWR VPWR sky130_fd_sc_hd__decap_3
X_6271_ _6353_/A _6355_/A VGND VGND VPWR VPWR _6426_/B sky130_fd_sc_hd__or2_2
XFILLER_69_500 VGND VGND VPWR VPWR sky130_fd_sc_hd__decap_3
XFILLER_69_511 VGND VGND VPWR VPWR sky130_fd_sc_hd__decap_3
XPHY_EDGE_ROW_102_Left_222 VGND VGND VPWR VPWR sky130_fd_sc_hd__decap_3
X_8010_ _8349_/CLK _8010_/D VGND VGND VPWR VPWR _8010_/Q sky130_fd_sc_hd__dfxtp_2
X_5222_ _8195_/Q _8196_/Q _6380_/S VGND VGND VPWR VPWR _5222_/X sky130_fd_sc_hd__mux2_2
XFILLER_69_544 VGND VGND VPWR VPWR sky130_fd_sc_hd__decap_3
X_5153_ _8200_/Q _8201_/Q _5484_/S VGND VGND VPWR VPWR _5153_/X sky130_fd_sc_hd__mux2_2
XFILLER_111_663 VGND VGND VPWR VPWR sky130_fd_sc_hd__decap_3
XFILLER_29_408 VGND VGND VPWR VPWR sky130_fd_sc_hd__decap_3
XFILLER_96_363 VGND VGND VPWR VPWR sky130_fd_sc_hd__fill_1
X_4104_ _7930_/B _8393_/Q VGND VGND VPWR VPWR _4105_/A sky130_fd_sc_hd__and2_2
XTAP_TAPCELL_ROW_71_1187 VGND VPWR sky130_fd_sc_hd__tapvpwrvgnd_1
XTAP_TAPCELL_ROW_71_1176 VGND VPWR sky130_fd_sc_hd__tapvpwrvgnd_1
XFILLER_56_227 VGND VGND VPWR VPWR sky130_fd_sc_hd__decap_3
XFILLER_84_536 VGND VGND VPWR VPWR sky130_fd_sc_hd__decap_3
XFILLER_96_374 VGND VGND VPWR VPWR sky130_fd_sc_hd__decap_3
X_5084_ _7619_/A _7631_/B VGND VGND VPWR VPWR _7617_/A sky130_fd_sc_hd__nand2_2
XFILLER_37_430 VGND VGND VPWR VPWR sky130_fd_sc_hd__decap_3
XFILLER_37_452 VGND VGND VPWR VPWR sky130_fd_sc_hd__decap_3
XFILLER_49_290 VGND VGND VPWR VPWR sky130_fd_sc_hd__decap_3
XFILLER_84_569 VGND VGND VPWR VPWR sky130_fd_sc_hd__decap_3
X_4035_ _4035_/A VGND VGND VPWR VPWR _7955_/D sky130_fd_sc_hd__buf_1
XTAP_TAPCELL_ROW_27_609 VGND VPWR sky130_fd_sc_hd__tapvpwrvgnd_1
XFILLER_64_282 VGND VGND VPWR VPWR sky130_fd_sc_hd__decap_3
XFILLER_92_580 VGND VGND VPWR VPWR sky130_fd_sc_hd__decap_3
XFILLER_24_168 VGND VGND VPWR VPWR sky130_fd_sc_hd__decap_3
XFILLER_40_617 VGND VGND VPWR VPWR sky130_fd_sc_hd__fill_2
XFILLER_52_477 VGND VGND VPWR VPWR sky130_fd_sc_hd__decap_3
XPHY_EDGE_ROW_111_Left_231 VGND VGND VPWR VPWR sky130_fd_sc_hd__decap_3
X_5986_ _5985_/X _5631_/X _6321_/B VGND VGND VPWR VPWR _5987_/B sky130_fd_sc_hd__mux2_2
X_7725_ _7796_/A _7725_/B VGND VGND VPWR VPWR _7725_/Y sky130_fd_sc_hd__nand2_2
X_4937_ _8170_/Q _8234_/Q VGND VGND VPWR VPWR _5027_/B sky130_fd_sc_hd__and2b_2
XANTENNA_20 _6555_/A VGND VGND VPWR VPWR sky130_fd_sc_hd__diode_2
XANTENNA_31 _8209_/Q VGND VGND VPWR VPWR sky130_fd_sc_hd__diode_2
XFILLER_20_330 VGND VGND VPWR VPWR sky130_fd_sc_hd__decap_3
X_7656_ _7805_/A _7656_/B VGND VGND VPWR VPWR _7812_/C sky130_fd_sc_hd__xnor2_2
X_4868_ _4868_/A _4868_/B VGND VGND VPWR VPWR _6792_/C sky130_fd_sc_hd__nor2_4
XFILLER_20_374 VGND VGND VPWR VPWR sky130_fd_sc_hd__decap_3
X_6607_ _6148_/X _6604_/X _6670_/C _7182_/B _8192_/Q VGND VGND VPWR VPWR _6607_/X
+ sky130_fd_sc_hd__a221o_2
X_7587_ _7587_/A _7587_/B _7587_/C _7586_/X VGND VGND VPWR VPWR _7588_/B sky130_fd_sc_hd__or4b_4
X_4799_ _8207_/Q _8271_/Q VGND VGND VPWR VPWR _4801_/A sky130_fd_sc_hd__and2b_2
XFILLER_106_424 VGND VGND VPWR VPWR sky130_fd_sc_hd__decap_3
XFILLER_118_273 VGND VGND VPWR VPWR sky130_fd_sc_hd__fill_2
X_6538_ _6538_/A VGND VGND VPWR VPWR _6538_/Y sky130_fd_sc_hd__inv_2
XFILLER_108_6 VGND VGND VPWR VPWR sky130_fd_sc_hd__decap_3
XFILLER_97_17 VGND VGND VPWR VPWR sky130_fd_sc_hd__decap_3
X_6469_ _8188_/Q _6436_/X _6463_/Y _8289_/Q _6468_/Y VGND VGND VPWR VPWR _6471_/B
+ sky130_fd_sc_hd__a221o_2
XFILLER_79_308 VGND VGND VPWR VPWR sky130_fd_sc_hd__decap_3
X_8208_ _8218_/CLK _8208_/D VGND VGND VPWR VPWR _8208_/Q sky130_fd_sc_hd__dfxtp_2
Xoutput160 _7987_/Q VGND VGND VPWR VPWR result[29] sky130_fd_sc_hd__clkdlybuf4s25_1
X_8139_ _8349_/CLK _8139_/D VGND VGND VPWR VPWR _8139_/Q sky130_fd_sc_hd__dfxtp_2
Xoutput193 _8017_/Q VGND VGND VPWR VPWR result[59] sky130_fd_sc_hd__clkdlybuf4s25_1
Xoutput182 _8007_/Q VGND VGND VPWR VPWR result[49] sky130_fd_sc_hd__clkdlybuf4s25_1
Xoutput171 _7997_/Q VGND VGND VPWR VPWR result[39] sky130_fd_sc_hd__clkdlybuf4s25_1
XTAP_TAPCELL_ROW_7_356 VGND VPWR sky130_fd_sc_hd__tapvpwrvgnd_1
XTAP_TAPCELL_ROW_7_345 VGND VPWR sky130_fd_sc_hd__tapvpwrvgnd_1
XPHY_EDGE_ROW_102_Right_102 VGND VGND VPWR VPWR sky130_fd_sc_hd__decap_3
XFILLER_101_162 VGND VGND VPWR VPWR sky130_fd_sc_hd__decap_3
XTAP_TAPCELL_ROW_89_1415 VGND VPWR sky130_fd_sc_hd__tapvpwrvgnd_1
XFILLER_46_32 VGND VGND VPWR VPWR sky130_fd_sc_hd__decap_3
XFILLER_75_547 VGND VGND VPWR VPWR sky130_fd_sc_hd__decap_3
XFILLER_28_452 VGND VGND VPWR VPWR sky130_fd_sc_hd__decap_3
XFILLER_46_54 VGND VGND VPWR VPWR sky130_fd_sc_hd__decap_3
XFILLER_55_260 VGND VGND VPWR VPWR sky130_fd_sc_hd__decap_3
XFILLER_90_517 VGND VGND VPWR VPWR sky130_fd_sc_hd__decap_3
XFILLER_90_539 VGND VGND VPWR VPWR sky130_fd_sc_hd__decap_3
XFILLER_15_113 VGND VGND VPWR VPWR sky130_fd_sc_hd__fill_2
XFILLER_43_411 VGND VGND VPWR VPWR sky130_fd_sc_hd__decap_3
XFILLER_46_98 VGND VGND VPWR VPWR sky130_fd_sc_hd__decap_3
XFILLER_55_293 VGND VGND VPWR VPWR sky130_fd_sc_hd__decap_3
XFILLER_15_146 VGND VGND VPWR VPWR sky130_fd_sc_hd__decap_3
XFILLER_16_669 VGND VGND VPWR VPWR sky130_fd_sc_hd__decap_3
XFILLER_31_606 VGND VGND VPWR VPWR sky130_fd_sc_hd__fill_1
XFILLER_62_20 VGND VGND VPWR VPWR sky130_fd_sc_hd__decap_3
XFILLER_70_230 VGND VGND VPWR VPWR sky130_fd_sc_hd__decap_3
XTAP_TAPCELL_ROW_54_962 VGND VPWR sky130_fd_sc_hd__tapvpwrvgnd_1
XFILLER_102_93 VGND VGND VPWR VPWR sky130_fd_sc_hd__decap_3
XFILLER_24_691 VGND VGND VPWR VPWR sky130_fd_sc_hd__decap_3
XFILLER_43_499 VGND VGND VPWR VPWR sky130_fd_sc_hd__decap_3
XFILLER_62_53 VGND VGND VPWR VPWR sky130_fd_sc_hd__decap_3
XFILLER_70_274 VGND VGND VPWR VPWR sky130_fd_sc_hd__fill_2
XFILLER_30_138 VGND VGND VPWR VPWR sky130_fd_sc_hd__fill_2
XFILLER_62_75 VGND VGND VPWR VPWR sky130_fd_sc_hd__decap_3
XFILLER_62_97 VGND VGND VPWR VPWR sky130_fd_sc_hd__decap_3
XFILLER_11_363 VGND VGND VPWR VPWR sky130_fd_sc_hd__decap_3
XFILLER_7_26 VGND VGND VPWR VPWR sky130_fd_sc_hd__decap_3
XFILLER_7_323 VGND VGND VPWR VPWR sky130_fd_sc_hd__decap_3
XFILLER_109_240 VGND VGND VPWR VPWR sky130_fd_sc_hd__decap_3
XFILLER_11_396 VGND VGND VPWR VPWR sky130_fd_sc_hd__fill_1
XFILLER_109_284 VGND VGND VPWR VPWR sky130_fd_sc_hd__fill_2
XFILLER_7_389 VGND VGND VPWR VPWR sky130_fd_sc_hd__decap_3
XFILLER_109_295 VGND VGND VPWR VPWR sky130_fd_sc_hd__fill_1
XFILLER_112_416 VGND VGND VPWR VPWR sky130_fd_sc_hd__decap_3
XFILLER_3_551 VGND VGND VPWR VPWR sky130_fd_sc_hd__decap_3
XTAP_TAPCELL_ROW_111_1700 VGND VPWR sky130_fd_sc_hd__tapvpwrvgnd_1
XFILLER_112_449 VGND VGND VPWR VPWR sky130_fd_sc_hd__decap_3
XFILLER_3_595 VGND VGND VPWR VPWR sky130_fd_sc_hd__decap_3
XFILLER_97_127 VGND VGND VPWR VPWR sky130_fd_sc_hd__decap_3
XFILLER_39_706 VGND VGND VPWR VPWR sky130_fd_sc_hd__fill_1
XFILLER_78_330 VGND VGND VPWR VPWR sky130_fd_sc_hd__decap_3
XFILLER_78_363 VGND VGND VPWR VPWR sky130_fd_sc_hd__fill_1
XFILLER_38_227 VGND VGND VPWR VPWR sky130_fd_sc_hd__decap_3
XFILLER_78_374 VGND VGND VPWR VPWR sky130_fd_sc_hd__decap_3
XFILLER_93_322 VGND VGND VPWR VPWR sky130_fd_sc_hd__decap_3
XFILLER_93_355 VGND VGND VPWR VPWR sky130_fd_sc_hd__decap_3
XFILLER_19_452 VGND VGND VPWR VPWR sky130_fd_sc_hd__decap_3
XFILLER_34_400 VGND VGND VPWR VPWR sky130_fd_sc_hd__decap_3
XFILLER_53_208 VGND VGND VPWR VPWR sky130_fd_sc_hd__decap_3
XFILLER_93_388 VGND VGND VPWR VPWR sky130_fd_sc_hd__decap_3
XTAP_TAPCELL_ROW_109_1673 VGND VPWR sky130_fd_sc_hd__tapvpwrvgnd_1
XFILLER_74_580 VGND VGND VPWR VPWR sky130_fd_sc_hd__decap_3
XFILLER_93_399 VGND VGND VPWR VPWR sky130_fd_sc_hd__decap_3
XFILLER_34_477 VGND VGND VPWR VPWR sky130_fd_sc_hd__decap_3
XFILLER_61_241 VGND VGND VPWR VPWR sky130_fd_sc_hd__decap_3
X_5840_ _8235_/Q _5804_/B _5839_/X VGND VGND VPWR VPWR _5841_/B sky130_fd_sc_hd__o21a_2
X_5771_ _6769_/B _5767_/X _5770_/X _7631_/B VGND VGND VPWR VPWR _5788_/B sky130_fd_sc_hd__a2bb2o_2
X_7510_ _7473_/X _8219_/Q _7508_/X _7509_/X VGND VGND VPWR VPWR _7510_/X sky130_fd_sc_hd__a211o_4
X_4722_ _8222_/Q _4722_/B VGND VGND VPWR VPWR _7649_/A sky130_fd_sc_hd__nand2_2
XFILLER_30_672 VGND VGND VPWR VPWR sky130_fd_sc_hd__decap_3
X_7441_ _5319_/A _7472_/B _7441_/B1 _6717_/A VGND VGND VPWR VPWR _7442_/B sky130_fd_sc_hd__o2bb2a_2
XTAP_TAPCELL_ROW_32_678 VGND VPWR sky130_fd_sc_hd__tapvpwrvgnd_1
Xinput40 operand_a[40] VGND VGND VPWR VPWR _4256_/B sky130_fd_sc_hd__clkdlybuf4s25_1
X_4653_ _4653_/A VGND VGND VPWR VPWR _8264_/D sky130_fd_sc_hd__buf_1
X_7372_ _7372_/A _7372_/B VGND VGND VPWR VPWR _7394_/C sky130_fd_sc_hd__and2_2
Xinput73 operand_b[12] VGND VGND VPWR VPWR _4328_/B sky130_fd_sc_hd__clkdlybuf4s25_1
Xinput62 operand_a[60] VGND VGND VPWR VPWR _4296_/B sky130_fd_sc_hd__clkdlybuf4s25_1
Xinput51 operand_a[50] VGND VGND VPWR VPWR _4276_/B sky130_fd_sc_hd__clkdlybuf4s25_1
X_4584_ _7898_/B _8096_/Q VGND VGND VPWR VPWR _4585_/A sky130_fd_sc_hd__and2_2
Xinput95 operand_b[32] VGND VGND VPWR VPWR _4368_/B sky130_fd_sc_hd__clkdlybuf4s25_1
Xinput84 operand_b[22] VGND VGND VPWR VPWR _4348_/B sky130_fd_sc_hd__clkdlybuf4s25_1
X_6323_ _6322_/X _6239_/X _6165_/X _6104_/X _7812_/A _7670_/A VGND VGND VPWR VPWR
+ _6323_/X sky130_fd_sc_hd__mux4_2
XTAP_TAPCELL_ROW_73_1205 VGND VPWR sky130_fd_sc_hd__tapvpwrvgnd_1
XFILLER_103_405 VGND VGND VPWR VPWR sky130_fd_sc_hd__decap_3
XFILLER_115_243 VGND VGND VPWR VPWR sky130_fd_sc_hd__fill_1
XFILLER_115_276 VGND VGND VPWR VPWR sky130_fd_sc_hd__decap_3
XFILLER_89_617 VGND VGND VPWR VPWR sky130_fd_sc_hd__decap_3
X_6254_ _8246_/Q _6218_/X _7725_/B VGND VGND VPWR VPWR _6254_/X sky130_fd_sc_hd__a21o_4
XFILLER_103_438 VGND VGND VPWR VPWR sky130_fd_sc_hd__decap_3
XFILLER_103_449 VGND VGND VPWR VPWR sky130_fd_sc_hd__decap_3
XFILLER_115_287 VGND VGND VPWR VPWR sky130_fd_sc_hd__decap_3
XFILLER_88_127 VGND VGND VPWR VPWR sky130_fd_sc_hd__decap_3
X_5205_ _8219_/Q _8220_/Q _5484_/S VGND VGND VPWR VPWR _5205_/X sky130_fd_sc_hd__mux2_2
XFILLER_69_352 VGND VGND VPWR VPWR sky130_fd_sc_hd__decap_3
XFILLER_97_650 VGND VGND VPWR VPWR sky130_fd_sc_hd__decap_3
X_6185_ _6179_/X _6184_/X _7844_/A VGND VGND VPWR VPWR _8314_/D sky130_fd_sc_hd__a21oi_2
XTAP_TAPCELL_ROW_4_315 VGND VPWR sky130_fd_sc_hd__tapvpwrvgnd_1
XFILLER_69_396 VGND VGND VPWR VPWR sky130_fd_sc_hd__decap_3
XFILLER_96_171 VGND VGND VPWR VPWR sky130_fd_sc_hd__decap_3
X_5136_ _5131_/X _5135_/X _5596_/S VGND VGND VPWR VPWR _5136_/X sky130_fd_sc_hd__mux2_2
XFILLER_57_558 VGND VGND VPWR VPWR sky130_fd_sc_hd__fill_2
XFILLER_84_333 VGND VGND VPWR VPWR sky130_fd_sc_hd__decap_3
X_5067_ _4801_/A _5061_/Y _5066_/Y _4824_/A VGND VGND VPWR VPWR _5067_/X sky130_fd_sc_hd__o22a_2
XFILLER_84_377 VGND VGND VPWR VPWR sky130_fd_sc_hd__fill_2
X_4018_ _7930_/B VGND VGND VPWR VPWR _4719_/A sky130_fd_sc_hd__inv_2
XFILLER_25_422 VGND VGND VPWR VPWR sky130_fd_sc_hd__fill_2
XFILLER_72_539 VGND VGND VPWR VPWR sky130_fd_sc_hd__decap_3
XFILLER_13_617 VGND VGND VPWR VPWR sky130_fd_sc_hd__decap_3
XFILLER_16_46 VGND VGND VPWR VPWR sky130_fd_sc_hd__fill_2
XFILLER_16_68 VGND VGND VPWR VPWR sky130_fd_sc_hd__fill_2
XFILLER_52_241 VGND VGND VPWR VPWR sky130_fd_sc_hd__decap_3
XTAP_TAPCELL_ROW_84_1356 VGND VPWR sky130_fd_sc_hd__tapvpwrvgnd_1
XTAP_TAPCELL_ROW_84_1345 VGND VPWR sky130_fd_sc_hd__tapvpwrvgnd_1
XFILLER_13_639 VGND VGND VPWR VPWR sky130_fd_sc_hd__decap_3
XFILLER_16_79 VGND VGND VPWR VPWR sky130_fd_sc_hd__decap_3
XFILLER_25_477 VGND VGND VPWR VPWR sky130_fd_sc_hd__fill_2
XFILLER_25_499 VGND VGND VPWR VPWR sky130_fd_sc_hd__decap_3
XFILLER_40_403 VGND VGND VPWR VPWR sky130_fd_sc_hd__decap_3
XFILLER_40_436 VGND VGND VPWR VPWR sky130_fd_sc_hd__decap_3
X_5969_ _5966_/X _5967_/Y _5968_/X _5965_/A VGND VGND VPWR VPWR _5969_/X sky130_fd_sc_hd__a22o_2
XTAP_TAPCELL_ROW_51_921 VGND VPWR sky130_fd_sc_hd__tapvpwrvgnd_1
XFILLER_40_469 VGND VGND VPWR VPWR sky130_fd_sc_hd__decap_3
X_7708_ _7797_/A1 _8214_/Q _5121_/A _5579_/S VGND VGND VPWR VPWR _7708_/Y sky130_fd_sc_hd__a211oi_2
XFILLER_32_23 VGND VGND VPWR VPWR sky130_fd_sc_hd__decap_3
XFILLER_32_56 VGND VGND VPWR VPWR sky130_fd_sc_hd__decap_3
XFILLER_20_171 VGND VGND VPWR VPWR sky130_fd_sc_hd__decap_3
X_7639_ _7649_/B _7639_/B VGND VGND VPWR VPWR _7639_/Y sky130_fd_sc_hd__nand2_2
XFILLER_4_304 VGND VGND VPWR VPWR sky130_fd_sc_hd__decap_3
XFILLER_4_315 VGND VGND VPWR VPWR sky130_fd_sc_hd__decap_3
XFILLER_106_221 VGND VGND VPWR VPWR sky130_fd_sc_hd__decap_3
XFILLER_106_3 VGND VGND VPWR VPWR sky130_fd_sc_hd__fill_2
XFILLER_4_348 VGND VGND VPWR VPWR sky130_fd_sc_hd__decap_3
XFILLER_106_265 VGND VGND VPWR VPWR sky130_fd_sc_hd__decap_3
XTAP_TAPCELL_ROW_95_1496 VGND VPWR sky130_fd_sc_hd__tapvpwrvgnd_1
XFILLER_0_521 VGND VGND VPWR VPWR sky130_fd_sc_hd__decap_3
XFILLER_106_298 VGND VGND VPWR VPWR sky130_fd_sc_hd__fill_2
XFILLER_0_543 VGND VGND VPWR VPWR sky130_fd_sc_hd__fill_2
XFILLER_48_514 VGND VGND VPWR VPWR sky130_fd_sc_hd__decap_3
XFILLER_48_536 VGND VGND VPWR VPWR sky130_fd_sc_hd__decap_3
XFILLER_57_42 VGND VGND VPWR VPWR sky130_fd_sc_hd__fill_1
XFILLER_57_53 VGND VGND VPWR VPWR sky130_fd_sc_hd__decap_3
XFILLER_88_683 VGND VGND VPWR VPWR sky130_fd_sc_hd__fill_2
XFILLER_48_569 VGND VGND VPWR VPWR sky130_fd_sc_hd__decap_3
XFILLER_75_388 VGND VGND VPWR VPWR sky130_fd_sc_hd__decap_3
XFILLER_90_303 VGND VGND VPWR VPWR sky130_fd_sc_hd__decap_3
XFILLER_16_433 VGND VGND VPWR VPWR sky130_fd_sc_hd__decap_3
XFILLER_28_271 VGND VGND VPWR VPWR sky130_fd_sc_hd__decap_3
XFILLER_44_731 VGND VGND VPWR VPWR sky130_fd_sc_hd__fill_2
XFILLER_75_399 VGND VGND VPWR VPWR sky130_fd_sc_hd__decap_3
XFILLER_71_561 VGND VGND VPWR VPWR sky130_fd_sc_hd__decap_3
XFILLER_71_594 VGND VGND VPWR VPWR sky130_fd_sc_hd__decap_3
XFILLER_43_296 VGND VGND VPWR VPWR sky130_fd_sc_hd__decap_3
XFILLER_12_661 VGND VGND VPWR VPWR sky130_fd_sc_hd__decap_3
XFILLER_11_160 VGND VGND VPWR VPWR sky130_fd_sc_hd__decap_3
XFILLER_8_654 VGND VGND VPWR VPWR sky130_fd_sc_hd__fill_1
XFILLER_8_698 VGND VGND VPWR VPWR sky130_fd_sc_hd__fill_2
XFILLER_7_197 VGND VGND VPWR VPWR sky130_fd_sc_hd__fill_1
XFILLER_98_414 VGND VGND VPWR VPWR sky130_fd_sc_hd__decap_3
XFILLER_98_71 VGND VGND VPWR VPWR sky130_fd_sc_hd__decap_3
XFILLER_112_235 VGND VGND VPWR VPWR sky130_fd_sc_hd__fill_1
XFILLER_86_609 VGND VGND VPWR VPWR sky130_fd_sc_hd__decap_3
XFILLER_98_458 VGND VGND VPWR VPWR sky130_fd_sc_hd__decap_3
XFILLER_100_419 VGND VGND VPWR VPWR sky130_fd_sc_hd__fill_1
XFILLER_39_525 VGND VGND VPWR VPWR sky130_fd_sc_hd__decap_3
XFILLER_66_300 VGND VGND VPWR VPWR sky130_fd_sc_hd__decap_3
XFILLER_78_160 VGND VGND VPWR VPWR sky130_fd_sc_hd__decap_3
XFILLER_85_119 VGND VGND VPWR VPWR sky130_fd_sc_hd__decap_3
XFILLER_39_558 VGND VGND VPWR VPWR sky130_fd_sc_hd__fill_2
XFILLER_39_569 VGND VGND VPWR VPWR sky130_fd_sc_hd__decap_3
XFILLER_94_642 VGND VGND VPWR VPWR sky130_fd_sc_hd__fill_2
XFILLER_94_653 VGND VGND VPWR VPWR sky130_fd_sc_hd__decap_3
XFILLER_94_686 VGND VGND VPWR VPWR sky130_fd_sc_hd__fill_2
XFILLER_94_697 VGND VGND VPWR VPWR sky130_fd_sc_hd__decap_3
X_7990_ _8396_/CLK _7990_/D VGND VGND VPWR VPWR _7990_/Q sky130_fd_sc_hd__dfxtp_2
XFILLER_19_260 VGND VGND VPWR VPWR sky130_fd_sc_hd__decap_3
XFILLER_47_591 VGND VGND VPWR VPWR sky130_fd_sc_hd__decap_3
XFILLER_81_325 VGND VGND VPWR VPWR sky130_fd_sc_hd__decap_3
X_6941_ _8202_/Q _6940_/X _6687_/A VGND VGND VPWR VPWR _6941_/X sky130_fd_sc_hd__a21o_2
XTAP_TAPCELL_ROW_37_737 VGND VPWR sky130_fd_sc_hd__tapvpwrvgnd_1
XFILLER_50_701 VGND VGND VPWR VPWR sky130_fd_sc_hd__decap_3
XFILLER_81_358 VGND VGND VPWR VPWR sky130_fd_sc_hd__decap_3
X_6872_ _6849_/Y _6871_/X _7844_/A VGND VGND VPWR VPWR _8333_/D sky130_fd_sc_hd__a21oi_2
XFILLER_62_572 VGND VGND VPWR VPWR sky130_fd_sc_hd__decap_3
X_5823_ _6421_/S _7623_/S VGND VGND VPWR VPWR _5855_/S sky130_fd_sc_hd__or2_2
XFILLER_34_296 VGND VGND VPWR VPWR sky130_fd_sc_hd__decap_3
XTAP_TAPCELL_ROW_17_483 VGND VPWR sky130_fd_sc_hd__tapvpwrvgnd_1
X_5754_ _6109_/A _5744_/Y _5753_/X VGND VGND VPWR VPWR _5754_/Y sky130_fd_sc_hd__a21oi_2
X_5685_ _5173_/X _5684_/X _5151_/X _5166_/X _6819_/A _7745_/A VGND VGND VPWR VPWR
+ _5685_/X sky130_fd_sc_hd__mux4_2
X_4705_ _4705_/A VGND VGND VPWR VPWR _8290_/D sky130_fd_sc_hd__buf_1
XFILLER_118_15 VGND VGND VPWR VPWR sky130_fd_sc_hd__decap_3
X_7424_ _8214_/Q _8215_/Q _7424_/C VGND VGND VPWR VPWR _7424_/X sky130_fd_sc_hd__and3_2
X_4636_ _7930_/B _8122_/Q VGND VGND VPWR VPWR _4637_/A sky130_fd_sc_hd__and2_2
X_7355_ _8278_/Q _5397_/A _5338_/A VGND VGND VPWR VPWR _7356_/B sky130_fd_sc_hd__o21a_2
X_6306_ _8247_/Q _6259_/B _6305_/X VGND VGND VPWR VPWR _6306_/X sky130_fd_sc_hd__a21o_4
X_4567_ _4567_/A VGND VGND VPWR VPWR _8221_/D sky130_fd_sc_hd__buf_1
XFILLER_103_202 VGND VGND VPWR VPWR sky130_fd_sc_hd__decap_3
XFILLER_89_425 VGND VGND VPWR VPWR sky130_fd_sc_hd__decap_3
X_7286_ _6148_/X _7282_/Y _7344_/C _7182_/B _8212_/Q VGND VGND VPWR VPWR _7286_/X
+ sky130_fd_sc_hd__a221o_2
X_4498_ _7898_/B _8053_/Q VGND VGND VPWR VPWR _4499_/A sky130_fd_sc_hd__and2_2
XFILLER_103_246 VGND VGND VPWR VPWR sky130_fd_sc_hd__decap_3
XFILLER_77_609 VGND VGND VPWR VPWR sky130_fd_sc_hd__fill_2
XFILLER_89_458 VGND VGND VPWR VPWR sky130_fd_sc_hd__decap_3
X_6237_ _6233_/B _7231_/A _7610_/B _6235_/B VGND VGND VPWR VPWR _6237_/X sky130_fd_sc_hd__a2bb2o_2
X_6168_ _5487_/X _5673_/B _6744_/B _6784_/A VGND VGND VPWR VPWR _6169_/B sky130_fd_sc_hd__a22o_2
XFILLER_57_322 VGND VGND VPWR VPWR sky130_fd_sc_hd__fill_1
XFILLER_57_333 VGND VGND VPWR VPWR sky130_fd_sc_hd__decap_3
XFILLER_69_193 VGND VGND VPWR VPWR sky130_fd_sc_hd__decap_3
XFILLER_85_631 VGND VGND VPWR VPWR sky130_fd_sc_hd__decap_3
XFILLER_85_653 VGND VGND VPWR VPWR sky130_fd_sc_hd__decap_3
XFILLER_94_29 VGND VGND VPWR VPWR sky130_fd_sc_hd__decap_3
XFILLER_97_491 VGND VGND VPWR VPWR sky130_fd_sc_hd__decap_3
X_5119_ _6247_/B _5854_/B VGND VGND VPWR VPWR _7670_/B sky130_fd_sc_hd__nand2_2
XFILLER_27_23 VGND VGND VPWR VPWR sky130_fd_sc_hd__decap_3
XFILLER_27_45 VGND VGND VPWR VPWR sky130_fd_sc_hd__decap_3
XFILLER_45_517 VGND VGND VPWR VPWR sky130_fd_sc_hd__decap_3
XFILLER_57_355 VGND VGND VPWR VPWR sky130_fd_sc_hd__decap_3
XFILLER_72_303 VGND VGND VPWR VPWR sky130_fd_sc_hd__decap_3
XFILLER_84_141 VGND VGND VPWR VPWR sky130_fd_sc_hd__fill_2
XFILLER_84_152 VGND VGND VPWR VPWR sky130_fd_sc_hd__decap_3
XFILLER_85_686 VGND VGND VPWR VPWR sky130_fd_sc_hd__decap_3
X_6099_ _6099_/A _6099_/B VGND VGND VPWR VPWR _6099_/Y sky130_fd_sc_hd__nor2_2
XFILLER_27_67 VGND VGND VPWR VPWR sky130_fd_sc_hd__decap_3
XFILLER_57_399 VGND VGND VPWR VPWR sky130_fd_sc_hd__fill_2
XFILLER_72_336 VGND VGND VPWR VPWR sky130_fd_sc_hd__decap_3
XFILLER_84_174 VGND VGND VPWR VPWR sky130_fd_sc_hd__fill_1
XFILLER_25_263 VGND VGND VPWR VPWR sky130_fd_sc_hd__decap_3
XFILLER_40_200 VGND VGND VPWR VPWR sky130_fd_sc_hd__decap_3
XFILLER_53_561 VGND VGND VPWR VPWR sky130_fd_sc_hd__fill_1
XFILLER_53_594 VGND VGND VPWR VPWR sky130_fd_sc_hd__decap_3
XFILLER_13_447 VGND VGND VPWR VPWR sky130_fd_sc_hd__fill_1
XFILLER_13_458 VGND VGND VPWR VPWR sky130_fd_sc_hd__decap_3
XFILLER_40_244 VGND VGND VPWR VPWR sky130_fd_sc_hd__decap_3
XFILLER_43_66 VGND VGND VPWR VPWR sky130_fd_sc_hd__decap_3
XFILLER_40_299 VGND VGND VPWR VPWR sky130_fd_sc_hd__decap_3
XTAP_TAPCELL_ROW_97_1514 VGND VPWR sky130_fd_sc_hd__tapvpwrvgnd_1
XTAP_TAPCELL_ROW_97_1525 VGND VPWR sky130_fd_sc_hd__tapvpwrvgnd_1
XFILLER_4_112 VGND VGND VPWR VPWR sky130_fd_sc_hd__decap_3
Xrebuffer762 rebuffer948/X VGND VGND VPWR VPWR _6483_/A sky130_fd_sc_hd__buf_6
XFILLER_4_167 VGND VGND VPWR VPWR sky130_fd_sc_hd__decap_3
XFILLER_5_679 VGND VGND VPWR VPWR sky130_fd_sc_hd__decap_3
Xrebuffer795 rebuffer947/X VGND VGND VPWR VPWR rebuffer795/X sky130_fd_sc_hd__buf_6
XFILLER_107_585 VGND VGND VPWR VPWR sky130_fd_sc_hd__fill_1
XFILLER_0_340 VGND VGND VPWR VPWR sky130_fd_sc_hd__decap_3
XFILLER_0_351 VGND VGND VPWR VPWR sky130_fd_sc_hd__decap_3
XFILLER_67_119 VGND VGND VPWR VPWR sky130_fd_sc_hd__decap_3
XFILLER_68_85 VGND VGND VPWR VPWR sky130_fd_sc_hd__decap_3
XFILLER_76_620 VGND VGND VPWR VPWR sky130_fd_sc_hd__decap_3
XFILLER_95_417 VGND VGND VPWR VPWR sky130_fd_sc_hd__decap_3
XFILLER_102_290 VGND VGND VPWR VPWR sky130_fd_sc_hd__decap_3
XFILLER_76_653 VGND VGND VPWR VPWR sky130_fd_sc_hd__fill_1
XFILLER_88_480 VGND VGND VPWR VPWR sky130_fd_sc_hd__decap_3
XFILLER_63_303 VGND VGND VPWR VPWR sky130_fd_sc_hd__decap_3
XFILLER_76_675 VGND VGND VPWR VPWR sky130_fd_sc_hd__decap_3
XFILLER_84_40 VGND VGND VPWR VPWR sky130_fd_sc_hd__decap_3
XFILLER_36_528 VGND VGND VPWR VPWR sky130_fd_sc_hd__decap_3
XFILLER_48_399 VGND VGND VPWR VPWR sky130_fd_sc_hd__decap_3
XFILLER_90_111 VGND VGND VPWR VPWR sky130_fd_sc_hd__decap_3
XFILLER_16_230 VGND VGND VPWR VPWR sky130_fd_sc_hd__decap_3
XFILLER_63_358 VGND VGND VPWR VPWR sky130_fd_sc_hd__decap_3
XFILLER_90_155 VGND VGND VPWR VPWR sky130_fd_sc_hd__decap_3
XTAP_TAPCELL_ROW_106_1632 VGND VPWR sky130_fd_sc_hd__tapvpwrvgnd_1
XTAP_TAPCELL_ROW_106_1643 VGND VPWR sky130_fd_sc_hd__tapvpwrvgnd_1
XTAP_TAPCELL_ROW_34_707 VGND VPWR sky130_fd_sc_hd__tapvpwrvgnd_1
XFILLER_32_701 VGND VGND VPWR VPWR sky130_fd_sc_hd__decap_3
XFILLER_31_222 VGND VGND VPWR VPWR sky130_fd_sc_hd__fill_2
XFILLER_71_391 VGND VGND VPWR VPWR sky130_fd_sc_hd__fill_1
XFILLER_31_266 VGND VGND VPWR VPWR sky130_fd_sc_hd__decap_3
XTAP_TAPCELL_ROW_14_442 VGND VPWR sky130_fd_sc_hd__tapvpwrvgnd_1
XFILLER_31_299 VGND VGND VPWR VPWR sky130_fd_sc_hd__fill_2
XFILLER_8_451 VGND VGND VPWR VPWR sky130_fd_sc_hd__fill_1
XFILLER_8_462 VGND VGND VPWR VPWR sky130_fd_sc_hd__decap_3
X_5470_ _6706_/S _6421_/S VGND VGND VPWR VPWR _5470_/X sky130_fd_sc_hd__and2b_2
XFILLER_69_3 VGND VGND VPWR VPWR sky130_fd_sc_hd__fill_2
XFILLER_8_495 VGND VGND VPWR VPWR sky130_fd_sc_hd__decap_3
X_4421_ _4421_/A VGND VGND VPWR VPWR _8148_/D sky130_fd_sc_hd__buf_1
XTAP_TAPCELL_ROW_117_1783 VGND VPWR sky130_fd_sc_hd__tapvpwrvgnd_1
XFILLER_98_200 VGND VGND VPWR VPWR sky130_fd_sc_hd__decap_3
X_7140_ _8272_/Q _5422_/X _7139_/X _8290_/Q _6687_/A VGND VGND VPWR VPWR _7140_/X
+ sky130_fd_sc_hd__a221o_2
X_4352_ _7898_/B _4352_/B VGND VGND VPWR VPWR _4353_/A sky130_fd_sc_hd__and2_2
X_7071_ _8202_/Q _8203_/Q _8204_/Q _8205_/Q VGND VGND VPWR VPWR _7072_/C sky130_fd_sc_hd__and4_2
X_4283_ _4283_/A VGND VGND VPWR VPWR _8079_/D sky130_fd_sc_hd__buf_1
XFILLER_113_577 VGND VGND VPWR VPWR sky130_fd_sc_hd__decap_3
XFILLER_58_119 VGND VGND VPWR VPWR sky130_fd_sc_hd__decap_3
XFILLER_86_439 VGND VGND VPWR VPWR sky130_fd_sc_hd__decap_3
X_6022_ _7767_/B _6022_/B _6022_/C VGND VGND VPWR VPWR _6023_/B sky130_fd_sc_hd__or3_2
XFILLER_100_227 VGND VGND VPWR VPWR sky130_fd_sc_hd__decap_3
XFILLER_39_311 VGND VGND VPWR VPWR sky130_fd_sc_hd__decap_3
XFILLER_39_333 VGND VGND VPWR VPWR sky130_fd_sc_hd__decap_3
XFILLER_67_620 VGND VGND VPWR VPWR sky130_fd_sc_hd__decap_3
XFILLER_39_366 VGND VGND VPWR VPWR sky130_fd_sc_hd__fill_2
XFILLER_54_303 VGND VGND VPWR VPWR sky130_fd_sc_hd__decap_3
XFILLER_66_141 VGND VGND VPWR VPWR sky130_fd_sc_hd__fill_2
XFILLER_82_612 VGND VGND VPWR VPWR sky130_fd_sc_hd__decap_3
XFILLER_39_388 VGND VGND VPWR VPWR sky130_fd_sc_hd__decap_3
XFILLER_39_399 VGND VGND VPWR VPWR sky130_fd_sc_hd__decap_3
XFILLER_66_174 VGND VGND VPWR VPWR sky130_fd_sc_hd__decap_3
XFILLER_81_122 VGND VGND VPWR VPWR sky130_fd_sc_hd__decap_3
XFILLER_82_645 VGND VGND VPWR VPWR sky130_fd_sc_hd__decap_3
X_7973_ _8380_/CLK _7973_/D VGND VGND VPWR VPWR _7973_/Q sky130_fd_sc_hd__dfxtp_2
XTAP_TAPCELL_ROW_68_1137 VGND VPWR sky130_fd_sc_hd__tapvpwrvgnd_1
XFILLER_54_347 VGND VGND VPWR VPWR sky130_fd_sc_hd__decap_3
X_6924_ _5832_/A _5750_/X _5528_/A VGND VGND VPWR VPWR _6924_/X sky130_fd_sc_hd__o21a_2
XTAP_TAPCELL_ROW_68_1148 VGND VPWR sky130_fd_sc_hd__tapvpwrvgnd_1
XFILLER_22_200 VGND VGND VPWR VPWR sky130_fd_sc_hd__decap_3
XFILLER_35_561 VGND VGND VPWR VPWR sky130_fd_sc_hd__decap_3
XTAP_TAPCELL_ROW_81_1315 VGND VPWR sky130_fd_sc_hd__tapvpwrvgnd_1
XFILLER_22_222 VGND VGND VPWR VPWR sky130_fd_sc_hd__fill_1
XFILLER_50_531 VGND VGND VPWR VPWR sky130_fd_sc_hd__fill_1
XFILLER_50_542 VGND VGND VPWR VPWR sky130_fd_sc_hd__decap_3
XFILLER_62_391 VGND VGND VPWR VPWR sky130_fd_sc_hd__decap_3
X_6855_ _6944_/A _6856_/A2 _6854_/X _5614_/X _8199_/Q VGND VGND VPWR VPWR _6857_/A
+ sky130_fd_sc_hd__o221a_2
XFILLER_50_564 VGND VGND VPWR VPWR sky130_fd_sc_hd__decap_3
X_6786_ _7193_/A _5545_/X _6354_/B _6785_/X VGND VGND VPWR VPWR _6787_/B sky130_fd_sc_hd__a31o_2
X_5806_ _5897_/A _5601_/X _5718_/X _8235_/Q VGND VGND VPWR VPWR _5806_/X sky130_fd_sc_hd__a2bb2o_2
X_3998_ _8352_/Q _7930_/B VGND VGND VPWR VPWR _3999_/A sky130_fd_sc_hd__and2_2
X_5737_ _8290_/Q _5723_/X _5726_/X _5812_/A _5736_/X VGND VGND VPWR VPWR _5737_/X
+ sky130_fd_sc_hd__a221o_2
XFILLER_13_69 VGND VGND VPWR VPWR sky130_fd_sc_hd__decap_3
XFILLER_108_327 VGND VGND VPWR VPWR sky130_fd_sc_hd__decap_3
X_7407_ _7407_/A _7407_/B _7407_/C VGND VGND VPWR VPWR _7409_/A sky130_fd_sc_hd__and3_2
X_5668_ _5886_/A _5666_/X _5667_/X VGND VGND VPWR VPWR _5668_/X sky130_fd_sc_hd__o21ba_2
X_8387_ _8387_/CLK _8387_/D VGND VGND VPWR VPWR _8387_/Q sky130_fd_sc_hd__dfxtp_2
X_5599_ _7631_/B _8230_/Q _5597_/X _5598_/X VGND VGND VPWR VPWR _5599_/X sky130_fd_sc_hd__a31o_2
X_4619_ _4619_/A VGND VGND VPWR VPWR _8247_/D sky130_fd_sc_hd__buf_1
XTAP_TAPCELL_ROW_79_1288 VGND VPWR sky130_fd_sc_hd__tapvpwrvgnd_1
XFILLER_104_500 VGND VGND VPWR VPWR sky130_fd_sc_hd__decap_3
XFILLER_116_360 VGND VGND VPWR VPWR sky130_fd_sc_hd__decap_3
XFILLER_116_371 VGND VGND VPWR VPWR sky130_fd_sc_hd__decap_3
XFILLER_2_638 VGND VGND VPWR VPWR sky130_fd_sc_hd__decap_3
XFILLER_89_211 VGND VGND VPWR VPWR sky130_fd_sc_hd__decap_3
X_7338_ _8277_/Q _7338_/B VGND VGND VPWR VPWR _7338_/X sky130_fd_sc_hd__and2_2
XFILLER_104_566 VGND VGND VPWR VPWR sky130_fd_sc_hd__fill_1
X_7269_ _8211_/Q _8210_/Q _8209_/Q _8208_/Q _7796_/A _7765_/A VGND VGND VPWR VPWR
+ _7269_/X sky130_fd_sc_hd__mux4_2
XTAP_TAPCELL_ROW_92_1455 VGND VPWR sky130_fd_sc_hd__tapvpwrvgnd_1
XFILLER_49_119 VGND VGND VPWR VPWR sky130_fd_sc_hd__decap_3
XFILLER_77_439 VGND VGND VPWR VPWR sky130_fd_sc_hd__fill_2
XFILLER_89_277 VGND VGND VPWR VPWR sky130_fd_sc_hd__decap_3
XFILLER_58_642 VGND VGND VPWR VPWR sky130_fd_sc_hd__fill_2
XFILLER_38_55 VGND VGND VPWR VPWR sky130_fd_sc_hd__decap_3
XFILLER_38_88 VGND VGND VPWR VPWR sky130_fd_sc_hd__decap_3
XFILLER_18_539 VGND VGND VPWR VPWR sky130_fd_sc_hd__decap_3
XFILLER_57_163 VGND VGND VPWR VPWR sky130_fd_sc_hd__decap_3
XFILLER_58_697 VGND VGND VPWR VPWR sky130_fd_sc_hd__decap_3
XFILLER_73_623 VGND VGND VPWR VPWR sky130_fd_sc_hd__decap_3
XFILLER_45_358 VGND VGND VPWR VPWR sky130_fd_sc_hd__decap_3
XFILLER_54_10 VGND VGND VPWR VPWR sky130_fd_sc_hd__fill_2
XFILLER_54_21 VGND VGND VPWR VPWR sky130_fd_sc_hd__decap_3
XFILLER_54_32 VGND VGND VPWR VPWR sky130_fd_sc_hd__decap_3
XFILLER_72_133 VGND VGND VPWR VPWR sky130_fd_sc_hd__decap_3
XFILLER_73_667 VGND VGND VPWR VPWR sky130_fd_sc_hd__decap_3
XFILLER_14_701 VGND VGND VPWR VPWR sky130_fd_sc_hd__decap_3
XFILLER_26_561 VGND VGND VPWR VPWR sky130_fd_sc_hd__decap_3
XFILLER_26_583 VGND VGND VPWR VPWR sky130_fd_sc_hd__decap_3
XFILLER_60_317 VGND VGND VPWR VPWR sky130_fd_sc_hd__decap_3
XFILLER_41_520 VGND VGND VPWR VPWR sky130_fd_sc_hd__decap_3
XFILLER_110_71 VGND VGND VPWR VPWR sky130_fd_sc_hd__fill_1
XFILLER_13_244 VGND VGND VPWR VPWR sky130_fd_sc_hd__decap_3
XFILLER_41_564 VGND VGND VPWR VPWR sky130_fd_sc_hd__decap_3
XFILLER_9_215 VGND VGND VPWR VPWR sky130_fd_sc_hd__decap_3
XFILLER_70_20 VGND VGND VPWR VPWR sky130_fd_sc_hd__decap_3
XFILLER_70_53 VGND VGND VPWR VPWR sky130_fd_sc_hd__decap_3
XTAP_TAPCELL_ROW_101_1573 VGND VPWR sky130_fd_sc_hd__tapvpwrvgnd_1
XTAP_TAPCELL_ROW_11_401 VGND VPWR sky130_fd_sc_hd__tapvpwrvgnd_1
XFILLER_70_97 VGND VGND VPWR VPWR sky130_fd_sc_hd__decap_3
Xclkload18 _8392_/CLK VGND VGND VPWR VPWR clkload18/Y sky130_fd_sc_hd__clkinv_2
Xclkload29 _8280_/CLK VGND VGND VPWR VPWR clkload29/X sky130_fd_sc_hd__clkbuf_4
XFILLER_119_91 VGND VGND VPWR VPWR sky130_fd_sc_hd__decap_3
XFILLER_107_393 VGND VGND VPWR VPWR sky130_fd_sc_hd__decap_3
XFILLER_110_503 VGND VGND VPWR VPWR sky130_fd_sc_hd__decap_3
XFILLER_68_406 VGND VGND VPWR VPWR sky130_fd_sc_hd__decap_3
XFILLER_110_536 VGND VGND VPWR VPWR sky130_fd_sc_hd__decap_3
XFILLER_49_631 VGND VGND VPWR VPWR sky130_fd_sc_hd__decap_3
XFILLER_68_439 VGND VGND VPWR VPWR sky130_fd_sc_hd__fill_1
XFILLER_95_236 VGND VGND VPWR VPWR sky130_fd_sc_hd__decap_3
XFILLER_49_664 VGND VGND VPWR VPWR sky130_fd_sc_hd__decap_3
XFILLER_64_601 VGND VGND VPWR VPWR sky130_fd_sc_hd__decap_3
XFILLER_95_269 VGND VGND VPWR VPWR sky130_fd_sc_hd__decap_3
XFILLER_95_72 VGND VGND VPWR VPWR sky130_fd_sc_hd__decap_3
XFILLER_36_336 VGND VGND VPWR VPWR sky130_fd_sc_hd__decap_3
XFILLER_76_483 VGND VGND VPWR VPWR sky130_fd_sc_hd__decap_3
XFILLER_91_420 VGND VGND VPWR VPWR sky130_fd_sc_hd__decap_3
XTAP_TAPCELL_ROW_19_512 VGND VPWR sky130_fd_sc_hd__tapvpwrvgnd_1
XTAP_TAPCELL_ROW_19_501 VGND VPWR sky130_fd_sc_hd__tapvpwrvgnd_1
XFILLER_24_509 VGND VGND VPWR VPWR sky130_fd_sc_hd__decap_3
XFILLER_63_122 VGND VGND VPWR VPWR sky130_fd_sc_hd__decap_3
XFILLER_63_155 VGND VGND VPWR VPWR sky130_fd_sc_hd__decap_3
XFILLER_91_464 VGND VGND VPWR VPWR sky130_fd_sc_hd__decap_3
XTAP_TAPCELL_ROW_47_865 VGND VPWR sky130_fd_sc_hd__tapvpwrvgnd_1
XFILLER_17_561 VGND VGND VPWR VPWR sky130_fd_sc_hd__decap_3
XFILLER_17_572 VGND VGND VPWR VPWR sky130_fd_sc_hd__decap_3
XFILLER_51_328 VGND VGND VPWR VPWR sky130_fd_sc_hd__decap_3
X_4970_ _4970_/A _4970_/B _4970_/C VGND VGND VPWR VPWR _4971_/D sky130_fd_sc_hd__or3_2
XTAP_TAPCELL_ROW_47_876 VGND VPWR sky130_fd_sc_hd__tapvpwrvgnd_1
XFILLER_17_594 VGND VGND VPWR VPWR sky130_fd_sc_hd__decap_3
XFILLER_32_520 VGND VGND VPWR VPWR sky130_fd_sc_hd__fill_1
XFILLER_32_542 VGND VGND VPWR VPWR sky130_fd_sc_hd__decap_3
XFILLER_44_380 VGND VGND VPWR VPWR sky130_fd_sc_hd__decap_3
XFILLER_20_704 VGND VGND VPWR VPWR sky130_fd_sc_hd__fill_1
X_6640_ _7619_/A _6638_/X _6639_/Y _5402_/X VGND VGND VPWR VPWR _6640_/X sky130_fd_sc_hd__a22o_2
XTAP_TAPCELL_ROW_119_1801 VGND VPWR sky130_fd_sc_hd__tapvpwrvgnd_1
X_6571_ _8223_/Q _6571_/B _6571_/C VGND VGND VPWR VPWR _6571_/X sky130_fd_sc_hd__and3_2
XTAP_TAPCELL_ROW_63_1078 VGND VPWR sky130_fd_sc_hd__tapvpwrvgnd_1
XTAP_TAPCELL_ROW_119_1812 VGND VPWR sky130_fd_sc_hd__tapvpwrvgnd_1
XTAP_TAPCELL_ROW_119_1823 VGND VPWR sky130_fd_sc_hd__tapvpwrvgnd_1
X_8310_ _8377_/CLK _8310_/D VGND VGND VPWR VPWR _8310_/Q sky130_fd_sc_hd__dfxtp_2
X_5522_ _5520_/X _5521_/X _6648_/A VGND VGND VPWR VPWR _5523_/B sky130_fd_sc_hd__mux2_2
XFILLER_8_281 VGND VGND VPWR VPWR sky130_fd_sc_hd__decap_3
XFILLER_117_146 VGND VGND VPWR VPWR sky130_fd_sc_hd__decap_3
X_8241_ _8379_/CLK _8241_/D VGND VGND VPWR VPWR _8241_/Q sky130_fd_sc_hd__dfxtp_2
X_5453_ _5451_/X _5452_/X _5579_/S VGND VGND VPWR VPWR _5453_/X sky130_fd_sc_hd__mux2_2
XFILLER_99_520 VGND VGND VPWR VPWR sky130_fd_sc_hd__decap_3
X_8172_ clkload9/A _8172_/D VGND VGND VPWR VPWR _8172_/Q sky130_fd_sc_hd__dfxtp_2
X_5384_ _5161_/X _5383_/X _5384_/S VGND VGND VPWR VPWR _5384_/X sky130_fd_sc_hd__mux2_2
X_4404_ _7930_/B _4404_/B VGND VGND VPWR VPWR _4405_/A sky130_fd_sc_hd__and2_2
XFILLER_113_330 VGND VGND VPWR VPWR sky130_fd_sc_hd__decap_3
XFILLER_99_531 VGND VGND VPWR VPWR sky130_fd_sc_hd__decap_3
XFILLER_99_564 VGND VGND VPWR VPWR sky130_fd_sc_hd__decap_3
X_7123_ _8208_/Q _7228_/B _7796_/A VGND VGND VPWR VPWR _7123_/X sky130_fd_sc_hd__mux2_2
X_4335_ _4335_/A VGND VGND VPWR VPWR _8105_/D sky130_fd_sc_hd__buf_1
XFILLER_101_503 VGND VGND VPWR VPWR sky130_fd_sc_hd__fill_1
XFILLER_101_514 VGND VGND VPWR VPWR sky130_fd_sc_hd__decap_3
XFILLER_113_352 VGND VGND VPWR VPWR sky130_fd_sc_hd__decap_3
XFILLER_115_27 VGND VGND VPWR VPWR sky130_fd_sc_hd__decap_3
XFILLER_59_417 VGND VGND VPWR VPWR sky130_fd_sc_hd__decap_3
XFILLER_86_203 VGND VGND VPWR VPWR sky130_fd_sc_hd__decap_3
XFILLER_99_575 VGND VGND VPWR VPWR sky130_fd_sc_hd__fill_2
XFILLER_86_236 VGND VGND VPWR VPWR sky130_fd_sc_hd__decap_3
X_7054_ _7619_/A _4805_/A _7053_/X _5601_/X _4806_/A VGND VGND VPWR VPWR _7054_/X
+ sky130_fd_sc_hd__o32a_2
X_4266_ _7898_/B _4266_/B VGND VGND VPWR VPWR _4267_/A sky130_fd_sc_hd__and2_2
XFILLER_67_461 VGND VGND VPWR VPWR sky130_fd_sc_hd__fill_2
X_6005_ _8239_/Q _5995_/X _5977_/A VGND VGND VPWR VPWR _6005_/X sky130_fd_sc_hd__o21a_2
X_4197_ _4197_/A VGND VGND VPWR VPWR _8036_/D sky130_fd_sc_hd__buf_1
XFILLER_27_314 VGND VGND VPWR VPWR sky130_fd_sc_hd__decap_3
XFILLER_67_472 VGND VGND VPWR VPWR sky130_fd_sc_hd__decap_3
XFILLER_94_280 VGND VGND VPWR VPWR sky130_fd_sc_hd__decap_3
XFILLER_27_358 VGND VGND VPWR VPWR sky130_fd_sc_hd__decap_3
XFILLER_54_133 VGND VGND VPWR VPWR sky130_fd_sc_hd__decap_3
XFILLER_54_144 VGND VGND VPWR VPWR sky130_fd_sc_hd__decap_3
XFILLER_82_442 VGND VGND VPWR VPWR sky130_fd_sc_hd__decap_3
XFILLER_42_306 VGND VGND VPWR VPWR sky130_fd_sc_hd__fill_2
XFILLER_54_177 VGND VGND VPWR VPWR sky130_fd_sc_hd__decap_3
XFILLER_70_604 VGND VGND VPWR VPWR sky130_fd_sc_hd__decap_3
XFILLER_82_497 VGND VGND VPWR VPWR sky130_fd_sc_hd__decap_3
X_7956_ _8285_/CLK _7956_/D VGND VGND VPWR VPWR _7956_/Q sky130_fd_sc_hd__dfxtp_2
XFILLER_23_520 VGND VGND VPWR VPWR sky130_fd_sc_hd__decap_3
XFILLER_70_659 VGND VGND VPWR VPWR sky130_fd_sc_hd__decap_3
X_7887_ _7887_/A VGND VGND VPWR VPWR _8380_/D sky130_fd_sc_hd__buf_1
X_6907_ _8264_/Q _6880_/X _6906_/X VGND VGND VPWR VPWR _6907_/X sky130_fd_sc_hd__o21a_4
XFILLER_23_553 VGND VGND VPWR VPWR sky130_fd_sc_hd__decap_3
XFILLER_23_564 VGND VGND VPWR VPWR sky130_fd_sc_hd__decap_3
XFILLER_24_46 VGND VGND VPWR VPWR sky130_fd_sc_hd__decap_3
X_6838_ _6711_/C _8194_/Q _6838_/C _6838_/D VGND VGND VPWR VPWR _6838_/X sky130_fd_sc_hd__and4bb_4
XFILLER_10_225 VGND VGND VPWR VPWR sky130_fd_sc_hd__fill_1
XFILLER_50_383 VGND VGND VPWR VPWR sky130_fd_sc_hd__decap_3
XFILLER_10_236 VGND VGND VPWR VPWR sky130_fd_sc_hd__decap_3
XFILLER_6_207 VGND VGND VPWR VPWR sky130_fd_sc_hd__decap_3
X_6769_ _6769_/A _6769_/B _6769_/C VGND VGND VPWR VPWR _6769_/X sky130_fd_sc_hd__or3_2
XFILLER_40_45 VGND VGND VPWR VPWR sky130_fd_sc_hd__decap_3
XFILLER_108_168 VGND VGND VPWR VPWR sky130_fd_sc_hd__decap_3
XFILLER_109_669 VGND VGND VPWR VPWR sky130_fd_sc_hd__decap_3
XFILLER_78_704 VGND VGND VPWR VPWR sky130_fd_sc_hd__fill_1
XFILLER_104_363 VGND VGND VPWR VPWR sky130_fd_sc_hd__fill_1
XFILLER_104_374 VGND VGND VPWR VPWR sky130_fd_sc_hd__decap_3
XFILLER_77_203 VGND VGND VPWR VPWR sky130_fd_sc_hd__decap_3
XFILLER_49_98 VGND VGND VPWR VPWR sky130_fd_sc_hd__decap_3
XFILLER_77_225 VGND VGND VPWR VPWR sky130_fd_sc_hd__decap_3
XFILLER_1_28 VGND VGND VPWR VPWR sky130_fd_sc_hd__fill_1
XFILLER_77_258 VGND VGND VPWR VPWR sky130_fd_sc_hd__decap_3
XFILLER_92_206 VGND VGND VPWR VPWR sky130_fd_sc_hd__decap_3
XFILLER_93_729 VGND VGND VPWR VPWR sky130_fd_sc_hd__decap_3
XFILLER_46_623 VGND VGND VPWR VPWR sky130_fd_sc_hd__decap_3
XFILLER_58_472 VGND VGND VPWR VPWR sky130_fd_sc_hd__decap_3
XFILLER_58_483 VGND VGND VPWR VPWR sky130_fd_sc_hd__decap_3
XFILLER_65_20 VGND VGND VPWR VPWR sky130_fd_sc_hd__decap_3
XFILLER_92_228 VGND VGND VPWR VPWR sky130_fd_sc_hd__decap_3
XFILLER_18_358 VGND VGND VPWR VPWR sky130_fd_sc_hd__decap_3
XFILLER_45_133 VGND VGND VPWR VPWR sky130_fd_sc_hd__decap_3
XFILLER_65_53 VGND VGND VPWR VPWR sky130_fd_sc_hd__decap_3
XFILLER_65_75 VGND VGND VPWR VPWR sky130_fd_sc_hd__decap_3
XFILLER_33_306 VGND VGND VPWR VPWR sky130_fd_sc_hd__decap_3
XFILLER_61_626 VGND VGND VPWR VPWR sky130_fd_sc_hd__decap_3
XFILLER_73_464 VGND VGND VPWR VPWR sky130_fd_sc_hd__decap_3
XTAP_TAPCELL_ROW_103_1602 VGND VPWR sky130_fd_sc_hd__tapvpwrvgnd_1
XFILLER_14_520 VGND VGND VPWR VPWR sky130_fd_sc_hd__decap_3
XFILLER_45_188 VGND VGND VPWR VPWR sky130_fd_sc_hd__decap_3
XFILLER_60_125 VGND VGND VPWR VPWR sky130_fd_sc_hd__decap_3
XTAP_TAPCELL_ROW_44_835 VGND VPWR sky130_fd_sc_hd__tapvpwrvgnd_1
XFILLER_14_542 VGND VGND VPWR VPWR sky130_fd_sc_hd__decap_3
XFILLER_60_147 VGND VGND VPWR VPWR sky130_fd_sc_hd__decap_3
XFILLER_81_63 VGND VGND VPWR VPWR sky130_fd_sc_hd__decap_3
XFILLER_41_383 VGND VGND VPWR VPWR sky130_fd_sc_hd__decap_3
XTAP_TAPCELL_ROW_24_570 VGND VPWR sky130_fd_sc_hd__tapvpwrvgnd_1
XFILLER_6_730 VGND VGND VPWR VPWR sky130_fd_sc_hd__decap_3
XFILLER_115_606 VGND VGND VPWR VPWR sky130_fd_sc_hd__fill_2
XFILLER_115_617 VGND VGND VPWR VPWR sky130_fd_sc_hd__decap_3
XPHY_EDGE_ROW_116_Right_116 VGND VGND VPWR VPWR sky130_fd_sc_hd__decap_3
XFILLER_107_190 VGND VGND VPWR VPWR sky130_fd_sc_hd__decap_3
XTAP_TAPCELL_ROW_114_1742 VGND VPWR sky130_fd_sc_hd__tapvpwrvgnd_1
XFILLER_96_512 VGND VGND VPWR VPWR sky130_fd_sc_hd__fill_2
XFILLER_110_300 VGND VGND VPWR VPWR sky130_fd_sc_hd__decap_3
XFILLER_68_225 VGND VGND VPWR VPWR sky130_fd_sc_hd__decap_3
XFILLER_96_556 VGND VGND VPWR VPWR sky130_fd_sc_hd__decap_3
X_4120_ _7930_/B _8401_/Q VGND VGND VPWR VPWR _4121_/A sky130_fd_sc_hd__and2_2
XFILLER_68_269 VGND VGND VPWR VPWR sky130_fd_sc_hd__decap_3
XFILLER_84_718 VGND VGND VPWR VPWR sky130_fd_sc_hd__fill_1
X_4051_ _4051_/A VGND VGND VPWR VPWR _7963_/D sky130_fd_sc_hd__buf_1
XFILLER_110_388 VGND VGND VPWR VPWR sky130_fd_sc_hd__decap_3
XFILLER_49_461 VGND VGND VPWR VPWR sky130_fd_sc_hd__decap_3
XFILLER_83_228 VGND VGND VPWR VPWR sky130_fd_sc_hd__decap_3
Xinput5 cmd[3] VGND VGND VPWR VPWR input5/X sky130_fd_sc_hd__clkdlybuf4s25_1
XFILLER_36_111 VGND VGND VPWR VPWR sky130_fd_sc_hd__decap_3
XFILLER_37_645 VGND VGND VPWR VPWR sky130_fd_sc_hd__decap_3
XFILLER_37_656 VGND VGND VPWR VPWR sky130_fd_sc_hd__decap_3
XFILLER_64_431 VGND VGND VPWR VPWR sky130_fd_sc_hd__decap_3
X_7810_ _5950_/A _7808_/Y _7809_/Y _7796_/A VGND VGND VPWR VPWR _7810_/X sky130_fd_sc_hd__a22o_2
XFILLER_52_604 VGND VGND VPWR VPWR sky130_fd_sc_hd__fill_1
XFILLER_64_475 VGND VGND VPWR VPWR sky130_fd_sc_hd__fill_1
XFILLER_64_486 VGND VGND VPWR VPWR sky130_fd_sc_hd__decap_3
XTAP_TAPCELL_ROW_65_1107 VGND VPWR sky130_fd_sc_hd__tapvpwrvgnd_1
XFILLER_24_328 VGND VGND VPWR VPWR sky130_fd_sc_hd__decap_3
XFILLER_51_125 VGND VGND VPWR VPWR sky130_fd_sc_hd__decap_3
X_7741_ _7812_/A _8177_/Q _7812_/C VGND VGND VPWR VPWR _7741_/X sky130_fd_sc_hd__and3_2
X_4953_ _4953_/A _5651_/A VGND VGND VPWR VPWR _4954_/A sky130_fd_sc_hd__and2_2
XFILLER_51_158 VGND VGND VPWR VPWR sky130_fd_sc_hd__decap_3
X_7672_ _7672_/A VGND VGND VPWR VPWR _7672_/X sky130_fd_sc_hd__buf_1
XFILLER_32_361 VGND VGND VPWR VPWR sky130_fd_sc_hd__decap_3
XFILLER_32_372 VGND VGND VPWR VPWR sky130_fd_sc_hd__fill_2
XFILLER_60_692 VGND VGND VPWR VPWR sky130_fd_sc_hd__decap_3
X_6623_ _6623_/A _6623_/B VGND VGND VPWR VPWR _6642_/A sky130_fd_sc_hd__nor2_2
X_4884_ _6378_/S _8250_/Q VGND VGND VPWR VPWR _4887_/A sky130_fd_sc_hd__nor2_2
XFILLER_20_589 VGND VGND VPWR VPWR sky130_fd_sc_hd__decap_3
X_6554_ _6551_/X _6552_/X _6794_/A VGND VGND VPWR VPWR _6555_/C sky130_fd_sc_hd__mux2_2
X_6485_ _6450_/B _6462_/C _6464_/Y VGND VGND VPWR VPWR _6486_/B sky130_fd_sc_hd__o21ai_2
X_5505_ _6707_/S _8163_/Q _5311_/X _5503_/X _5504_/X VGND VGND VPWR VPWR _5511_/B
+ sky130_fd_sc_hd__o221a_4
XFILLER_105_116 VGND VGND VPWR VPWR sky130_fd_sc_hd__fill_2
X_8224_ _8224_/CLK _8224_/D VGND VGND VPWR VPWR _8224_/Q sky130_fd_sc_hd__dfxtp_4
X_5436_ _6445_/A1 _5429_/X _5480_/A2 _6804_/A _4969_/A VGND VGND VPWR VPWR _5436_/X
+ sky130_fd_sc_hd__o221a_2
XTAP_TAPCELL_ROW_76_1247 VGND VPWR sky130_fd_sc_hd__tapvpwrvgnd_1
XFILLER_10_59 VGND VGND VPWR VPWR sky130_fd_sc_hd__decap_3
XFILLER_99_350 VGND VGND VPWR VPWR sky130_fd_sc_hd__decap_3
X_8155_ clkload6/A _8155_/D VGND VGND VPWR VPWR _8155_/Q sky130_fd_sc_hd__dfxtp_2
X_5367_ _5444_/S _5367_/B VGND VGND VPWR VPWR _5573_/B sky130_fd_sc_hd__nand2_2
XFILLER_101_322 VGND VGND VPWR VPWR sky130_fd_sc_hd__fill_1
XFILLER_87_523 VGND VGND VPWR VPWR sky130_fd_sc_hd__fill_1
X_8086_ _8228_/CLK _8086_/D VGND VGND VPWR VPWR _8086_/Q sky130_fd_sc_hd__dfxtp_2
X_7106_ _7228_/B _8271_/Q _7105_/X VGND VGND VPWR VPWR _7106_/Y sky130_fd_sc_hd__a21oi_2
X_5298_ _7610_/B VGND VGND VPWR VPWR _7562_/A sky130_fd_sc_hd__buf_1
X_4318_ _7898_/B _4318_/B VGND VGND VPWR VPWR _4319_/A sky130_fd_sc_hd__and2_2
XFILLER_101_333 VGND VGND VPWR VPWR sky130_fd_sc_hd__decap_3
XFILLER_113_193 VGND VGND VPWR VPWR sky130_fd_sc_hd__fill_2
XFILLER_19_46 VGND VGND VPWR VPWR sky130_fd_sc_hd__decap_3
XFILLER_75_729 VGND VGND VPWR VPWR sky130_fd_sc_hd__decap_3
XFILLER_87_589 VGND VGND VPWR VPWR sky130_fd_sc_hd__decap_3
X_7037_ _8205_/Q _8204_/Q _8203_/Q _8202_/Q _7796_/A _7812_/A VGND VGND VPWR VPWR
+ _7037_/X sky130_fd_sc_hd__mux4_2
X_4249_ _4249_/A VGND VGND VPWR VPWR _8062_/D sky130_fd_sc_hd__buf_1
XFILLER_101_399 VGND VGND VPWR VPWR sky130_fd_sc_hd__fill_1
XFILLER_19_57 VGND VGND VPWR VPWR sky130_fd_sc_hd__decap_3
XFILLER_28_601 VGND VGND VPWR VPWR sky130_fd_sc_hd__decap_3
XFILLER_74_206 VGND VGND VPWR VPWR sky130_fd_sc_hd__decap_3
XFILLER_74_239 VGND VGND VPWR VPWR sky130_fd_sc_hd__decap_3
XFILLER_27_133 VGND VGND VPWR VPWR sky130_fd_sc_hd__decap_3
XFILLER_28_645 VGND VGND VPWR VPWR sky130_fd_sc_hd__decap_3
XFILLER_55_420 VGND VGND VPWR VPWR sky130_fd_sc_hd__decap_3
XFILLER_55_442 VGND VGND VPWR VPWR sky130_fd_sc_hd__decap_3
XFILLER_15_306 VGND VGND VPWR VPWR sky130_fd_sc_hd__decap_3
XFILLER_27_166 VGND VGND VPWR VPWR sky130_fd_sc_hd__fill_2
XFILLER_43_615 VGND VGND VPWR VPWR sky130_fd_sc_hd__fill_1
XFILLER_55_464 VGND VGND VPWR VPWR sky130_fd_sc_hd__fill_1
XTAP_TAPCELL_ROW_87_1387 VGND VPWR sky130_fd_sc_hd__tapvpwrvgnd_1
XTAP_TAPCELL_ROW_2_287 VGND VPWR sky130_fd_sc_hd__tapvpwrvgnd_1
XFILLER_42_125 VGND VGND VPWR VPWR sky130_fd_sc_hd__fill_2
XFILLER_42_136 VGND VGND VPWR VPWR sky130_fd_sc_hd__decap_3
XFILLER_70_434 VGND VGND VPWR VPWR sky130_fd_sc_hd__decap_3
XFILLER_70_445 VGND VGND VPWR VPWR sky130_fd_sc_hd__decap_3
XFILLER_82_283 VGND VGND VPWR VPWR sky130_fd_sc_hd__decap_3
X_7939_ _8398_/CLK _7939_/D VGND VGND VPWR VPWR _7939_/Q sky130_fd_sc_hd__dfxtp_2
XFILLER_30_309 VGND VGND VPWR VPWR sky130_fd_sc_hd__decap_3
XFILLER_70_467 VGND VGND VPWR VPWR sky130_fd_sc_hd__decap_3
XFILLER_11_523 VGND VGND VPWR VPWR sky130_fd_sc_hd__fill_1
XFILLER_51_11 VGND VGND VPWR VPWR sky130_fd_sc_hd__decap_3
XFILLER_11_556 VGND VGND VPWR VPWR sky130_fd_sc_hd__decap_3
XFILLER_7_505 VGND VGND VPWR VPWR sky130_fd_sc_hd__decap_3
XFILLER_11_578 VGND VGND VPWR VPWR sky130_fd_sc_hd__decap_3
XFILLER_51_66 VGND VGND VPWR VPWR sky130_fd_sc_hd__decap_3
XFILLER_7_538 VGND VGND VPWR VPWR sky130_fd_sc_hd__fill_1
XFILLER_109_477 VGND VGND VPWR VPWR sky130_fd_sc_hd__fill_1
XFILLER_109_488 VGND VGND VPWR VPWR sky130_fd_sc_hd__decap_3
XFILLER_3_722 VGND VGND VPWR VPWR sky130_fd_sc_hd__decap_3
XFILLER_104_182 VGND VGND VPWR VPWR sky130_fd_sc_hd__decap_3
XFILLER_78_545 VGND VGND VPWR VPWR sky130_fd_sc_hd__fill_1
XFILLER_66_707 VGND VGND VPWR VPWR sky130_fd_sc_hd__decap_3
XFILLER_78_578 VGND VGND VPWR VPWR sky130_fd_sc_hd__decap_3
XFILLER_19_623 VGND VGND VPWR VPWR sky130_fd_sc_hd__decap_3
XFILLER_65_228 VGND VGND VPWR VPWR sky130_fd_sc_hd__decap_3
XFILLER_93_526 VGND VGND VPWR VPWR sky130_fd_sc_hd__decap_3
XFILLER_18_111 VGND VGND VPWR VPWR sky130_fd_sc_hd__decap_3
XFILLER_19_645 VGND VGND VPWR VPWR sky130_fd_sc_hd__decap_3
XFILLER_46_442 VGND VGND VPWR VPWR sky130_fd_sc_hd__decap_3
XFILLER_93_559 VGND VGND VPWR VPWR sky130_fd_sc_hd__fill_1
XFILLER_18_144 VGND VGND VPWR VPWR sky130_fd_sc_hd__decap_3
XFILLER_18_177 VGND VGND VPWR VPWR sky130_fd_sc_hd__fill_2
XFILLER_46_475 VGND VGND VPWR VPWR sky130_fd_sc_hd__fill_1
XFILLER_46_486 VGND VGND VPWR VPWR sky130_fd_sc_hd__decap_3
XFILLER_80_209 VGND VGND VPWR VPWR sky130_fd_sc_hd__decap_3
XTAP_TAPCELL_ROW_29_640 VGND VPWR sky130_fd_sc_hd__tapvpwrvgnd_1
XFILLER_33_125 VGND VGND VPWR VPWR sky130_fd_sc_hd__decap_3
XFILLER_61_423 VGND VGND VPWR VPWR sky130_fd_sc_hd__decap_3
XFILLER_73_294 VGND VGND VPWR VPWR sky130_fd_sc_hd__decap_3
XFILLER_92_40 VGND VGND VPWR VPWR sky130_fd_sc_hd__decap_3
XFILLER_33_169 VGND VGND VPWR VPWR sky130_fd_sc_hd__fill_1
XFILLER_61_467 VGND VGND VPWR VPWR sky130_fd_sc_hd__decap_3
XFILLER_14_361 VGND VGND VPWR VPWR sky130_fd_sc_hd__decap_3
XFILLER_14_383 VGND VGND VPWR VPWR sky130_fd_sc_hd__fill_1
XFILLER_14_394 VGND VGND VPWR VPWR sky130_fd_sc_hd__decap_3
XTAP_TAPCELL_ROW_60_1037 VGND VPWR sky130_fd_sc_hd__tapvpwrvgnd_1
XFILLER_115_425 VGND VGND VPWR VPWR sky130_fd_sc_hd__decap_3
XFILLER_115_447 VGND VGND VPWR VPWR sky130_fd_sc_hd__fill_1
XFILLER_51_3 VGND VGND VPWR VPWR sky130_fd_sc_hd__fill_2
X_6270_ _5642_/X _6269_/X _6355_/B VGND VGND VPWR VPWR _6270_/X sky130_fd_sc_hd__a21o_2
XFILLER_102_108 VGND VGND VPWR VPWR sky130_fd_sc_hd__decap_3
X_5221_ _6321_/B _5740_/A _5212_/X _5220_/Y VGND VGND VPWR VPWR _5221_/X sky130_fd_sc_hd__a31o_2
XFILLER_111_620 VGND VGND VPWR VPWR sky130_fd_sc_hd__decap_3
XFILLER_69_523 VGND VGND VPWR VPWR sky130_fd_sc_hd__decap_3
X_5152_ _8202_/Q _8203_/Q _5484_/S VGND VGND VPWR VPWR _5152_/X sky130_fd_sc_hd__mux2_2
XFILLER_110_130 VGND VGND VPWR VPWR sky130_fd_sc_hd__decap_3
XFILLER_111_642 VGND VGND VPWR VPWR sky130_fd_sc_hd__decap_3
XFILLER_69_556 VGND VGND VPWR VPWR sky130_fd_sc_hd__decap_3
XFILLER_69_567 VGND VGND VPWR VPWR sky130_fd_sc_hd__decap_3
XFILLER_96_331 VGND VGND VPWR VPWR sky130_fd_sc_hd__decap_3
X_4103_ _4103_/A VGND VGND VPWR VPWR _7989_/D sky130_fd_sc_hd__buf_1
XTAP_TAPCELL_ROW_71_1188 VGND VPWR sky130_fd_sc_hd__tapvpwrvgnd_1
XTAP_TAPCELL_ROW_71_1177 VGND VPWR sky130_fd_sc_hd__tapvpwrvgnd_1
XFILLER_111_697 VGND VGND VPWR VPWR sky130_fd_sc_hd__decap_3
XFILLER_2_71 VGND VGND VPWR VPWR sky130_fd_sc_hd__decap_3
XFILLER_56_206 VGND VGND VPWR VPWR sky130_fd_sc_hd__decap_3
XFILLER_57_729 VGND VGND VPWR VPWR sky130_fd_sc_hd__decap_3
XFILLER_69_589 VGND VGND VPWR VPWR sky130_fd_sc_hd__decap_3
XFILLER_96_386 VGND VGND VPWR VPWR sky130_fd_sc_hd__decap_3
X_5083_ _5107_/A VGND VGND VPWR VPWR _5333_/A sky130_fd_sc_hd__buf_1
XFILLER_37_442 VGND VGND VPWR VPWR sky130_fd_sc_hd__decap_3
XFILLER_56_239 VGND VGND VPWR VPWR sky130_fd_sc_hd__decap_3
X_4034_ _8357_/Q _7930_/B VGND VGND VPWR VPWR _4035_/A sky130_fd_sc_hd__and2_2
XFILLER_112_39 VGND VGND VPWR VPWR sky130_fd_sc_hd__fill_1
XFILLER_25_615 VGND VGND VPWR VPWR sky130_fd_sc_hd__fill_1
XFILLER_37_464 VGND VGND VPWR VPWR sky130_fd_sc_hd__decap_3
XFILLER_52_401 VGND VGND VPWR VPWR sky130_fd_sc_hd__decap_3
XFILLER_64_261 VGND VGND VPWR VPWR sky130_fd_sc_hd__decap_3
XFILLER_71_209 VGND VGND VPWR VPWR sky130_fd_sc_hd__fill_1
XFILLER_37_486 VGND VGND VPWR VPWR sky130_fd_sc_hd__decap_3
XFILLER_64_294 VGND VGND VPWR VPWR sky130_fd_sc_hd__decap_3
XFILLER_12_309 VGND VGND VPWR VPWR sky130_fd_sc_hd__fill_2
XFILLER_24_136 VGND VGND VPWR VPWR sky130_fd_sc_hd__decap_3
XFILLER_24_147 VGND VGND VPWR VPWR sky130_fd_sc_hd__decap_3
XFILLER_52_445 VGND VGND VPWR VPWR sky130_fd_sc_hd__decap_3
X_7724_ _7653_/X _8208_/Q _7655_/X _7722_/X _7723_/X VGND VGND VPWR VPWR _7724_/X
+ sky130_fd_sc_hd__a311o_2
X_5985_ _5984_/X _5828_/X _6706_/S VGND VGND VPWR VPWR _5985_/X sky130_fd_sc_hd__mux2_2
XFILLER_40_629 VGND VGND VPWR VPWR sky130_fd_sc_hd__decap_3
XFILLER_52_489 VGND VGND VPWR VPWR sky130_fd_sc_hd__decap_3
X_4936_ _4936_/A _5725_/B VGND VGND VPWR VPWR _5867_/C sky130_fd_sc_hd__xor2_2
XANTENNA_10 _8298_/D VGND VGND VPWR VPWR sky130_fd_sc_hd__diode_2
XANTENNA_21 _6869_/X VGND VGND VPWR VPWR sky130_fd_sc_hd__diode_2
XANTENNA_32 _5319_/A VGND VGND VPWR VPWR sky130_fd_sc_hd__diode_2
XFILLER_32_191 VGND VGND VPWR VPWR sky130_fd_sc_hd__decap_3
X_7655_ _7655_/A VGND VGND VPWR VPWR _7655_/X sky130_fd_sc_hd__buf_1
X_4867_ _6605_/A _8255_/Q VGND VGND VPWR VPWR _4868_/B sky130_fd_sc_hd__nor2_2
X_7586_ _8285_/Q _7633_/C _7612_/D _8284_/Q _7633_/B VGND VGND VPWR VPWR _7586_/X
+ sky130_fd_sc_hd__o221a_2
X_6606_ _6334_/A _6604_/X _6670_/C _5614_/X _8192_/Q VGND VGND VPWR VPWR _6606_/Y
+ sky130_fd_sc_hd__o221ai_2
XFILLER_20_386 VGND VGND VPWR VPWR sky130_fd_sc_hd__decap_3
XFILLER_21_36 VGND VGND VPWR VPWR sky130_fd_sc_hd__fill_2
X_6537_ _8222_/Q _8223_/Q _7827_/B VGND VGND VPWR VPWR _6538_/A sky130_fd_sc_hd__mux2_2
X_4798_ _6992_/A _7030_/A VGND VGND VPWR VPWR _7166_/B sky130_fd_sc_hd__or2_2
XFILLER_4_519 VGND VGND VPWR VPWR sky130_fd_sc_hd__decap_3
XFILLER_106_447 VGND VGND VPWR VPWR sky130_fd_sc_hd__decap_3
X_6468_ _6769_/B _6468_/B VGND VGND VPWR VPWR _6468_/Y sky130_fd_sc_hd__nor2_2
X_8207_ _8207_/CLK _8207_/D VGND VGND VPWR VPWR _8207_/Q sky130_fd_sc_hd__dfxtp_4
Xoutput161 _7960_/Q VGND VGND VPWR VPWR result[2] sky130_fd_sc_hd__clkdlybuf4s25_1
Xoutput150 _7959_/Q VGND VGND VPWR VPWR result[1] sky130_fd_sc_hd__clkdlybuf4s25_1
X_6399_ _6397_/Y _6398_/Y _4891_/B VGND VGND VPWR VPWR _6399_/Y sky130_fd_sc_hd__a21oi_2
X_5419_ _8163_/Q _5292_/X _5296_/X VGND VGND VPWR VPWR _5419_/X sky130_fd_sc_hd__a21o_2
X_8138_ _8355_/CLK _8138_/D VGND VGND VPWR VPWR _8138_/Q sky130_fd_sc_hd__dfxtp_2
Xoutput194 _7963_/Q VGND VGND VPWR VPWR result[5] sky130_fd_sc_hd__clkdlybuf4s25_1
Xoutput183 _7962_/Q VGND VGND VPWR VPWR result[4] sky130_fd_sc_hd__clkdlybuf4s25_1
Xoutput172 _7961_/Q VGND VGND VPWR VPWR result[3] sky130_fd_sc_hd__clkdlybuf4s25_1
XTAP_TAPCELL_ROW_7_346 VGND VPWR sky130_fd_sc_hd__tapvpwrvgnd_1
XFILLER_87_331 VGND VGND VPWR VPWR sky130_fd_sc_hd__decap_3
XFILLER_102_686 VGND VGND VPWR VPWR sky130_fd_sc_hd__fill_2
XFILLER_47_206 VGND VGND VPWR VPWR sky130_fd_sc_hd__decap_3
XFILLER_75_526 VGND VGND VPWR VPWR sky130_fd_sc_hd__decap_3
X_8069_ _8207_/CLK _8069_/D VGND VGND VPWR VPWR _8069_/Q sky130_fd_sc_hd__dfxtp_2
XTAP_TAPCELL_ROW_89_1416 VGND VPWR sky130_fd_sc_hd__tapvpwrvgnd_1
XFILLER_101_196 VGND VGND VPWR VPWR sky130_fd_sc_hd__decap_3
XFILLER_46_11 VGND VGND VPWR VPWR sky130_fd_sc_hd__decap_3
XFILLER_47_239 VGND VGND VPWR VPWR sky130_fd_sc_hd__fill_1
XFILLER_16_615 VGND VGND VPWR VPWR sky130_fd_sc_hd__decap_3
XFILLER_28_464 VGND VGND VPWR VPWR sky130_fd_sc_hd__decap_3
XFILLER_46_77 VGND VGND VPWR VPWR sky130_fd_sc_hd__decap_3
XFILLER_90_529 VGND VGND VPWR VPWR sky130_fd_sc_hd__decap_3
XFILLER_16_648 VGND VGND VPWR VPWR sky130_fd_sc_hd__decap_3
XFILLER_55_272 VGND VGND VPWR VPWR sky130_fd_sc_hd__decap_3
XFILLER_71_732 VGND VGND VPWR VPWR sky130_fd_sc_hd__fill_1
XFILLER_83_592 VGND VGND VPWR VPWR sky130_fd_sc_hd__decap_3
XFILLER_102_50 VGND VGND VPWR VPWR sky130_fd_sc_hd__decap_3
XFILLER_15_158 VGND VGND VPWR VPWR sky130_fd_sc_hd__decap_3
XFILLER_15_169 VGND VGND VPWR VPWR sky130_fd_sc_hd__decap_3
XFILLER_43_456 VGND VGND VPWR VPWR sky130_fd_sc_hd__decap_3
XFILLER_70_242 VGND VGND VPWR VPWR sky130_fd_sc_hd__decap_3
XFILLER_70_253 VGND VGND VPWR VPWR sky130_fd_sc_hd__decap_3
XTAP_TAPCELL_ROW_54_963 VGND VPWR sky130_fd_sc_hd__tapvpwrvgnd_1
XFILLER_102_83 VGND VGND VPWR VPWR sky130_fd_sc_hd__fill_1
XFILLER_11_320 VGND VGND VPWR VPWR sky130_fd_sc_hd__decap_3
XFILLER_11_375 VGND VGND VPWR VPWR sky130_fd_sc_hd__decap_3
XFILLER_7_335 VGND VGND VPWR VPWR sky130_fd_sc_hd__fill_1
XFILLER_7_346 VGND VGND VPWR VPWR sky130_fd_sc_hd__decap_3
XFILLER_7_38 VGND VGND VPWR VPWR sky130_fd_sc_hd__decap_3
XFILLER_109_252 VGND VGND VPWR VPWR sky130_fd_sc_hd__decap_3
XFILLER_7_368 VGND VGND VPWR VPWR sky130_fd_sc_hd__decap_3
XFILLER_3_530 VGND VGND VPWR VPWR sky130_fd_sc_hd__decap_3
XFILLER_98_607 VGND VGND VPWR VPWR sky130_fd_sc_hd__decap_3
XTAP_TAPCELL_ROW_111_1701 VGND VPWR sky130_fd_sc_hd__tapvpwrvgnd_1
XFILLER_87_51 VGND VGND VPWR VPWR sky130_fd_sc_hd__decap_3
XFILLER_105_491 VGND VGND VPWR VPWR sky130_fd_sc_hd__decap_3
XFILLER_78_342 VGND VGND VPWR VPWR sky130_fd_sc_hd__decap_3
XFILLER_39_729 VGND VGND VPWR VPWR sky130_fd_sc_hd__decap_3
XFILLER_66_526 VGND VGND VPWR VPWR sky130_fd_sc_hd__decap_3
XFILLER_78_386 VGND VGND VPWR VPWR sky130_fd_sc_hd__decap_3
XFILLER_19_475 VGND VGND VPWR VPWR sky130_fd_sc_hd__decap_3
XFILLER_46_250 VGND VGND VPWR VPWR sky130_fd_sc_hd__fill_2
XFILLER_93_367 VGND VGND VPWR VPWR sky130_fd_sc_hd__decap_3
XTAP_TAPCELL_ROW_109_1674 VGND VPWR sky130_fd_sc_hd__tapvpwrvgnd_1
XFILLER_34_456 VGND VGND VPWR VPWR sky130_fd_sc_hd__decap_3
XFILLER_61_253 VGND VGND VPWR VPWR sky130_fd_sc_hd__decap_3
XFILLER_34_489 VGND VGND VPWR VPWR sky130_fd_sc_hd__decap_3
X_5770_ _5587_/A _5768_/X _5769_/X _5108_/A VGND VGND VPWR VPWR _5770_/X sky130_fd_sc_hd__a22o_2
XFILLER_21_139 VGND VGND VPWR VPWR sky130_fd_sc_hd__decap_3
XFILLER_30_640 VGND VGND VPWR VPWR sky130_fd_sc_hd__decap_3
X_4721_ _8286_/Q VGND VGND VPWR VPWR _4722_/B sky130_fd_sc_hd__inv_2
XFILLER_30_651 VGND VGND VPWR VPWR sky130_fd_sc_hd__decap_3
X_7440_ _6099_/A _7472_/B _7441_/B1 _6148_/A VGND VGND VPWR VPWR _7440_/X sky130_fd_sc_hd__a2bb2o_4
X_4652_ _7930_/B _8130_/Q VGND VGND VPWR VPWR _4653_/A sky130_fd_sc_hd__and2_2
XTAP_TAPCELL_ROW_32_679 VGND VPWR sky130_fd_sc_hd__tapvpwrvgnd_1
Xinput30 operand_a[31] VGND VGND VPWR VPWR _4238_/B sky130_fd_sc_hd__clkdlybuf4s25_1
XFILLER_116_701 VGND VGND VPWR VPWR sky130_fd_sc_hd__decap_3
X_7371_ _7369_/Y _7370_/X _5563_/X VGND VGND VPWR VPWR _7371_/X sky130_fd_sc_hd__o21a_2
Xinput63 operand_a[61] VGND VGND VPWR VPWR _4298_/B sky130_fd_sc_hd__clkdlybuf4s25_1
Xinput52 operand_a[51] VGND VGND VPWR VPWR _4278_/B sky130_fd_sc_hd__clkdlybuf4s25_1
Xinput41 operand_a[41] VGND VGND VPWR VPWR _4258_/B sky130_fd_sc_hd__clkdlybuf4s25_1
X_4583_ _4583_/A VGND VGND VPWR VPWR _8229_/D sky130_fd_sc_hd__buf_1
Xinput96 operand_b[33] VGND VGND VPWR VPWR _4370_/B sky130_fd_sc_hd__clkdlybuf4s25_1
Xinput85 operand_b[23] VGND VGND VPWR VPWR _4350_/B sky130_fd_sc_hd__clkdlybuf4s25_1
Xinput74 operand_b[13] VGND VGND VPWR VPWR _4330_/B sky130_fd_sc_hd__clkdlybuf4s25_1
X_6322_ _8184_/Q _8183_/Q _6380_/S VGND VGND VPWR VPWR _6322_/X sky130_fd_sc_hd__mux2_2
XTAP_TAPCELL_ROW_73_1206 VGND VPWR sky130_fd_sc_hd__tapvpwrvgnd_1
XFILLER_88_106 VGND VGND VPWR VPWR sky130_fd_sc_hd__decap_3
XFILLER_89_629 VGND VGND VPWR VPWR sky130_fd_sc_hd__decap_3
X_6253_ _7305_/A1 _6219_/Y _6252_/X _7898_/B VGND VGND VPWR VPWR _8316_/D sky130_fd_sc_hd__o211a_2
XFILLER_88_139 VGND VGND VPWR VPWR sky130_fd_sc_hd__fill_1
X_5204_ _5911_/B _5204_/B VGND VGND VPWR VPWR _5913_/B sky130_fd_sc_hd__and2_2
XFILLER_69_331 VGND VGND VPWR VPWR sky130_fd_sc_hd__decap_3
XFILLER_97_662 VGND VGND VPWR VPWR sky130_fd_sc_hd__decap_3
X_6184_ _6184_/A _6184_/B _6183_/Y VGND VGND VPWR VPWR _6184_/X sky130_fd_sc_hd__or3b_2
XTAP_TAPCELL_ROW_4_305 VGND VPWR sky130_fd_sc_hd__tapvpwrvgnd_1
XFILLER_57_515 VGND VGND VPWR VPWR sky130_fd_sc_hd__decap_3
XFILLER_69_375 VGND VGND VPWR VPWR sky130_fd_sc_hd__decap_3
XFILLER_84_301 VGND VGND VPWR VPWR sky130_fd_sc_hd__decap_3
XFILLER_84_312 VGND VGND VPWR VPWR sky130_fd_sc_hd__decap_3
X_5135_ _5132_/X _5133_/X _5634_/S VGND VGND VPWR VPWR _5135_/X sky130_fd_sc_hd__mux2_2
XTAP_TAPCELL_ROW_4_316 VGND VPWR sky130_fd_sc_hd__tapvpwrvgnd_1
XFILLER_29_228 VGND VGND VPWR VPWR sky130_fd_sc_hd__decap_3
XFILLER_84_345 VGND VGND VPWR VPWR sky130_fd_sc_hd__decap_3
X_5066_ _4814_/B _5065_/Y _4814_/A VGND VGND VPWR VPWR _5066_/Y sky130_fd_sc_hd__a21boi_2
XFILLER_44_209 VGND VGND VPWR VPWR sky130_fd_sc_hd__decap_3
XFILLER_72_518 VGND VGND VPWR VPWR sky130_fd_sc_hd__decap_3
X_4017_ _4017_/A _4017_/B _4017_/C _4017_/D VGND VGND VPWR VPWR _4032_/A sky130_fd_sc_hd__or4_2
XFILLER_53_732 VGND VGND VPWR VPWR sky130_fd_sc_hd__fill_1
XFILLER_65_581 VGND VGND VPWR VPWR sky130_fd_sc_hd__fill_1
XFILLER_65_592 VGND VGND VPWR VPWR sky130_fd_sc_hd__decap_3
XFILLER_13_607 VGND VGND VPWR VPWR sky130_fd_sc_hd__decap_3
XFILLER_52_253 VGND VGND VPWR VPWR sky130_fd_sc_hd__decap_3
XFILLER_80_551 VGND VGND VPWR VPWR sky130_fd_sc_hd__decap_3
XTAP_TAPCELL_ROW_84_1357 VGND VPWR sky130_fd_sc_hd__tapvpwrvgnd_1
XTAP_TAPCELL_ROW_84_1346 VGND VPWR sky130_fd_sc_hd__tapvpwrvgnd_1
XFILLER_12_117 VGND VGND VPWR VPWR sky130_fd_sc_hd__decap_3
XFILLER_25_489 VGND VGND VPWR VPWR sky130_fd_sc_hd__fill_1
XFILLER_40_415 VGND VGND VPWR VPWR sky130_fd_sc_hd__decap_3
XFILLER_52_275 VGND VGND VPWR VPWR sky130_fd_sc_hd__decap_3
XFILLER_80_584 VGND VGND VPWR VPWR sky130_fd_sc_hd__decap_3
XFILLER_80_595 VGND VGND VPWR VPWR sky130_fd_sc_hd__decap_3
X_5968_ _6804_/A _6042_/A1 _5933_/Y _5967_/Y VGND VGND VPWR VPWR _5968_/X sky130_fd_sc_hd__a2bb2o_2
XTAP_TAPCELL_ROW_51_922 VGND VPWR sky130_fd_sc_hd__tapvpwrvgnd_1
XFILLER_40_448 VGND VGND VPWR VPWR sky130_fd_sc_hd__decap_3
X_7707_ _7796_/A _8214_/Q VGND VGND VPWR VPWR _7707_/Y sky130_fd_sc_hd__nand2_2
X_4919_ _5900_/S _8237_/Q VGND VGND VPWR VPWR _4921_/A sky130_fd_sc_hd__nand2_2
XFILLER_20_150 VGND VGND VPWR VPWR sky130_fd_sc_hd__decap_3
XFILLER_21_673 VGND VGND VPWR VPWR sky130_fd_sc_hd__decap_3
XFILLER_32_35 VGND VGND VPWR VPWR sky130_fd_sc_hd__decap_3
X_5899_ _6368_/B _7010_/B _5941_/B _7195_/B VGND VGND VPWR VPWR _5899_/X sky130_fd_sc_hd__o2bb2a_2
XFILLER_32_68 VGND VGND VPWR VPWR sky130_fd_sc_hd__decap_3
XFILLER_32_79 VGND VGND VPWR VPWR sky130_fd_sc_hd__decap_3
X_7638_ _8286_/Q _7836_/B _8222_/Q VGND VGND VPWR VPWR _7638_/Y sky130_fd_sc_hd__o21ai_4
Xrebuffer933 _7280_/B VGND VGND VPWR VPWR rebuffer933/X sky130_fd_sc_hd__buf_6
XFILLER_119_561 VGND VGND VPWR VPWR sky130_fd_sc_hd__decap_3
X_7569_ _7930_/B _7569_/B VGND VGND VPWR VPWR _8355_/D sky130_fd_sc_hd__and2_4
XFILLER_106_200 VGND VGND VPWR VPWR sky130_fd_sc_hd__decap_3
XFILLER_106_233 VGND VGND VPWR VPWR sky130_fd_sc_hd__decap_3
XFILLER_4_327 VGND VGND VPWR VPWR sky130_fd_sc_hd__decap_3
XTAP_TAPCELL_ROW_95_1497 VGND VPWR sky130_fd_sc_hd__tapvpwrvgnd_1
XFILLER_0_511 VGND VGND VPWR VPWR sky130_fd_sc_hd__fill_2
XFILLER_106_277 VGND VGND VPWR VPWR sky130_fd_sc_hd__decap_3
XFILLER_0_533 VGND VGND VPWR VPWR sky130_fd_sc_hd__decap_3
XFILLER_48_526 VGND VGND VPWR VPWR sky130_fd_sc_hd__decap_3
XFILLER_57_21 VGND VGND VPWR VPWR sky130_fd_sc_hd__decap_3
XFILLER_102_483 VGND VGND VPWR VPWR sky130_fd_sc_hd__decap_3
XFILLER_48_548 VGND VGND VPWR VPWR sky130_fd_sc_hd__decap_3
XFILLER_75_323 VGND VGND VPWR VPWR sky130_fd_sc_hd__decap_3
XFILLER_63_518 VGND VGND VPWR VPWR sky130_fd_sc_hd__decap_3
XFILLER_75_356 VGND VGND VPWR VPWR sky130_fd_sc_hd__decap_3
XFILLER_113_60 VGND VGND VPWR VPWR sky130_fd_sc_hd__decap_3
XFILLER_90_315 VGND VGND VPWR VPWR sky130_fd_sc_hd__decap_3
XFILLER_16_445 VGND VGND VPWR VPWR sky130_fd_sc_hd__decap_3
XFILLER_73_42 VGND VGND VPWR VPWR sky130_fd_sc_hd__decap_3
XFILLER_31_404 VGND VGND VPWR VPWR sky130_fd_sc_hd__decap_3
XFILLER_73_97 VGND VGND VPWR VPWR sky130_fd_sc_hd__decap_3
XFILLER_12_640 VGND VGND VPWR VPWR sky130_fd_sc_hd__decap_3
XFILLER_12_651 VGND VGND VPWR VPWR sky130_fd_sc_hd__decap_3
XFILLER_11_172 VGND VGND VPWR VPWR sky130_fd_sc_hd__decap_3
XFILLER_7_110 VGND VGND VPWR VPWR sky130_fd_sc_hd__fill_2
XFILLER_98_50 VGND VGND VPWR VPWR sky130_fd_sc_hd__decap_3
XFILLER_3_360 VGND VGND VPWR VPWR sky130_fd_sc_hd__decap_3
XFILLER_98_83 VGND VGND VPWR VPWR sky130_fd_sc_hd__fill_1
XFILLER_112_258 VGND VGND VPWR VPWR sky130_fd_sc_hd__decap_3
XFILLER_79_673 VGND VGND VPWR VPWR sky130_fd_sc_hd__decap_3
XFILLER_39_537 VGND VGND VPWR VPWR sky130_fd_sc_hd__decap_3
XFILLER_93_131 VGND VGND VPWR VPWR sky130_fd_sc_hd__decap_3
XFILLER_26_209 VGND VGND VPWR VPWR sky130_fd_sc_hd__decap_3
XFILLER_54_507 VGND VGND VPWR VPWR sky130_fd_sc_hd__decap_3
XFILLER_81_304 VGND VGND VPWR VPWR sky130_fd_sc_hd__decap_3
XFILLER_93_153 VGND VGND VPWR VPWR sky130_fd_sc_hd__fill_2
XFILLER_93_164 VGND VGND VPWR VPWR sky130_fd_sc_hd__decap_3
XFILLER_94_665 VGND VGND VPWR VPWR sky130_fd_sc_hd__decap_3
X_6940_ _8266_/Q _5292_/X _5422_/A VGND VGND VPWR VPWR _6940_/X sky130_fd_sc_hd__a21o_2
XFILLER_35_732 VGND VGND VPWR VPWR sky130_fd_sc_hd__fill_1
XFILLER_81_337 VGND VGND VPWR VPWR sky130_fd_sc_hd__decap_3
XFILLER_93_175 VGND VGND VPWR VPWR sky130_fd_sc_hd__decap_3
XTAP_TAPCELL_ROW_37_738 VGND VPWR sky130_fd_sc_hd__tapvpwrvgnd_1
XFILLER_62_540 VGND VGND VPWR VPWR sky130_fd_sc_hd__decap_3
X_6871_ _6184_/B _6852_/Y _6857_/X _6870_/X VGND VGND VPWR VPWR _6871_/X sky130_fd_sc_hd__o211a_2
XFILLER_34_253 VGND VGND VPWR VPWR sky130_fd_sc_hd__decap_3
XFILLER_50_713 VGND VGND VPWR VPWR sky130_fd_sc_hd__fill_2
XFILLER_50_724 VGND VGND VPWR VPWR sky130_fd_sc_hd__fill_1
XFILLER_62_584 VGND VGND VPWR VPWR sky130_fd_sc_hd__decap_3
X_5822_ _6130_/B _5822_/B VGND VGND VPWR VPWR _5822_/Y sky130_fd_sc_hd__nand2_2
XFILLER_22_448 VGND VGND VPWR VPWR sky130_fd_sc_hd__decap_3
XFILLER_62_595 VGND VGND VPWR VPWR sky130_fd_sc_hd__decap_3
X_5753_ _5832_/A _5750_/X _5752_/Y _7827_/A VGND VGND VPWR VPWR _5753_/X sky130_fd_sc_hd__o22a_2
XTAP_TAPCELL_ROW_17_484 VGND VPWR sky130_fd_sc_hd__tapvpwrvgnd_1
X_4704_ _7843_/A _8156_/Q VGND VGND VPWR VPWR _4705_/A sky130_fd_sc_hd__and2_2
X_5684_ _5177_/X _5178_/X _5684_/S VGND VGND VPWR VPWR _5684_/X sky130_fd_sc_hd__mux2_2
XFILLER_8_70 VGND VGND VPWR VPWR sky130_fd_sc_hd__decap_3
X_7423_ _6320_/Y _6321_/X _7421_/Y _7193_/A VGND VGND VPWR VPWR _7429_/C sky130_fd_sc_hd__a31o_2
X_4635_ _4635_/A VGND VGND VPWR VPWR _8255_/D sky130_fd_sc_hd__buf_1
XFILLER_116_531 VGND VGND VPWR VPWR sky130_fd_sc_hd__fill_1
XFILLER_118_27 VGND VGND VPWR VPWR sky130_fd_sc_hd__fill_1
XFILLER_118_38 VGND VGND VPWR VPWR sky130_fd_sc_hd__decap_3
X_7354_ _7353_/Y _5338_/X _5601_/A _8214_/Q VGND VGND VPWR VPWR _7354_/X sky130_fd_sc_hd__o22a_2
X_4566_ _7843_/A _8087_/Q VGND VGND VPWR VPWR _4567_/A sky130_fd_sc_hd__and2_2
XFILLER_116_542 VGND VGND VPWR VPWR sky130_fd_sc_hd__decap_3
XFILLER_116_564 VGND VGND VPWR VPWR sky130_fd_sc_hd__decap_3
XFILLER_89_404 VGND VGND VPWR VPWR sky130_fd_sc_hd__decap_3
X_6305_ _8247_/Q _6258_/X _5041_/Y VGND VGND VPWR VPWR _6305_/X sky130_fd_sc_hd__o21a_4
XFILLER_103_214 VGND VGND VPWR VPWR sky130_fd_sc_hd__decap_3
XFILLER_103_225 VGND VGND VPWR VPWR sky130_fd_sc_hd__decap_3
XFILLER_116_586 VGND VGND VPWR VPWR sky130_fd_sc_hd__fill_2
XFILLER_89_437 VGND VGND VPWR VPWR sky130_fd_sc_hd__fill_1
X_7285_ _6334_/A _7282_/Y _7344_/C _5614_/X _8212_/Q VGND VGND VPWR VPWR _7285_/Y
+ sky130_fd_sc_hd__o221ai_2
X_4497_ _4497_/A VGND VGND VPWR VPWR _8186_/D sky130_fd_sc_hd__buf_1
XFILLER_103_258 VGND VGND VPWR VPWR sky130_fd_sc_hd__decap_3
X_6236_ _6236_/A _6236_/B VGND VGND VPWR VPWR _6236_/X sky130_fd_sc_hd__or2_2
XFILLER_97_470 VGND VGND VPWR VPWR sky130_fd_sc_hd__decap_3
X_6167_ _6166_/X _5861_/X _6507_/S VGND VGND VPWR VPWR _6744_/B sky130_fd_sc_hd__mux2_2
X_5118_ _5118_/A VGND VGND VPWR VPWR _5854_/B sky130_fd_sc_hd__buf_1
XFILLER_17_209 VGND VGND VPWR VPWR sky130_fd_sc_hd__decap_3
XFILLER_57_367 VGND VGND VPWR VPWR sky130_fd_sc_hd__decap_3
XFILLER_84_131 VGND VGND VPWR VPWR sky130_fd_sc_hd__decap_3
XFILLER_84_164 VGND VGND VPWR VPWR sky130_fd_sc_hd__fill_1
X_6098_ _6098_/A _6192_/C VGND VGND VPWR VPWR _6099_/B sky130_fd_sc_hd__or2_2
XFILLER_38_570 VGND VGND VPWR VPWR sky130_fd_sc_hd__decap_3
XFILLER_45_529 VGND VGND VPWR VPWR sky130_fd_sc_hd__decap_3
XFILLER_72_315 VGND VGND VPWR VPWR sky130_fd_sc_hd__decap_3
XFILLER_84_197 VGND VGND VPWR VPWR sky130_fd_sc_hd__decap_3
X_5049_ _8251_/Q _5048_/X _8187_/Q VGND VGND VPWR VPWR _5049_/X sky130_fd_sc_hd__a21bo_2
XFILLER_25_242 VGND VGND VPWR VPWR sky130_fd_sc_hd__decap_3
XFILLER_72_348 VGND VGND VPWR VPWR sky130_fd_sc_hd__decap_3
XFILLER_13_415 VGND VGND VPWR VPWR sky130_fd_sc_hd__decap_3
XFILLER_25_275 VGND VGND VPWR VPWR sky130_fd_sc_hd__decap_3
XFILLER_43_23 VGND VGND VPWR VPWR sky130_fd_sc_hd__decap_3
XFILLER_13_426 VGND VGND VPWR VPWR sky130_fd_sc_hd__decap_3
XFILLER_25_297 VGND VGND VPWR VPWR sky130_fd_sc_hd__decap_3
XFILLER_40_234 VGND VGND VPWR VPWR sky130_fd_sc_hd__decap_3
XFILLER_43_45 VGND VGND VPWR VPWR sky130_fd_sc_hd__decap_3
XFILLER_9_419 VGND VGND VPWR VPWR sky130_fd_sc_hd__decap_3
XTAP_TAPCELL_ROW_97_1515 VGND VPWR sky130_fd_sc_hd__tapvpwrvgnd_1
XFILLER_21_492 VGND VGND VPWR VPWR sky130_fd_sc_hd__decap_3
XFILLER_5_614 VGND VGND VPWR VPWR sky130_fd_sc_hd__fill_2
Xrebuffer730 _6177_/A2 VGND VGND VPWR VPWR _6143_/B1 sky130_fd_sc_hd__buf_2
XTAP_TAPCELL_ROW_97_1526 VGND VPWR sky130_fd_sc_hd__tapvpwrvgnd_1
XFILLER_107_531 VGND VGND VPWR VPWR sky130_fd_sc_hd__decap_3
XFILLER_119_391 VGND VGND VPWR VPWR sky130_fd_sc_hd__fill_1
XFILLER_5_647 VGND VGND VPWR VPWR sky130_fd_sc_hd__decap_3
Xrebuffer763 _5656_/B VGND VGND VPWR VPWR _5480_/A2 sky130_fd_sc_hd__buf_2
XFILLER_107_542 VGND VGND VPWR VPWR sky130_fd_sc_hd__decap_3
XFILLER_107_564 VGND VGND VPWR VPWR sky130_fd_sc_hd__decap_3
Xrebuffer796 _6258_/X VGND VGND VPWR VPWR _6259_/B sky130_fd_sc_hd__buf_2
XFILLER_68_20 VGND VGND VPWR VPWR sky130_fd_sc_hd__decap_3
XFILLER_110_707 VGND VGND VPWR VPWR sky130_fd_sc_hd__fill_2
XFILLER_0_363 VGND VGND VPWR VPWR sky130_fd_sc_hd__fill_1
XFILLER_48_301 VGND VGND VPWR VPWR sky130_fd_sc_hd__fill_1
XFILLER_67_109 VGND VGND VPWR VPWR sky130_fd_sc_hd__decap_3
XFILLER_68_75 VGND VGND VPWR VPWR sky130_fd_sc_hd__decap_3
XFILLER_95_429 VGND VGND VPWR VPWR sky130_fd_sc_hd__decap_3
XFILLER_0_396 VGND VGND VPWR VPWR sky130_fd_sc_hd__decap_3
XFILLER_68_97 VGND VGND VPWR VPWR sky130_fd_sc_hd__decap_3
XFILLER_36_518 VGND VGND VPWR VPWR sky130_fd_sc_hd__fill_1
XFILLER_48_345 VGND VGND VPWR VPWR sky130_fd_sc_hd__fill_2
XFILLER_48_356 VGND VGND VPWR VPWR sky130_fd_sc_hd__decap_3
XFILLER_48_378 VGND VGND VPWR VPWR sky130_fd_sc_hd__decap_3
XFILLER_75_131 VGND VGND VPWR VPWR sky130_fd_sc_hd__fill_1
XFILLER_76_687 VGND VGND VPWR VPWR sky130_fd_sc_hd__decap_3
XFILLER_17_732 VGND VGND VPWR VPWR sky130_fd_sc_hd__fill_1
XFILLER_29_581 VGND VGND VPWR VPWR sky130_fd_sc_hd__decap_3
XFILLER_63_337 VGND VGND VPWR VPWR sky130_fd_sc_hd__decap_3
XFILLER_84_63 VGND VGND VPWR VPWR sky130_fd_sc_hd__decap_3
XFILLER_91_635 VGND VGND VPWR VPWR sky130_fd_sc_hd__decap_3
XFILLER_84_85 VGND VGND VPWR VPWR sky130_fd_sc_hd__fill_2
XFILLER_91_679 VGND VGND VPWR VPWR sky130_fd_sc_hd__fill_2
XTAP_TAPCELL_ROW_106_1633 VGND VPWR sky130_fd_sc_hd__tapvpwrvgnd_1
XFILLER_16_253 VGND VGND VPWR VPWR sky130_fd_sc_hd__decap_3
XFILLER_16_275 VGND VGND VPWR VPWR sky130_fd_sc_hd__decap_3
XFILLER_71_370 VGND VGND VPWR VPWR sky130_fd_sc_hd__decap_3
XFILLER_90_189 VGND VGND VPWR VPWR sky130_fd_sc_hd__decap_3
XFILLER_16_297 VGND VGND VPWR VPWR sky130_fd_sc_hd__decap_3
XFILLER_31_234 VGND VGND VPWR VPWR sky130_fd_sc_hd__decap_3
XTAP_TAPCELL_ROW_14_443 VGND VPWR sky130_fd_sc_hd__tapvpwrvgnd_1
XFILLER_8_430 VGND VGND VPWR VPWR sky130_fd_sc_hd__decap_3
X_4420_ _7843_/A _4420_/B VGND VGND VPWR VPWR _4421_/A sky130_fd_sc_hd__and2_2
XTAP_TAPCELL_ROW_117_1784 VGND VPWR sky130_fd_sc_hd__tapvpwrvgnd_1
XFILLER_98_223 VGND VGND VPWR VPWR sky130_fd_sc_hd__decap_3
X_4351_ _4351_/A VGND VGND VPWR VPWR _8113_/D sky130_fd_sc_hd__buf_1
XFILLER_113_534 VGND VGND VPWR VPWR sky130_fd_sc_hd__fill_2
XFILLER_113_545 VGND VGND VPWR VPWR sky130_fd_sc_hd__decap_3
XFILLER_98_234 VGND VGND VPWR VPWR sky130_fd_sc_hd__decap_3
XFILLER_98_256 VGND VGND VPWR VPWR sky130_fd_sc_hd__decap_3
X_7070_ _7475_/A _7070_/B VGND VGND VPWR VPWR _7070_/X sky130_fd_sc_hd__or2_2
X_4282_ _7843_/A _4282_/B VGND VGND VPWR VPWR _4283_/A sky130_fd_sc_hd__and2_2
XFILLER_101_729 VGND VGND VPWR VPWR sky130_fd_sc_hd__decap_3
XFILLER_86_407 VGND VGND VPWR VPWR sky130_fd_sc_hd__decap_3
XFILLER_98_278 VGND VGND VPWR VPWR sky130_fd_sc_hd__decap_3
X_6021_ _6021_/A VGND VGND VPWR VPWR _6021_/Y sky130_fd_sc_hd__inv_2
XFILLER_100_239 VGND VGND VPWR VPWR sky130_fd_sc_hd__decap_3
XFILLER_67_632 VGND VGND VPWR VPWR sky130_fd_sc_hd__decap_3
XFILLER_104_29 VGND VGND VPWR VPWR sky130_fd_sc_hd__decap_3
XFILLER_39_345 VGND VGND VPWR VPWR sky130_fd_sc_hd__decap_3
XFILLER_67_676 VGND VGND VPWR VPWR sky130_fd_sc_hd__decap_3
XFILLER_94_462 VGND VGND VPWR VPWR sky130_fd_sc_hd__decap_3
XFILLER_54_315 VGND VGND VPWR VPWR sky130_fd_sc_hd__decap_3
XFILLER_66_164 VGND VGND VPWR VPWR sky130_fd_sc_hd__fill_1
XFILLER_66_186 VGND VGND VPWR VPWR sky130_fd_sc_hd__decap_3
XFILLER_81_101 VGND VGND VPWR VPWR sky130_fd_sc_hd__decap_3
XFILLER_82_624 VGND VGND VPWR VPWR sky130_fd_sc_hd__decap_3
XFILLER_94_495 VGND VGND VPWR VPWR sky130_fd_sc_hd__decap_3
X_7972_ _8379_/CLK _7972_/D VGND VGND VPWR VPWR _7972_/Q sky130_fd_sc_hd__dfxtp_2
XTAP_TAPCELL_ROW_68_1138 VGND VPWR sky130_fd_sc_hd__tapvpwrvgnd_1
XFILLER_54_359 VGND VGND VPWR VPWR sky130_fd_sc_hd__decap_3
XFILLER_66_197 VGND VGND VPWR VPWR sky130_fd_sc_hd__decap_3
XFILLER_81_134 VGND VGND VPWR VPWR sky130_fd_sc_hd__decap_3
XFILLER_82_657 VGND VGND VPWR VPWR sky130_fd_sc_hd__decap_3
XFILLER_82_679 VGND VGND VPWR VPWR sky130_fd_sc_hd__decap_3
X_6923_ _6109_/A _6922_/X _6787_/A VGND VGND VPWR VPWR _6923_/Y sky130_fd_sc_hd__o21ai_2
XTAP_TAPCELL_ROW_68_1149 VGND VPWR sky130_fd_sc_hd__tapvpwrvgnd_1
XFILLER_35_573 VGND VGND VPWR VPWR sky130_fd_sc_hd__decap_3
XFILLER_81_167 VGND VGND VPWR VPWR sky130_fd_sc_hd__fill_1
XTAP_TAPCELL_ROW_81_1316 VGND VPWR sky130_fd_sc_hd__tapvpwrvgnd_1
X_6854_ _8197_/Q _8198_/Q _6899_/A VGND VGND VPWR VPWR _6854_/X sky130_fd_sc_hd__and3_2
XFILLER_22_245 VGND VGND VPWR VPWR sky130_fd_sc_hd__decap_3
XFILLER_22_256 VGND VGND VPWR VPWR sky130_fd_sc_hd__decap_3
X_6785_ _7825_/A _6783_/X _6784_/X _5464_/A VGND VGND VPWR VPWR _6785_/X sky130_fd_sc_hd__o211a_2
X_5805_ _6184_/B VGND VGND VPWR VPWR _5805_/X sky130_fd_sc_hd__clkbuf_1
X_3997_ _3997_/A VGND VGND VPWR VPWR _7947_/D sky130_fd_sc_hd__buf_1
XFILLER_22_278 VGND VGND VPWR VPWR sky130_fd_sc_hd__decap_3
XFILLER_50_587 VGND VGND VPWR VPWR sky130_fd_sc_hd__fill_1
X_5736_ _7783_/B _5728_/Y _5730_/Y _5735_/X VGND VGND VPWR VPWR _5736_/X sky130_fd_sc_hd__o31a_2
X_5667_ _6804_/A _5662_/X _5664_/X _5966_/A _5886_/A VGND VGND VPWR VPWR _5667_/X
+ sky130_fd_sc_hd__o221a_2
XFILLER_108_339 VGND VGND VPWR VPWR sky130_fd_sc_hd__fill_1
X_7406_ _4769_/B _7370_/B _7370_/C _8215_/Q VGND VGND VPWR VPWR _7407_/C sky130_fd_sc_hd__a31o_2
X_4618_ _7898_/B _8113_/Q VGND VGND VPWR VPWR _4619_/A sky130_fd_sc_hd__and2_2
X_8386_ _8386_/CLK _8386_/D VGND VGND VPWR VPWR _8386_/Q sky130_fd_sc_hd__dfxtp_2
X_5598_ _6086_/A _8290_/Q _6686_/A _5598_/D VGND VGND VPWR VPWR _5598_/X sky130_fd_sc_hd__and4_2
XTAP_TAPCELL_ROW_79_1289 VGND VPWR sky130_fd_sc_hd__tapvpwrvgnd_1
XFILLER_116_383 VGND VGND VPWR VPWR sky130_fd_sc_hd__decap_3
X_7337_ _8277_/Q _7338_/B VGND VGND VPWR VPWR _7337_/X sky130_fd_sc_hd__or2_4
X_4549_ _4549_/A VGND VGND VPWR VPWR _8212_/D sky130_fd_sc_hd__buf_1
XFILLER_104_556 VGND VGND VPWR VPWR sky130_fd_sc_hd__fill_2
XFILLER_89_223 VGND VGND VPWR VPWR sky130_fd_sc_hd__fill_1
XFILLER_89_234 VGND VGND VPWR VPWR sky130_fd_sc_hd__decap_3
X_7268_ _7230_/X _8211_/Q _7265_/X _8210_/Q _7267_/Y VGND VGND VPWR VPWR _7274_/A
+ sky130_fd_sc_hd__a221o_2
XTAP_TAPCELL_ROW_92_1456 VGND VPWR sky130_fd_sc_hd__tapvpwrvgnd_1
X_6219_ _6219_/A _6219_/B VGND VGND VPWR VPWR _6219_/Y sky130_fd_sc_hd__xnor2_2
XFILLER_58_632 VGND VGND VPWR VPWR sky130_fd_sc_hd__fill_2
X_7199_ _8209_/Q _8208_/Q _7228_/B _8206_/Q _7796_/A _7812_/A VGND VGND VPWR VPWR
+ _7199_/X sky130_fd_sc_hd__mux4_2
XFILLER_18_507 VGND VGND VPWR VPWR sky130_fd_sc_hd__decap_3
XFILLER_38_67 VGND VGND VPWR VPWR sky130_fd_sc_hd__decap_3
XFILLER_57_131 VGND VGND VPWR VPWR sky130_fd_sc_hd__decap_3
XFILLER_85_440 VGND VGND VPWR VPWR sky130_fd_sc_hd__decap_3
XFILLER_57_175 VGND VGND VPWR VPWR sky130_fd_sc_hd__decap_3
XFILLER_72_101 VGND VGND VPWR VPWR sky130_fd_sc_hd__decap_3
XFILLER_85_495 VGND VGND VPWR VPWR sky130_fd_sc_hd__decap_3
XFILLER_45_337 VGND VGND VPWR VPWR sky130_fd_sc_hd__fill_2
XFILLER_73_679 VGND VGND VPWR VPWR sky130_fd_sc_hd__decap_3
XFILLER_14_724 VGND VGND VPWR VPWR sky130_fd_sc_hd__decap_3
XFILLER_26_573 VGND VGND VPWR VPWR sky130_fd_sc_hd__fill_1
XFILLER_54_44 VGND VGND VPWR VPWR sky130_fd_sc_hd__decap_3
XFILLER_60_307 VGND VGND VPWR VPWR sky130_fd_sc_hd__fill_1
XFILLER_72_156 VGND VGND VPWR VPWR sky130_fd_sc_hd__decap_3
XFILLER_72_178 VGND VGND VPWR VPWR sky130_fd_sc_hd__decap_3
XFILLER_13_212 VGND VGND VPWR VPWR sky130_fd_sc_hd__decap_3
XFILLER_54_77 VGND VGND VPWR VPWR sky130_fd_sc_hd__decap_3
XFILLER_13_256 VGND VGND VPWR VPWR sky130_fd_sc_hd__decap_3
XFILLER_70_32 VGND VGND VPWR VPWR sky130_fd_sc_hd__decap_3
XFILLER_9_238 VGND VGND VPWR VPWR sky130_fd_sc_hd__decap_3
XTAP_TAPCELL_ROW_101_1574 VGND VPWR sky130_fd_sc_hd__tapvpwrvgnd_1
XTAP_TAPCELL_ROW_11_402 VGND VPWR sky130_fd_sc_hd__tapvpwrvgnd_1
XFILLER_70_65 VGND VGND VPWR VPWR sky130_fd_sc_hd__decap_3
Xclkload19 _8389_/CLK VGND VGND VPWR VPWR clkload19/X sky130_fd_sc_hd__clkbuf_4
XFILLER_5_455 VGND VGND VPWR VPWR sky130_fd_sc_hd__decap_3
XFILLER_107_361 VGND VGND VPWR VPWR sky130_fd_sc_hd__decap_3
XFILLER_107_372 VGND VGND VPWR VPWR sky130_fd_sc_hd__decap_3
XFILLER_5_477 VGND VGND VPWR VPWR sky130_fd_sc_hd__decap_3
XFILLER_79_63 VGND VGND VPWR VPWR sky130_fd_sc_hd__fill_2
XFILLER_110_515 VGND VGND VPWR VPWR sky130_fd_sc_hd__decap_3
XFILLER_68_418 VGND VGND VPWR VPWR sky130_fd_sc_hd__fill_2
XFILLER_95_204 VGND VGND VPWR VPWR sky130_fd_sc_hd__decap_3
XFILLER_110_548 VGND VGND VPWR VPWR sky130_fd_sc_hd__decap_3
XFILLER_1_694 VGND VGND VPWR VPWR sky130_fd_sc_hd__decap_3
XFILLER_49_643 VGND VGND VPWR VPWR sky130_fd_sc_hd__decap_3
XFILLER_95_248 VGND VGND VPWR VPWR sky130_fd_sc_hd__decap_3
XFILLER_48_120 VGND VGND VPWR VPWR sky130_fd_sc_hd__decap_3
XFILLER_76_462 VGND VGND VPWR VPWR sky130_fd_sc_hd__decap_3
XFILLER_95_51 VGND VGND VPWR VPWR sky130_fd_sc_hd__decap_3
XFILLER_95_84 VGND VGND VPWR VPWR sky130_fd_sc_hd__decap_3
XFILLER_36_315 VGND VGND VPWR VPWR sky130_fd_sc_hd__decap_3
XFILLER_63_101 VGND VGND VPWR VPWR sky130_fd_sc_hd__decap_3
XFILLER_64_624 VGND VGND VPWR VPWR sky130_fd_sc_hd__decap_3
XTAP_TAPCELL_ROW_19_502 VGND VPWR sky130_fd_sc_hd__tapvpwrvgnd_1
XFILLER_36_348 VGND VGND VPWR VPWR sky130_fd_sc_hd__decap_3
XFILLER_63_134 VGND VGND VPWR VPWR sky130_fd_sc_hd__decap_3
XFILLER_64_657 VGND VGND VPWR VPWR sky130_fd_sc_hd__decap_3
XTAP_TAPCELL_ROW_47_866 VGND VPWR sky130_fd_sc_hd__tapvpwrvgnd_1
XFILLER_91_476 VGND VGND VPWR VPWR sky130_fd_sc_hd__decap_3
XFILLER_17_584 VGND VGND VPWR VPWR sky130_fd_sc_hd__decap_3
XFILLER_44_392 VGND VGND VPWR VPWR sky130_fd_sc_hd__decap_3
XFILLER_32_576 VGND VGND VPWR VPWR sky130_fd_sc_hd__decap_3
XFILLER_32_598 VGND VGND VPWR VPWR sky130_fd_sc_hd__decap_3
XFILLER_81_3 VGND VGND VPWR VPWR sky130_fd_sc_hd__fill_2
X_6570_ _8191_/Q _6605_/B VGND VGND VPWR VPWR _6570_/Y sky130_fd_sc_hd__xnor2_2
XTAP_TAPCELL_ROW_63_1079 VGND VPWR sky130_fd_sc_hd__tapvpwrvgnd_1
XTAP_TAPCELL_ROW_119_1802 VGND VPWR sky130_fd_sc_hd__tapvpwrvgnd_1
XTAP_TAPCELL_ROW_119_1813 VGND VPWR sky130_fd_sc_hd__tapvpwrvgnd_1
XTAP_TAPCELL_ROW_119_1824 VGND VPWR sky130_fd_sc_hd__tapvpwrvgnd_1
X_5521_ _5234_/X _5215_/X _7623_/S VGND VGND VPWR VPWR _5521_/X sky130_fd_sc_hd__mux2_2
XFILLER_117_125 VGND VGND VPWR VPWR sky130_fd_sc_hd__decap_3
X_8240_ _8379_/CLK _8240_/D VGND VGND VPWR VPWR _8240_/Q sky130_fd_sc_hd__dfxtp_2
XFILLER_8_293 VGND VGND VPWR VPWR sky130_fd_sc_hd__decap_3
X_5452_ _5232_/X _5214_/X _5452_/S VGND VGND VPWR VPWR _5452_/X sky130_fd_sc_hd__mux2_2
XFILLER_117_169 VGND VGND VPWR VPWR sky130_fd_sc_hd__decap_3
X_8171_ clkload9/A _8171_/D VGND VGND VPWR VPWR _8171_/Q sky130_fd_sc_hd__dfxtp_4
X_5383_ _6024_/A _6024_/B _5484_/S VGND VGND VPWR VPWR _5383_/X sky130_fd_sc_hd__mux2_2
X_4403_ _4403_/A VGND VGND VPWR VPWR _8139_/D sky130_fd_sc_hd__buf_1
XFILLER_99_543 VGND VGND VPWR VPWR sky130_fd_sc_hd__decap_3
X_7122_ _7193_/A _7122_/B VGND VGND VPWR VPWR _7122_/Y sky130_fd_sc_hd__nand2_2
X_4334_ _7898_/B _4334_/B VGND VGND VPWR VPWR _4335_/A sky130_fd_sc_hd__and2_2
XFILLER_113_364 VGND VGND VPWR VPWR sky130_fd_sc_hd__decap_3
XFILLER_59_429 VGND VGND VPWR VPWR sky130_fd_sc_hd__decap_3
XFILLER_87_705 VGND VGND VPWR VPWR sky130_fd_sc_hd__decap_3
X_7053_ _8270_/Q _5601_/A _5400_/X VGND VGND VPWR VPWR _7053_/X sky130_fd_sc_hd__o21a_2
XFILLER_101_526 VGND VGND VPWR VPWR sky130_fd_sc_hd__decap_3
XFILLER_113_386 VGND VGND VPWR VPWR sky130_fd_sc_hd__decap_3
XFILLER_115_39 VGND VGND VPWR VPWR sky130_fd_sc_hd__decap_3
XFILLER_86_248 VGND VGND VPWR VPWR sky130_fd_sc_hd__decap_3
X_6004_ _6003_/B _6003_/C _6003_/A VGND VGND VPWR VPWR _6004_/Y sky130_fd_sc_hd__a21oi_2
X_4265_ _4265_/A VGND VGND VPWR VPWR _8070_/D sky130_fd_sc_hd__buf_1
XFILLER_101_559 VGND VGND VPWR VPWR sky130_fd_sc_hd__fill_1
XFILLER_39_142 VGND VGND VPWR VPWR sky130_fd_sc_hd__decap_3
XFILLER_55_602 VGND VGND VPWR VPWR sky130_fd_sc_hd__decap_3
X_4196_ _7898_/B input7/X VGND VGND VPWR VPWR _4197_/A sky130_fd_sc_hd__and2_2
XFILLER_27_326 VGND VGND VPWR VPWR sky130_fd_sc_hd__decap_3
XFILLER_82_410 VGND VGND VPWR VPWR sky130_fd_sc_hd__decap_3
XFILLER_27_337 VGND VGND VPWR VPWR sky130_fd_sc_hd__decap_3
XFILLER_82_421 VGND VGND VPWR VPWR sky130_fd_sc_hd__decap_3
XFILLER_82_454 VGND VGND VPWR VPWR sky130_fd_sc_hd__decap_3
X_7955_ _8398_/CLK _7955_/D VGND VGND VPWR VPWR _7955_/Q sky130_fd_sc_hd__dfxtp_2
XFILLER_24_14 VGND VGND VPWR VPWR sky130_fd_sc_hd__fill_2
XFILLER_35_370 VGND VGND VPWR VPWR sky130_fd_sc_hd__decap_3
XFILLER_42_329 VGND VGND VPWR VPWR sky130_fd_sc_hd__decap_3
XFILLER_54_189 VGND VGND VPWR VPWR sky130_fd_sc_hd__decap_3
X_7886_ _8313_/Q _7898_/B VGND VGND VPWR VPWR _7887_/A sky130_fd_sc_hd__and2_2
X_6906_ _8264_/Q _6880_/X _8200_/Q VGND VGND VPWR VPWR _6906_/X sky130_fd_sc_hd__a21o_2
XFILLER_11_705 VGND VGND VPWR VPWR sky130_fd_sc_hd__decap_3
XFILLER_50_351 VGND VGND VPWR VPWR sky130_fd_sc_hd__decap_3
X_6837_ _8195_/Q _8196_/Q _8197_/Q _8198_/Q VGND VGND VPWR VPWR _6838_/D sky130_fd_sc_hd__nor4_2
XFILLER_10_204 VGND VGND VPWR VPWR sky130_fd_sc_hd__decap_3
XFILLER_11_727 VGND VGND VPWR VPWR sky130_fd_sc_hd__fill_1
XFILLER_23_576 VGND VGND VPWR VPWR sky130_fd_sc_hd__decap_3
XFILLER_23_598 VGND VGND VPWR VPWR sky130_fd_sc_hd__decap_3
XFILLER_109_604 VGND VGND VPWR VPWR sky130_fd_sc_hd__decap_3
X_6768_ _6767_/Y _5076_/Y _8197_/Q VGND VGND VPWR VPWR _6769_/C sky130_fd_sc_hd__mux2_2
X_6699_ _6999_/A1 _6697_/X _6698_/X VGND VGND VPWR VPWR _6699_/X sky130_fd_sc_hd__a21o_2
X_5719_ _7783_/B VGND VGND VPWR VPWR _5719_/Y sky130_fd_sc_hd__inv_2
XFILLER_108_147 VGND VGND VPWR VPWR sky130_fd_sc_hd__decap_3
X_8369_ _8384_/CLK _8369_/D VGND VGND VPWR VPWR _8369_/Q sky130_fd_sc_hd__dfxtp_2
XFILLER_2_469 VGND VGND VPWR VPWR sky130_fd_sc_hd__fill_1
XFILLER_49_55 VGND VGND VPWR VPWR sky130_fd_sc_hd__fill_1
XFILLER_104_397 VGND VGND VPWR VPWR sky130_fd_sc_hd__decap_3
XFILLER_49_66 VGND VGND VPWR VPWR sky130_fd_sc_hd__decap_3
XFILLER_49_88 VGND VGND VPWR VPWR sky130_fd_sc_hd__fill_2
XFILLER_77_215 VGND VGND VPWR VPWR sky130_fd_sc_hd__decap_3
XFILLER_93_719 VGND VGND VPWR VPWR sky130_fd_sc_hd__decap_3
XFILLER_100_570 VGND VGND VPWR VPWR sky130_fd_sc_hd__decap_3
XFILLER_105_72 VGND VGND VPWR VPWR sky130_fd_sc_hd__decap_3
XFILLER_18_304 VGND VGND VPWR VPWR sky130_fd_sc_hd__decap_3
XFILLER_45_101 VGND VGND VPWR VPWR sky130_fd_sc_hd__fill_2
XFILLER_45_145 VGND VGND VPWR VPWR sky130_fd_sc_hd__decap_3
XFILLER_73_421 VGND VGND VPWR VPWR sky130_fd_sc_hd__decap_3
XFILLER_85_281 VGND VGND VPWR VPWR sky130_fd_sc_hd__decap_3
XFILLER_33_318 VGND VGND VPWR VPWR sky130_fd_sc_hd__decap_3
XFILLER_65_87 VGND VGND VPWR VPWR sky130_fd_sc_hd__decap_3
XFILLER_73_476 VGND VGND VPWR VPWR sky130_fd_sc_hd__decap_3
XFILLER_14_510 VGND VGND VPWR VPWR sky130_fd_sc_hd__decap_3
XFILLER_26_381 VGND VGND VPWR VPWR sky130_fd_sc_hd__decap_3
XFILLER_26_392 VGND VGND VPWR VPWR sky130_fd_sc_hd__decap_3
XFILLER_54_690 VGND VGND VPWR VPWR sky130_fd_sc_hd__fill_1
XFILLER_60_137 VGND VGND VPWR VPWR sky130_fd_sc_hd__decap_3
XFILLER_61_638 VGND VGND VPWR VPWR sky130_fd_sc_hd__decap_3
XFILLER_81_20 VGND VGND VPWR VPWR sky130_fd_sc_hd__decap_3
XTAP_TAPCELL_ROW_103_1603 VGND VPWR sky130_fd_sc_hd__tapvpwrvgnd_1
XTAP_TAPCELL_ROW_44_836 VGND VPWR sky130_fd_sc_hd__tapvpwrvgnd_1
XTAP_TAPCELL_ROW_44_825 VGND VPWR sky130_fd_sc_hd__tapvpwrvgnd_1
XFILLER_41_340 VGND VGND VPWR VPWR sky130_fd_sc_hd__decap_3
XFILLER_60_159 VGND VGND VPWR VPWR sky130_fd_sc_hd__decap_3
XFILLER_14_576 VGND VGND VPWR VPWR sky130_fd_sc_hd__decap_3
XFILLER_14_598 VGND VGND VPWR VPWR sky130_fd_sc_hd__decap_3
XFILLER_41_362 VGND VGND VPWR VPWR sky130_fd_sc_hd__decap_3
XFILLER_81_75 VGND VGND VPWR VPWR sky130_fd_sc_hd__fill_1
XTAP_TAPCELL_ROW_24_571 VGND VPWR sky130_fd_sc_hd__tapvpwrvgnd_1
XFILLER_108_681 VGND VGND VPWR VPWR sky130_fd_sc_hd__decap_3
XFILLER_5_296 VGND VGND VPWR VPWR sky130_fd_sc_hd__fill_2
XTAP_TAPCELL_ROW_114_1743 VGND VPWR sky130_fd_sc_hd__tapvpwrvgnd_1
XFILLER_68_215 VGND VGND VPWR VPWR sky130_fd_sc_hd__fill_2
XFILLER_96_524 VGND VGND VPWR VPWR sky130_fd_sc_hd__decap_3
XFILLER_110_345 VGND VGND VPWR VPWR sky130_fd_sc_hd__decap_3
XFILLER_68_248 VGND VGND VPWR VPWR sky130_fd_sc_hd__decap_3
XFILLER_96_568 VGND VGND VPWR VPWR sky130_fd_sc_hd__decap_3
XFILLER_96_579 VGND VGND VPWR VPWR sky130_fd_sc_hd__decap_3
X_4050_ _7930_/B _8366_/Q VGND VGND VPWR VPWR _4051_/A sky130_fd_sc_hd__and2_2
XFILLER_37_624 VGND VGND VPWR VPWR sky130_fd_sc_hd__decap_3
XFILLER_49_473 VGND VGND VPWR VPWR sky130_fd_sc_hd__decap_3
XFILLER_76_270 VGND VGND VPWR VPWR sky130_fd_sc_hd__decap_3
Xinput6 operand_a[0] VGND VGND VPWR VPWR input6/X sky130_fd_sc_hd__clkdlybuf4s25_1
XFILLER_64_421 VGND VGND VPWR VPWR sky130_fd_sc_hd__decap_3
XFILLER_64_443 VGND VGND VPWR VPWR sky130_fd_sc_hd__decap_3
XFILLER_36_156 VGND VGND VPWR VPWR sky130_fd_sc_hd__decap_3
XFILLER_36_178 VGND VGND VPWR VPWR sky130_fd_sc_hd__decap_3
XFILLER_64_465 VGND VGND VPWR VPWR sky130_fd_sc_hd__fill_1
XFILLER_91_251 VGND VGND VPWR VPWR sky130_fd_sc_hd__decap_3
XTAP_TAPCELL_ROW_65_1108 VGND VPWR sky130_fd_sc_hd__tapvpwrvgnd_1
XFILLER_17_381 VGND VGND VPWR VPWR sky130_fd_sc_hd__decap_3
XFILLER_51_137 VGND VGND VPWR VPWR sky130_fd_sc_hd__decap_3
XFILLER_52_649 VGND VGND VPWR VPWR sky130_fd_sc_hd__decap_3
XFILLER_64_498 VGND VGND VPWR VPWR sky130_fd_sc_hd__decap_3
X_7740_ _7812_/A _7736_/X _7739_/X VGND VGND VPWR VPWR _7740_/Y sky130_fd_sc_hd__a21oi_2
X_4952_ _8164_/Q _6620_/A VGND VGND VPWR VPWR _5651_/A sky130_fd_sc_hd__or2b_2
X_7671_ _7671_/A VGND VGND VPWR VPWR _7672_/A sky130_fd_sc_hd__buf_1
X_4883_ _8186_/Q VGND VGND VPWR VPWR _6378_/S sky130_fd_sc_hd__inv_2
XFILLER_20_502 VGND VGND VPWR VPWR sky130_fd_sc_hd__decap_3
XFILLER_32_384 VGND VGND VPWR VPWR sky130_fd_sc_hd__decap_3
X_6622_ _8192_/Q _8256_/Q _6621_/X VGND VGND VPWR VPWR _6622_/X sky130_fd_sc_hd__a21o_2
XFILLER_20_579 VGND VGND VPWR VPWR sky130_fd_sc_hd__decap_3
XFILLER_9_580 VGND VGND VPWR VPWR sky130_fd_sc_hd__decap_3
X_6553_ _8190_/Q VGND VGND VPWR VPWR _6794_/A sky130_fd_sc_hd__inv_2
X_6484_ _6592_/A _6484_/B VGND VGND VPWR VPWR _6484_/Y sky130_fd_sc_hd__xnor2_2
X_5504_ _6707_/S _8163_/Q _5491_/C _6706_/S VGND VGND VPWR VPWR _5504_/X sky130_fd_sc_hd__a211o_2
X_8223_ _8229_/CLK _8223_/D VGND VGND VPWR VPWR _8223_/Q sky130_fd_sc_hd__dfxtp_2
X_5435_ _5435_/A VGND VGND VPWR VPWR _5714_/A sky130_fd_sc_hd__clkbuf_1
XTAP_TAPCELL_ROW_76_1248 VGND VPWR sky130_fd_sc_hd__tapvpwrvgnd_1
XFILLER_105_139 VGND VGND VPWR VPWR sky130_fd_sc_hd__decap_3
XFILLER_10_38 VGND VGND VPWR VPWR sky130_fd_sc_hd__fill_2
XFILLER_10_49 VGND VGND VPWR VPWR sky130_fd_sc_hd__decap_3
XFILLER_114_640 VGND VGND VPWR VPWR sky130_fd_sc_hd__decap_3
XFILLER_114_651 VGND VGND VPWR VPWR sky130_fd_sc_hd__decap_3
XFILLER_59_204 VGND VGND VPWR VPWR sky130_fd_sc_hd__decap_3
XFILLER_99_340 VGND VGND VPWR VPWR sky130_fd_sc_hd__decap_3
X_8154_ clkload6/A _8154_/D VGND VGND VPWR VPWR _8154_/Q sky130_fd_sc_hd__dfxtp_2
X_5366_ _5366_/A VGND VGND VPWR VPWR _5366_/Y sky130_fd_sc_hd__inv_2
XFILLER_87_535 VGND VGND VPWR VPWR sky130_fd_sc_hd__decap_3
XFILLER_99_373 VGND VGND VPWR VPWR sky130_fd_sc_hd__decap_3
X_8085_ _8226_/CLK _8085_/D VGND VGND VPWR VPWR _8085_/Q sky130_fd_sc_hd__dfxtp_2
X_7105_ _8207_/Q _8271_/Q _7619_/A VGND VGND VPWR VPWR _7105_/X sky130_fd_sc_hd__o21a_2
X_5297_ _6763_/B _5415_/A VGND VGND VPWR VPWR _7610_/B sky130_fd_sc_hd__nor2_2
X_4317_ _4317_/A VGND VGND VPWR VPWR _8096_/D sky130_fd_sc_hd__buf_1
XFILLER_59_248 VGND VGND VPWR VPWR sky130_fd_sc_hd__decap_3
XFILLER_87_557 VGND VGND VPWR VPWR sky130_fd_sc_hd__decap_3
X_7036_ _7159_/A _6767_/Y _7035_/X _7631_/A VGND VGND VPWR VPWR _7036_/X sky130_fd_sc_hd__o22a_2
X_4248_ _7898_/B _4248_/B VGND VGND VPWR VPWR _4249_/A sky130_fd_sc_hd__and2_2
XFILLER_19_69 VGND VGND VPWR VPWR sky130_fd_sc_hd__fill_1
XFILLER_28_624 VGND VGND VPWR VPWR sky130_fd_sc_hd__decap_3
XFILLER_67_270 VGND VGND VPWR VPWR sky130_fd_sc_hd__fill_1
XFILLER_74_218 VGND VGND VPWR VPWR sky130_fd_sc_hd__decap_3
XFILLER_67_292 VGND VGND VPWR VPWR sky130_fd_sc_hd__fill_1
XFILLER_95_590 VGND VGND VPWR VPWR sky130_fd_sc_hd__decap_3
X_4179_ _4179_/A VGND VGND VPWR VPWR _8027_/D sky130_fd_sc_hd__buf_1
XFILLER_27_145 VGND VGND VPWR VPWR sky130_fd_sc_hd__decap_3
XFILLER_35_24 VGND VGND VPWR VPWR sky130_fd_sc_hd__decap_3
XTAP_TAPCELL_ROW_2_288 VGND VPWR sky130_fd_sc_hd__tapvpwrvgnd_1
XFILLER_15_318 VGND VGND VPWR VPWR sky130_fd_sc_hd__decap_3
XFILLER_35_35 VGND VGND VPWR VPWR sky130_fd_sc_hd__decap_3
XFILLER_35_57 VGND VGND VPWR VPWR sky130_fd_sc_hd__decap_3
XFILLER_55_487 VGND VGND VPWR VPWR sky130_fd_sc_hd__fill_1
XFILLER_70_413 VGND VGND VPWR VPWR sky130_fd_sc_hd__decap_3
XFILLER_82_295 VGND VGND VPWR VPWR sky130_fd_sc_hd__decap_3
X_7938_ _8352_/CLK _7938_/D VGND VGND VPWR VPWR _7938_/Q sky130_fd_sc_hd__dfxtp_2
XTAP_TAPCELL_ROW_87_1388 VGND VPWR sky130_fd_sc_hd__tapvpwrvgnd_1
XFILLER_23_340 VGND VGND VPWR VPWR sky130_fd_sc_hd__decap_3
XFILLER_42_159 VGND VGND VPWR VPWR sky130_fd_sc_hd__fill_2
XFILLER_23_362 VGND VGND VPWR VPWR sky130_fd_sc_hd__decap_3
XFILLER_51_671 VGND VGND VPWR VPWR sky130_fd_sc_hd__fill_1
XFILLER_51_682 VGND VGND VPWR VPWR sky130_fd_sc_hd__fill_1
X_7869_ _7869_/A VGND VGND VPWR VPWR _8371_/D sky130_fd_sc_hd__buf_1
XFILLER_51_23 VGND VGND VPWR VPWR sky130_fd_sc_hd__decap_3
XFILLER_51_45 VGND VGND VPWR VPWR sky130_fd_sc_hd__decap_3
XPHY_EDGE_ROW_14_Right_14 VGND VGND VPWR VPWR sky130_fd_sc_hd__decap_3
XTAP_TAPCELL_ROW_21_530 VGND VPWR sky130_fd_sc_hd__tapvpwrvgnd_1
XFILLER_109_412 VGND VGND VPWR VPWR sky130_fd_sc_hd__decap_3
XFILLER_109_434 VGND VGND VPWR VPWR sky130_fd_sc_hd__decap_3
XFILLER_109_456 VGND VGND VPWR VPWR sky130_fd_sc_hd__decap_3
XFILLER_105_673 VGND VGND VPWR VPWR sky130_fd_sc_hd__decap_3
XFILLER_78_502 VGND VGND VPWR VPWR sky130_fd_sc_hd__decap_3
XFILLER_104_150 VGND VGND VPWR VPWR sky130_fd_sc_hd__decap_3
XFILLER_105_684 VGND VGND VPWR VPWR sky130_fd_sc_hd__decap_3
XFILLER_116_60 VGND VGND VPWR VPWR sky130_fd_sc_hd__decap_3
XPHY_EDGE_ROW_23_Right_23 VGND VGND VPWR VPWR sky130_fd_sc_hd__decap_3
XFILLER_93_505 VGND VGND VPWR VPWR sky130_fd_sc_hd__decap_3
XFILLER_19_613 VGND VGND VPWR VPWR sky130_fd_sc_hd__decap_3
XFILLER_76_53 VGND VGND VPWR VPWR sky130_fd_sc_hd__decap_3
XFILLER_93_538 VGND VGND VPWR VPWR sky130_fd_sc_hd__decap_3
XFILLER_18_123 VGND VGND VPWR VPWR sky130_fd_sc_hd__decap_3
XFILLER_19_657 VGND VGND VPWR VPWR sky130_fd_sc_hd__decap_3
XFILLER_46_421 VGND VGND VPWR VPWR sky130_fd_sc_hd__decap_3
XFILLER_58_292 VGND VGND VPWR VPWR sky130_fd_sc_hd__decap_3
XTAP_TAPCELL_ROW_29_630 VGND VPWR sky130_fd_sc_hd__tapvpwrvgnd_1
XFILLER_19_679 VGND VGND VPWR VPWR sky130_fd_sc_hd__decap_3
XFILLER_46_454 VGND VGND VPWR VPWR sky130_fd_sc_hd__decap_3
XFILLER_61_402 VGND VGND VPWR VPWR sky130_fd_sc_hd__decap_3
XFILLER_73_251 VGND VGND VPWR VPWR sky130_fd_sc_hd__decap_3
XTAP_TAPCELL_ROW_29_641 VGND VPWR sky130_fd_sc_hd__tapvpwrvgnd_1
XFILLER_61_435 VGND VGND VPWR VPWR sky130_fd_sc_hd__decap_3
XFILLER_73_273 VGND VGND VPWR VPWR sky130_fd_sc_hd__decap_3
XFILLER_73_284 VGND VGND VPWR VPWR sky130_fd_sc_hd__decap_3
XFILLER_92_52 VGND VGND VPWR VPWR sky130_fd_sc_hd__fill_2
XFILLER_92_63 VGND VGND VPWR VPWR sky130_fd_sc_hd__decap_3
XTAP_TAPCELL_ROW_57_994 VGND VPWR sky130_fd_sc_hd__tapvpwrvgnd_1
XFILLER_33_159 VGND VGND VPWR VPWR sky130_fd_sc_hd__decap_3
XFILLER_61_479 VGND VGND VPWR VPWR sky130_fd_sc_hd__decap_3
XPHY_EDGE_ROW_32_Right_32 VGND VGND VPWR VPWR sky130_fd_sc_hd__decap_3
XFILLER_42_682 VGND VGND VPWR VPWR sky130_fd_sc_hd__fill_2
XFILLER_42_693 VGND VGND VPWR VPWR sky130_fd_sc_hd__fill_1
XTAP_TAPCELL_ROW_60_1038 VGND VPWR sky130_fd_sc_hd__tapvpwrvgnd_1
XFILLER_6_583 VGND VGND VPWR VPWR sky130_fd_sc_hd__fill_1
X_5220_ _6321_/B _5220_/B VGND VGND VPWR VPWR _5220_/Y sky130_fd_sc_hd__nor2_2
XPHY_EDGE_ROW_41_Right_41 VGND VGND VPWR VPWR sky130_fd_sc_hd__decap_3
XFILLER_69_535 VGND VGND VPWR VPWR sky130_fd_sc_hd__decap_3
X_5151_ _5147_/X _5150_/X _5684_/S VGND VGND VPWR VPWR _5151_/X sky130_fd_sc_hd__mux2_2
XFILLER_69_579 VGND VGND VPWR VPWR sky130_fd_sc_hd__fill_2
XFILLER_96_354 VGND VGND VPWR VPWR sky130_fd_sc_hd__decap_3
X_5082_ _7619_/A VGND VGND VPWR VPWR _5107_/A sky130_fd_sc_hd__inv_2
X_4102_ _7930_/B _8392_/Q VGND VGND VPWR VPWR _4103_/A sky130_fd_sc_hd__and2_2
XTAP_TAPCELL_ROW_71_1178 VGND VPWR sky130_fd_sc_hd__tapvpwrvgnd_1
XFILLER_110_153 VGND VGND VPWR VPWR sky130_fd_sc_hd__decap_3
XFILLER_111_676 VGND VGND VPWR VPWR sky130_fd_sc_hd__fill_1
XFILLER_56_218 VGND VGND VPWR VPWR sky130_fd_sc_hd__decap_3
XFILLER_84_527 VGND VGND VPWR VPWR sky130_fd_sc_hd__decap_3
XFILLER_96_365 VGND VGND VPWR VPWR sky130_fd_sc_hd__decap_3
XPHY_EDGE_ROW_16_Left_136 VGND VGND VPWR VPWR sky130_fd_sc_hd__decap_3
X_4033_ _4033_/A _4033_/B _4033_/C VGND VGND VPWR VPWR _7954_/D sky130_fd_sc_hd__nor3_2
XFILLER_110_197 VGND VGND VPWR VPWR sky130_fd_sc_hd__decap_3
XFILLER_2_83 VGND VGND VPWR VPWR sky130_fd_sc_hd__fill_1
XFILLER_2_94 VGND VGND VPWR VPWR sky130_fd_sc_hd__decap_3
XFILLER_49_281 VGND VGND VPWR VPWR sky130_fd_sc_hd__decap_3
XFILLER_112_29 VGND VGND VPWR VPWR sky130_fd_sc_hd__fill_1
XFILLER_52_424 VGND VGND VPWR VPWR sky130_fd_sc_hd__decap_3
XFILLER_64_273 VGND VGND VPWR VPWR sky130_fd_sc_hd__decap_3
XPHY_EDGE_ROW_50_Right_50 VGND VGND VPWR VPWR sky130_fd_sc_hd__decap_3
XFILLER_24_159 VGND VGND VPWR VPWR sky130_fd_sc_hd__decap_3
X_7723_ _7812_/A _8209_/Q _7820_/B VGND VGND VPWR VPWR _7723_/X sky130_fd_sc_hd__and3_2
X_5984_ _6024_/B _6024_/A _8173_/Q _8172_/Q _5678_/S _6199_/S1 VGND VGND VPWR VPWR
+ _5984_/X sky130_fd_sc_hd__mux4_2
XFILLER_33_671 VGND VGND VPWR VPWR sky130_fd_sc_hd__fill_1
X_4935_ _4935_/A _8235_/Q VGND VGND VPWR VPWR _5867_/B sky130_fd_sc_hd__xor2_4
XANTENNA_11 _8352_/D VGND VGND VPWR VPWR sky130_fd_sc_hd__diode_2
XANTENNA_22 _7142_/X VGND VGND VPWR VPWR sky130_fd_sc_hd__diode_2
XFILLER_20_321 VGND VGND VPWR VPWR sky130_fd_sc_hd__decap_3
XPHY_EDGE_ROW_25_Left_145 VGND VGND VPWR VPWR sky130_fd_sc_hd__decap_3
X_7654_ _7776_/A _7656_/B VGND VGND VPWR VPWR _7655_/A sky130_fd_sc_hd__xnor2_2
X_4866_ _6605_/A _8255_/Q VGND VGND VPWR VPWR _4868_/A sky130_fd_sc_hd__and2_2
XANTENNA_33 _5727_/B VGND VGND VPWR VPWR sky130_fd_sc_hd__diode_2
XFILLER_119_710 VGND VGND VPWR VPWR sky130_fd_sc_hd__decap_3
XFILLER_119_732 VGND VGND VPWR VPWR sky130_fd_sc_hd__fill_1
XFILLER_20_354 VGND VGND VPWR VPWR sky130_fd_sc_hd__decap_3
XFILLER_20_365 VGND VGND VPWR VPWR sky130_fd_sc_hd__decap_3
X_7585_ _8221_/Q _7585_/B VGND VGND VPWR VPWR _7633_/B sky130_fd_sc_hd__nand2_2
X_6605_ _6605_/A _6605_/B VGND VGND VPWR VPWR _6670_/C sky130_fd_sc_hd__nor2_2
X_4797_ _8268_/Q _8204_/Q VGND VGND VPWR VPWR _7030_/A sky130_fd_sc_hd__nor2b_2
XFILLER_20_398 VGND VGND VPWR VPWR sky130_fd_sc_hd__decap_3
X_6536_ _6536_/A _6571_/B VGND VGND VPWR VPWR _7827_/B sky130_fd_sc_hd__nand2_2
XFILLER_106_404 VGND VGND VPWR VPWR sky130_fd_sc_hd__decap_3
XFILLER_115_9 VGND VGND VPWR VPWR sky130_fd_sc_hd__decap_3
X_6467_ _8188_/Q _5701_/X _6466_/X _8288_/Q VGND VGND VPWR VPWR _6468_/B sky130_fd_sc_hd__o22a_2
XFILLER_0_704 VGND VGND VPWR VPWR sky130_fd_sc_hd__fill_2
X_8206_ _8229_/CLK _8206_/D VGND VGND VPWR VPWR _8206_/Q sky130_fd_sc_hd__dfxtp_2
Xoutput151 _7978_/Q VGND VGND VPWR VPWR result[20] sky130_fd_sc_hd__clkdlybuf4s25_1
Xoutput140 _7968_/Q VGND VGND VPWR VPWR result[10] sky130_fd_sc_hd__clkdlybuf4s25_1
X_6398_ _8245_/Q _6398_/B VGND VGND VPWR VPWR _6398_/Y sky130_fd_sc_hd__nand2_2
X_5418_ _5417_/A _7474_/A _6023_/A _5417_/Y VGND VGND VPWR VPWR _5418_/X sky130_fd_sc_hd__o22a_2
XFILLER_0_726 VGND VGND VPWR VPWR sky130_fd_sc_hd__fill_2
XFILLER_87_321 VGND VGND VPWR VPWR sky130_fd_sc_hd__decap_3
X_8137_ _8269_/CLK _8137_/D VGND VGND VPWR VPWR _8137_/Q sky130_fd_sc_hd__dfxtp_2
Xoutput195 _8018_/Q VGND VGND VPWR VPWR result[60] sky130_fd_sc_hd__clkdlybuf4s25_1
Xoutput184 _8008_/Q VGND VGND VPWR VPWR result[50] sky130_fd_sc_hd__clkdlybuf4s25_1
Xoutput173 _7998_/Q VGND VGND VPWR VPWR result[40] sky130_fd_sc_hd__clkdlybuf4s25_1
Xoutput162 _7988_/Q VGND VGND VPWR VPWR result[30] sky130_fd_sc_hd__clkdlybuf4s25_1
X_5349_ _4967_/Y _5348_/Y _5444_/S VGND VGND VPWR VPWR _5350_/A sky130_fd_sc_hd__mux2_2
XTAP_TAPCELL_ROW_7_347 VGND VPWR sky130_fd_sc_hd__tapvpwrvgnd_1
XFILLER_102_643 VGND VGND VPWR VPWR sky130_fd_sc_hd__fill_1
XFILLER_87_343 VGND VGND VPWR VPWR sky130_fd_sc_hd__fill_2
XPHY_EDGE_ROW_34_Left_154 VGND VGND VPWR VPWR sky130_fd_sc_hd__decap_3
XFILLER_101_153 VGND VGND VPWR VPWR sky130_fd_sc_hd__decap_3
XFILLER_75_505 VGND VGND VPWR VPWR sky130_fd_sc_hd__decap_3
XFILLER_87_365 VGND VGND VPWR VPWR sky130_fd_sc_hd__decap_3
XFILLER_87_387 VGND VGND VPWR VPWR sky130_fd_sc_hd__fill_2
X_8068_ _8218_/CLK _8068_/D VGND VGND VPWR VPWR _8068_/Q sky130_fd_sc_hd__dfxtp_2
XTAP_TAPCELL_ROW_89_1417 VGND VPWR sky130_fd_sc_hd__tapvpwrvgnd_1
XFILLER_28_421 VGND VGND VPWR VPWR sky130_fd_sc_hd__decap_3
XFILLER_46_23 VGND VGND VPWR VPWR sky130_fd_sc_hd__decap_3
XFILLER_75_538 VGND VGND VPWR VPWR sky130_fd_sc_hd__decap_3
XFILLER_87_398 VGND VGND VPWR VPWR sky130_fd_sc_hd__decap_3
X_7019_ _8204_/Q _8203_/Q _7796_/A VGND VGND VPWR VPWR _7019_/X sky130_fd_sc_hd__mux2_2
XFILLER_90_508 VGND VGND VPWR VPWR sky130_fd_sc_hd__decap_3
XFILLER_15_104 VGND VGND VPWR VPWR sky130_fd_sc_hd__fill_2
XFILLER_16_627 VGND VGND VPWR VPWR sky130_fd_sc_hd__decap_3
XFILLER_43_402 VGND VGND VPWR VPWR sky130_fd_sc_hd__decap_3
XFILLER_55_284 VGND VGND VPWR VPWR sky130_fd_sc_hd__decap_3
XTAP_TAPCELL_ROW_26_600 VGND VPWR sky130_fd_sc_hd__tapvpwrvgnd_1
XFILLER_15_137 VGND VGND VPWR VPWR sky130_fd_sc_hd__decap_3
XFILLER_70_221 VGND VGND VPWR VPWR sky130_fd_sc_hd__decap_3
XTAP_TAPCELL_ROW_54_964 VGND VPWR sky130_fd_sc_hd__tapvpwrvgnd_1
XFILLER_62_44 VGND VGND VPWR VPWR sky130_fd_sc_hd__decap_3
XFILLER_70_265 VGND VGND VPWR VPWR sky130_fd_sc_hd__decap_3
XFILLER_70_287 VGND VGND VPWR VPWR sky130_fd_sc_hd__decap_3
XPHY_EDGE_ROW_43_Left_163 VGND VGND VPWR VPWR sky130_fd_sc_hd__decap_3
XFILLER_11_332 VGND VGND VPWR VPWR sky130_fd_sc_hd__decap_3
XFILLER_30_129 VGND VGND VPWR VPWR sky130_fd_sc_hd__decap_3
XFILLER_62_88 VGND VGND VPWR VPWR sky130_fd_sc_hd__decap_3
XFILLER_70_298 VGND VGND VPWR VPWR sky130_fd_sc_hd__fill_1
XFILLER_11_354 VGND VGND VPWR VPWR sky130_fd_sc_hd__decap_3
XFILLER_7_303 VGND VGND VPWR VPWR sky130_fd_sc_hd__decap_3
XFILLER_7_314 VGND VGND VPWR VPWR sky130_fd_sc_hd__decap_3
XFILLER_109_220 VGND VGND VPWR VPWR sky130_fd_sc_hd__decap_3
XFILLER_109_231 VGND VGND VPWR VPWR sky130_fd_sc_hd__decap_3
XFILLER_11_387 VGND VGND VPWR VPWR sky130_fd_sc_hd__decap_3
XFILLER_109_264 VGND VGND VPWR VPWR sky130_fd_sc_hd__decap_3
XFILLER_112_407 VGND VGND VPWR VPWR sky130_fd_sc_hd__decap_3
XTAP_TAPCELL_ROW_111_1702 VGND VPWR sky130_fd_sc_hd__tapvpwrvgnd_1
XFILLER_30_9 VGND VGND VPWR VPWR sky130_fd_sc_hd__decap_3
XFILLER_3_586 VGND VGND VPWR VPWR sky130_fd_sc_hd__decap_3
XFILLER_97_118 VGND VGND VPWR VPWR sky130_fd_sc_hd__decap_3
XPHY_EDGE_ROW_52_Left_172 VGND VGND VPWR VPWR sky130_fd_sc_hd__decap_3
XFILLER_78_321 VGND VGND VPWR VPWR sky130_fd_sc_hd__decap_3
XFILLER_78_354 VGND VGND VPWR VPWR sky130_fd_sc_hd__decap_3
XFILLER_38_218 VGND VGND VPWR VPWR sky130_fd_sc_hd__decap_3
XFILLER_39_719 VGND VGND VPWR VPWR sky130_fd_sc_hd__fill_1
XFILLER_78_365 VGND VGND VPWR VPWR sky130_fd_sc_hd__decap_3
XFILLER_87_96 VGND VGND VPWR VPWR sky130_fd_sc_hd__decap_3
XFILLER_93_313 VGND VGND VPWR VPWR sky130_fd_sc_hd__decap_3
XFILLER_78_398 VGND VGND VPWR VPWR sky130_fd_sc_hd__decap_3
XFILLER_93_346 VGND VGND VPWR VPWR sky130_fd_sc_hd__decap_3
XFILLER_19_443 VGND VGND VPWR VPWR sky130_fd_sc_hd__decap_3
XFILLER_93_379 VGND VGND VPWR VPWR sky130_fd_sc_hd__decap_3
XFILLER_19_487 VGND VGND VPWR VPWR sky130_fd_sc_hd__decap_3
XFILLER_34_413 VGND VGND VPWR VPWR sky130_fd_sc_hd__decap_3
XFILLER_34_424 VGND VGND VPWR VPWR sky130_fd_sc_hd__decap_3
XFILLER_46_273 VGND VGND VPWR VPWR sky130_fd_sc_hd__decap_3
XFILLER_74_571 VGND VGND VPWR VPWR sky130_fd_sc_hd__decap_3
XTAP_TAPCELL_ROW_109_1675 VGND VPWR sky130_fd_sc_hd__tapvpwrvgnd_1
XFILLER_34_446 VGND VGND VPWR VPWR sky130_fd_sc_hd__fill_2
XPHY_EDGE_ROW_61_Left_181 VGND VGND VPWR VPWR sky130_fd_sc_hd__decap_3
XFILLER_15_660 VGND VGND VPWR VPWR sky130_fd_sc_hd__decap_3
XFILLER_22_619 VGND VGND VPWR VPWR sky130_fd_sc_hd__decap_3
XFILLER_61_265 VGND VGND VPWR VPWR sky130_fd_sc_hd__decap_3
XFILLER_61_298 VGND VGND VPWR VPWR sky130_fd_sc_hd__decap_3
Xclkbuf_leaf_41_clk clkload0/A VGND VGND VPWR VPWR _8360_/CLK sky130_fd_sc_hd__clkbuf_8
X_4720_ _6769_/B VGND VGND VPWR VPWR _6686_/A sky130_fd_sc_hd__inv_2
XFILLER_30_663 VGND VGND VPWR VPWR sky130_fd_sc_hd__decap_3
X_4651_ _4651_/A VGND VGND VPWR VPWR _8263_/D sky130_fd_sc_hd__buf_1
XTAP_TAPCELL_ROW_32_669 VGND VPWR sky130_fd_sc_hd__tapvpwrvgnd_1
Xinput31 operand_a[32] VGND VGND VPWR VPWR _4240_/B sky130_fd_sc_hd__clkdlybuf4s25_1
Xinput20 operand_a[22] VGND VGND VPWR VPWR _4220_/B sky130_fd_sc_hd__clkdlybuf4s25_1
XFILLER_116_713 VGND VGND VPWR VPWR sky130_fd_sc_hd__decap_3
Xinput64 operand_a[62] VGND VGND VPWR VPWR _4300_/B sky130_fd_sc_hd__clkdlybuf4s25_1
Xinput53 operand_a[52] VGND VGND VPWR VPWR _4280_/B sky130_fd_sc_hd__clkdlybuf4s25_1
Xinput42 operand_a[42] VGND VGND VPWR VPWR _4260_/B sky130_fd_sc_hd__clkdlybuf4s25_1
X_7370_ _7398_/C _7370_/B _7370_/C VGND VGND VPWR VPWR _7370_/X sky130_fd_sc_hd__and3_2
X_4582_ _7898_/B _8095_/Q VGND VGND VPWR VPWR _4583_/A sky130_fd_sc_hd__and2_2
XFILLER_115_223 VGND VGND VPWR VPWR sky130_fd_sc_hd__fill_1
XFILLER_6_380 VGND VGND VPWR VPWR sky130_fd_sc_hd__decap_3
Xinput97 operand_b[34] VGND VGND VPWR VPWR _4372_/B sky130_fd_sc_hd__clkdlybuf4s25_1
Xinput86 operand_b[24] VGND VGND VPWR VPWR _4352_/B sky130_fd_sc_hd__clkdlybuf4s25_1
Xinput75 operand_b[14] VGND VGND VPWR VPWR _4332_/B sky130_fd_sc_hd__clkdlybuf4s25_1
X_6321_ _6355_/B _6321_/B _5673_/A VGND VGND VPWR VPWR _6321_/X sky130_fd_sc_hd__or3b_2
XFILLER_115_234 VGND VGND VPWR VPWR sky130_fd_sc_hd__decap_3
XFILLER_115_267 VGND VGND VPWR VPWR sky130_fd_sc_hd__decap_3
XFILLER_89_608 VGND VGND VPWR VPWR sky130_fd_sc_hd__fill_2
XPHY_EDGE_ROW_70_Left_190 VGND VGND VPWR VPWR sky130_fd_sc_hd__decap_3
X_6252_ _7209_/A _6223_/Y _6224_/X _6251_/X VGND VGND VPWR VPWR _6252_/X sky130_fd_sc_hd__a31o_2
XTAP_TAPCELL_ROW_73_1207 VGND VPWR sky130_fd_sc_hd__tapvpwrvgnd_1
XFILLER_103_429 VGND VGND VPWR VPWR sky130_fd_sc_hd__fill_1
XFILLER_88_118 VGND VGND VPWR VPWR sky130_fd_sc_hd__decap_3
X_6183_ _6297_/C _6183_/B VGND VGND VPWR VPWR _6183_/Y sky130_fd_sc_hd__nand2_2
X_5203_ _5634_/S _8222_/Q _7776_/A VGND VGND VPWR VPWR _5204_/B sky130_fd_sc_hd__a21o_2
XFILLER_97_641 VGND VGND VPWR VPWR sky130_fd_sc_hd__decap_3
X_5134_ _5444_/S VGND VGND VPWR VPWR _5634_/S sky130_fd_sc_hd__buf_1
XTAP_TAPCELL_ROW_4_306 VGND VPWR sky130_fd_sc_hd__tapvpwrvgnd_1
XFILLER_69_387 VGND VGND VPWR VPWR sky130_fd_sc_hd__decap_3
XFILLER_96_162 VGND VGND VPWR VPWR sky130_fd_sc_hd__decap_3
XTAP_TAPCELL_ROW_4_317 VGND VPWR sky130_fd_sc_hd__tapvpwrvgnd_1
XFILLER_57_549 VGND VGND VPWR VPWR sky130_fd_sc_hd__decap_3
XFILLER_84_324 VGND VGND VPWR VPWR sky130_fd_sc_hd__decap_3
XFILLER_96_195 VGND VGND VPWR VPWR sky130_fd_sc_hd__fill_1
X_5065_ _8266_/Q _5063_/Y _5064_/X VGND VGND VPWR VPWR _5065_/Y sky130_fd_sc_hd__o21ai_2
XFILLER_37_240 VGND VGND VPWR VPWR sky130_fd_sc_hd__decap_3
XFILLER_84_357 VGND VGND VPWR VPWR sky130_fd_sc_hd__decap_3
X_4016_ _8314_/Q _8317_/Q _8316_/Q _8319_/Q VGND VGND VPWR VPWR _4017_/D sky130_fd_sc_hd__or4_2
XFILLER_37_273 VGND VGND VPWR VPWR sky130_fd_sc_hd__fill_2
XFILLER_37_284 VGND VGND VPWR VPWR sky130_fd_sc_hd__decap_3
XFILLER_52_210 VGND VGND VPWR VPWR sky130_fd_sc_hd__fill_1
XFILLER_25_446 VGND VGND VPWR VPWR sky130_fd_sc_hd__fill_2
XFILLER_52_221 VGND VGND VPWR VPWR sky130_fd_sc_hd__decap_3
XFILLER_52_232 VGND VGND VPWR VPWR sky130_fd_sc_hd__decap_3
XFILLER_80_530 VGND VGND VPWR VPWR sky130_fd_sc_hd__fill_2
XTAP_TAPCELL_ROW_84_1347 VGND VPWR sky130_fd_sc_hd__tapvpwrvgnd_1
XFILLER_25_468 VGND VGND VPWR VPWR sky130_fd_sc_hd__decap_3
XFILLER_40_427 VGND VGND VPWR VPWR sky130_fd_sc_hd__decap_3
XFILLER_80_563 VGND VGND VPWR VPWR sky130_fd_sc_hd__decap_3
X_5967_ _5967_/A VGND VGND VPWR VPWR _5967_/Y sky130_fd_sc_hd__inv_2
XTAP_TAPCELL_ROW_51_923 VGND VPWR sky130_fd_sc_hd__tapvpwrvgnd_1
XFILLER_12_129 VGND VGND VPWR VPWR sky130_fd_sc_hd__fill_2
X_7706_ _7652_/Y _7676_/X _7686_/X _7705_/X VGND VGND VPWR VPWR _7706_/X sky130_fd_sc_hd__a31o_2
Xclkbuf_leaf_32_clk clkbuf_2_2__f_clk/X VGND VGND VPWR VPWR _8386_/CLK sky130_fd_sc_hd__clkbuf_8
X_4918_ _8173_/Q VGND VGND VPWR VPWR _5900_/S sky130_fd_sc_hd__inv_2
XFILLER_32_47 VGND VGND VPWR VPWR sky130_fd_sc_hd__fill_2
X_7637_ _8286_/Q _7637_/B VGND VGND VPWR VPWR _7637_/Y sky130_fd_sc_hd__nand2_4
X_5898_ _5941_/B _5407_/X _6497_/B _7010_/B VGND VGND VPWR VPWR _5898_/X sky130_fd_sc_hd__o2bb2a_2
XFILLER_20_162 VGND VGND VPWR VPWR sky130_fd_sc_hd__decap_3
XFILLER_21_685 VGND VGND VPWR VPWR sky130_fd_sc_hd__decap_3
X_4849_ _4849_/A _4849_/B VGND VGND VPWR VPWR _6675_/B sky130_fd_sc_hd__nor2_2
X_7568_ _7640_/A1 _7544_/Y _7547_/Y _6220_/A _7567_/X VGND VGND VPWR VPWR _7569_/B
+ sky130_fd_sc_hd__a221o_2
XFILLER_106_212 VGND VGND VPWR VPWR sky130_fd_sc_hd__decap_3
XFILLER_113_6 VGND VGND VPWR VPWR sky130_fd_sc_hd__decap_3
XFILLER_119_584 VGND VGND VPWR VPWR sky130_fd_sc_hd__decap_3
XFILLER_4_339 VGND VGND VPWR VPWR sky130_fd_sc_hd__decap_3
X_7499_ _8219_/Q _5397_/A _5341_/A _8283_/Q VGND VGND VPWR VPWR _7499_/X sky130_fd_sc_hd__a2bb2o_2
X_6519_ _7121_/A _6519_/B VGND VGND VPWR VPWR _8323_/D sky130_fd_sc_hd__nor2_2
XFILLER_106_245 VGND VGND VPWR VPWR sky130_fd_sc_hd__decap_3
XFILLER_106_256 VGND VGND VPWR VPWR sky130_fd_sc_hd__decap_3
XFILLER_106_289 VGND VGND VPWR VPWR sky130_fd_sc_hd__decap_3
XTAP_TAPCELL_ROW_95_1498 VGND VPWR sky130_fd_sc_hd__tapvpwrvgnd_1
XFILLER_0_556 VGND VGND VPWR VPWR sky130_fd_sc_hd__decap_3
XFILLER_88_652 VGND VGND VPWR VPWR sky130_fd_sc_hd__decap_3
XFILLER_102_462 VGND VGND VPWR VPWR sky130_fd_sc_hd__decap_3
XFILLER_48_505 VGND VGND VPWR VPWR sky130_fd_sc_hd__decap_3
XFILLER_57_11 VGND VGND VPWR VPWR sky130_fd_sc_hd__fill_1
XFILLER_57_33 VGND VGND VPWR VPWR sky130_fd_sc_hd__decap_3
XFILLER_75_302 VGND VGND VPWR VPWR sky130_fd_sc_hd__decap_3
XFILLER_57_66 VGND VGND VPWR VPWR sky130_fd_sc_hd__fill_2
XFILLER_57_77 VGND VGND VPWR VPWR sky130_fd_sc_hd__decap_3
XFILLER_75_335 VGND VGND VPWR VPWR sky130_fd_sc_hd__fill_1
XFILLER_28_240 VGND VGND VPWR VPWR sky130_fd_sc_hd__decap_3
XFILLER_57_99 VGND VGND VPWR VPWR sky130_fd_sc_hd__decap_3
XFILLER_75_368 VGND VGND VPWR VPWR sky130_fd_sc_hd__fill_2
XFILLER_16_424 VGND VGND VPWR VPWR sky130_fd_sc_hd__decap_3
XFILLER_113_83 VGND VGND VPWR VPWR sky130_fd_sc_hd__fill_2
XFILLER_16_457 VGND VGND VPWR VPWR sky130_fd_sc_hd__fill_1
XFILLER_73_54 VGND VGND VPWR VPWR sky130_fd_sc_hd__fill_2
XFILLER_31_427 VGND VGND VPWR VPWR sky130_fd_sc_hd__decap_3
XFILLER_31_449 VGND VGND VPWR VPWR sky130_fd_sc_hd__fill_1
XFILLER_43_287 VGND VGND VPWR VPWR sky130_fd_sc_hd__decap_3
Xclkbuf_leaf_23_clk clkbuf_2_2__f_clk/X VGND VGND VPWR VPWR _8392_/CLK sky130_fd_sc_hd__clkbuf_8
XFILLER_11_151 VGND VGND VPWR VPWR sky130_fd_sc_hd__decap_3
XFILLER_7_122 VGND VGND VPWR VPWR sky130_fd_sc_hd__decap_3
XFILLER_8_623 VGND VGND VPWR VPWR sky130_fd_sc_hd__decap_3
XFILLER_8_645 VGND VGND VPWR VPWR sky130_fd_sc_hd__decap_3
XFILLER_7_166 VGND VGND VPWR VPWR sky130_fd_sc_hd__fill_2
XFILLER_8_678 VGND VGND VPWR VPWR sky130_fd_sc_hd__fill_2
XFILLER_8_689 VGND VGND VPWR VPWR sky130_fd_sc_hd__decap_3
XFILLER_22_91 VGND VGND VPWR VPWR sky130_fd_sc_hd__decap_3
XFILLER_98_405 VGND VGND VPWR VPWR sky130_fd_sc_hd__decap_3
XFILLER_112_248 VGND VGND VPWR VPWR sky130_fd_sc_hd__decap_3
XFILLER_98_449 VGND VGND VPWR VPWR sky130_fd_sc_hd__decap_3
XFILLER_39_505 VGND VGND VPWR VPWR sky130_fd_sc_hd__decap_3
XFILLER_79_685 VGND VGND VPWR VPWR sky130_fd_sc_hd__decap_3
XFILLER_66_324 VGND VGND VPWR VPWR sky130_fd_sc_hd__decap_3
XFILLER_78_173 VGND VGND VPWR VPWR sky130_fd_sc_hd__fill_2
XFILLER_78_184 VGND VGND VPWR VPWR sky130_fd_sc_hd__fill_2
XFILLER_78_195 VGND VGND VPWR VPWR sky130_fd_sc_hd__fill_1
XFILLER_94_633 VGND VGND VPWR VPWR sky130_fd_sc_hd__decap_3
XFILLER_66_346 VGND VGND VPWR VPWR sky130_fd_sc_hd__decap_3
XFILLER_66_368 VGND VGND VPWR VPWR sky130_fd_sc_hd__decap_3
XFILLER_94_677 VGND VGND VPWR VPWR sky130_fd_sc_hd__decap_3
XFILLER_19_284 VGND VGND VPWR VPWR sky130_fd_sc_hd__decap_3
XFILLER_47_582 VGND VGND VPWR VPWR sky130_fd_sc_hd__decap_3
XFILLER_81_316 VGND VGND VPWR VPWR sky130_fd_sc_hd__decap_3
XFILLER_93_187 VGND VGND VPWR VPWR sky130_fd_sc_hd__decap_3
XTAP_TAPCELL_ROW_37_739 VGND VPWR sky130_fd_sc_hd__tapvpwrvgnd_1
XFILLER_19_295 VGND VGND VPWR VPWR sky130_fd_sc_hd__decap_3
XFILLER_81_349 VGND VGND VPWR VPWR sky130_fd_sc_hd__decap_3
X_6870_ _5966_/A _6858_/X _6864_/Y _6869_/X VGND VGND VPWR VPWR _6870_/X sky130_fd_sc_hd__o211a_2
XFILLER_22_416 VGND VGND VPWR VPWR sky130_fd_sc_hd__decap_3
X_5821_ _6648_/A _5441_/X _6130_/A VGND VGND VPWR VPWR _5821_/X sky130_fd_sc_hd__o21a_2
XFILLER_22_427 VGND VGND VPWR VPWR sky130_fd_sc_hd__fill_1
X_5752_ _6109_/A _5752_/B VGND VGND VPWR VPWR _5752_/Y sky130_fd_sc_hd__nor2_2
XTAP_TAPCELL_ROW_17_485 VGND VPWR sky130_fd_sc_hd__tapvpwrvgnd_1
XTAP_TAPCELL_ROW_17_474 VGND VPWR sky130_fd_sc_hd__tapvpwrvgnd_1
Xclkbuf_leaf_14_clk clkload2/A VGND VGND VPWR VPWR _8353_/CLK sky130_fd_sc_hd__clkbuf_8
X_4703_ _4703_/A VGND VGND VPWR VPWR _8289_/D sky130_fd_sc_hd__buf_1
XFILLER_30_471 VGND VGND VPWR VPWR sky130_fd_sc_hd__decap_3
X_5683_ _5832_/A _5683_/B VGND VGND VPWR VPWR _5683_/X sky130_fd_sc_hd__or2_2
X_7422_ _6321_/X _7421_/Y _6326_/X VGND VGND VPWR VPWR _7429_/D sky130_fd_sc_hd__a21o_2
X_4634_ _7930_/B _8121_/Q VGND VGND VPWR VPWR _4635_/A sky130_fd_sc_hd__and2_2
X_7353_ _8278_/Q VGND VGND VPWR VPWR _7353_/Y sky130_fd_sc_hd__inv_2
X_4565_ _4565_/A VGND VGND VPWR VPWR _8220_/D sky130_fd_sc_hd__buf_1
X_6304_ _6307_/A _6359_/B VGND VGND VPWR VPWR _6304_/Y sky130_fd_sc_hd__xnor2_2
XFILLER_116_598 VGND VGND VPWR VPWR sky130_fd_sc_hd__decap_3
XFILLER_89_416 VGND VGND VPWR VPWR sky130_fd_sc_hd__decap_3
XPHY_EDGE_ROW_4_Right_4 VGND VGND VPWR VPWR sky130_fd_sc_hd__decap_3
X_7284_ _8210_/Q _8211_/Q _7284_/C VGND VGND VPWR VPWR _7344_/C sky130_fd_sc_hd__and3_2
X_4496_ _7898_/B _8052_/Q VGND VGND VPWR VPWR _4497_/A sky130_fd_sc_hd__and2_2
XFILLER_103_237 VGND VGND VPWR VPWR sky130_fd_sc_hd__decap_3
XFILLER_89_449 VGND VGND VPWR VPWR sky130_fd_sc_hd__decap_3
X_6235_ _7264_/A _6235_/B VGND VGND VPWR VPWR _6236_/B sky130_fd_sc_hd__nor2_2
XFILLER_57_302 VGND VGND VPWR VPWR sky130_fd_sc_hd__decap_3
XFILLER_69_162 VGND VGND VPWR VPWR sky130_fd_sc_hd__decap_3
XFILLER_85_600 VGND VGND VPWR VPWR sky130_fd_sc_hd__decap_3
X_6166_ _6165_/X _6104_/X _6012_/X _5956_/X _7812_/A _7670_/A VGND VGND VPWR VPWR
+ _6166_/X sky130_fd_sc_hd__mux4_2
XFILLER_111_281 VGND VGND VPWR VPWR sky130_fd_sc_hd__decap_3
XFILLER_57_313 VGND VGND VPWR VPWR sky130_fd_sc_hd__decap_3
XFILLER_69_184 VGND VGND VPWR VPWR sky130_fd_sc_hd__decap_3
XFILLER_85_622 VGND VGND VPWR VPWR sky130_fd_sc_hd__decap_3
XFILLER_97_482 VGND VGND VPWR VPWR sky130_fd_sc_hd__decap_3
X_6097_ _6097_/A _8177_/Q VGND VGND VPWR VPWR _6192_/C sky130_fd_sc_hd__nand2_2
X_5117_ _6765_/B _5239_/B VGND VGND VPWR VPWR _5118_/A sky130_fd_sc_hd__or2_2
XFILLER_57_346 VGND VGND VPWR VPWR sky130_fd_sc_hd__decap_3
X_5048_ _6563_/B _5048_/B VGND VGND VPWR VPWR _5048_/X sky130_fd_sc_hd__or2_2
XFILLER_38_582 VGND VGND VPWR VPWR sky130_fd_sc_hd__fill_1
XFILLER_72_327 VGND VGND VPWR VPWR sky130_fd_sc_hd__decap_3
XFILLER_85_699 VGND VGND VPWR VPWR sky130_fd_sc_hd__decap_3
XFILLER_25_232 VGND VGND VPWR VPWR sky130_fd_sc_hd__fill_2
XFILLER_25_254 VGND VGND VPWR VPWR sky130_fd_sc_hd__decap_3
XFILLER_53_585 VGND VGND VPWR VPWR sky130_fd_sc_hd__decap_3
XFILLER_80_360 VGND VGND VPWR VPWR sky130_fd_sc_hd__decap_3
XFILLER_13_438 VGND VGND VPWR VPWR sky130_fd_sc_hd__decap_3
XFILLER_13_449 VGND VGND VPWR VPWR sky130_fd_sc_hd__decap_3
XFILLER_40_213 VGND VGND VPWR VPWR sky130_fd_sc_hd__decap_3
X_6999_ _6999_/A1 _6997_/X _6998_/X VGND VGND VPWR VPWR _6999_/X sky130_fd_sc_hd__a21o_2
XFILLER_43_57 VGND VGND VPWR VPWR sky130_fd_sc_hd__decap_3
XFILLER_21_471 VGND VGND VPWR VPWR sky130_fd_sc_hd__decap_3
XFILLER_40_279 VGND VGND VPWR VPWR sky130_fd_sc_hd__decap_3
Xrebuffer731 _6142_/X VGND VGND VPWR VPWR _6177_/A2 sky130_fd_sc_hd__buf_2
XTAP_TAPCELL_ROW_97_1516 VGND VPWR sky130_fd_sc_hd__tapvpwrvgnd_1
XFILLER_111_3 VGND VGND VPWR VPWR sky130_fd_sc_hd__fill_2
XFILLER_4_103 VGND VGND VPWR VPWR sky130_fd_sc_hd__decap_3
Xrebuffer764 _5315_/X VGND VGND VPWR VPWR _5316_/B sky130_fd_sc_hd__buf_2
XFILLER_4_125 VGND VGND VPWR VPWR sky130_fd_sc_hd__decap_3
XFILLER_4_147 VGND VGND VPWR VPWR sky130_fd_sc_hd__decap_3
Xrebuffer797 _6222_/X VGND VGND VPWR VPWR _6224_/B sky130_fd_sc_hd__buf_2
XFILLER_76_611 VGND VGND VPWR VPWR sky130_fd_sc_hd__decap_3
XFILLER_95_408 VGND VGND VPWR VPWR sky130_fd_sc_hd__decap_3
XFILLER_0_386 VGND VGND VPWR VPWR sky130_fd_sc_hd__decap_3
XFILLER_102_281 VGND VGND VPWR VPWR sky130_fd_sc_hd__decap_3
XFILLER_48_335 VGND VGND VPWR VPWR sky130_fd_sc_hd__fill_2
XFILLER_84_20 VGND VGND VPWR VPWR sky130_fd_sc_hd__decap_3
XFILLER_63_327 VGND VGND VPWR VPWR sky130_fd_sc_hd__fill_2
XFILLER_75_165 VGND VGND VPWR VPWR sky130_fd_sc_hd__decap_3
XFILLER_76_699 VGND VGND VPWR VPWR sky130_fd_sc_hd__fill_1
XFILLER_16_221 VGND VGND VPWR VPWR sky130_fd_sc_hd__decap_3
XFILLER_29_593 VGND VGND VPWR VPWR sky130_fd_sc_hd__decap_3
XFILLER_44_530 VGND VGND VPWR VPWR sky130_fd_sc_hd__fill_2
XFILLER_63_349 VGND VGND VPWR VPWR sky130_fd_sc_hd__decap_3
XFILLER_91_647 VGND VGND VPWR VPWR sky130_fd_sc_hd__fill_1
XFILLER_91_658 VGND VGND VPWR VPWR sky130_fd_sc_hd__fill_2
XFILLER_91_669 VGND VGND VPWR VPWR sky130_fd_sc_hd__decap_3
XTAP_TAPCELL_ROW_106_1634 VGND VPWR sky130_fd_sc_hd__tapvpwrvgnd_1
XFILLER_16_265 VGND VGND VPWR VPWR sky130_fd_sc_hd__fill_1
XFILLER_44_585 VGND VGND VPWR VPWR sky130_fd_sc_hd__decap_3
XFILLER_71_382 VGND VGND VPWR VPWR sky130_fd_sc_hd__decap_3
XFILLER_71_393 VGND VGND VPWR VPWR sky130_fd_sc_hd__decap_3
XFILLER_31_246 VGND VGND VPWR VPWR sky130_fd_sc_hd__decap_3
XTAP_TAPCELL_ROW_14_444 VGND VPWR sky130_fd_sc_hd__tapvpwrvgnd_1
XFILLER_12_460 VGND VGND VPWR VPWR sky130_fd_sc_hd__decap_3
XFILLER_31_279 VGND VGND VPWR VPWR sky130_fd_sc_hd__fill_1
XFILLER_76_6 VGND VGND VPWR VPWR sky130_fd_sc_hd__decap_3
XFILLER_8_442 VGND VGND VPWR VPWR sky130_fd_sc_hd__decap_3
XFILLER_8_486 VGND VGND VPWR VPWR sky130_fd_sc_hd__decap_3
XTAP_TAPCELL_ROW_117_1774 VGND VPWR sky130_fd_sc_hd__tapvpwrvgnd_1
X_4350_ _7898_/B _4350_/B VGND VGND VPWR VPWR _4351_/A sky130_fd_sc_hd__and2_2
XFILLER_113_502 VGND VGND VPWR VPWR sky130_fd_sc_hd__fill_2
XTAP_TAPCELL_ROW_117_1785 VGND VPWR sky130_fd_sc_hd__tapvpwrvgnd_1
XFILLER_4_681 VGND VGND VPWR VPWR sky130_fd_sc_hd__decap_3
X_4281_ _4281_/A VGND VGND VPWR VPWR _8078_/D sky130_fd_sc_hd__buf_1
XFILLER_113_568 VGND VGND VPWR VPWR sky130_fd_sc_hd__decap_3
Xclkbuf_leaf_3_clk clkload1/A VGND VGND VPWR VPWR _8207_/CLK sky130_fd_sc_hd__clkbuf_8
X_6020_ _7193_/A _6008_/Y _6009_/Y _7122_/B _6019_/Y VGND VGND VPWR VPWR _6021_/A
+ sky130_fd_sc_hd__a32o_2
XFILLER_39_302 VGND VGND VPWR VPWR sky130_fd_sc_hd__decap_3
XFILLER_39_324 VGND VGND VPWR VPWR sky130_fd_sc_hd__decap_3
XFILLER_79_471 VGND VGND VPWR VPWR sky130_fd_sc_hd__decap_3
XFILLER_39_357 VGND VGND VPWR VPWR sky130_fd_sc_hd__decap_3
XFILLER_94_430 VGND VGND VPWR VPWR sky130_fd_sc_hd__decap_3
XFILLER_39_379 VGND VGND VPWR VPWR sky130_fd_sc_hd__decap_3
XFILLER_54_327 VGND VGND VPWR VPWR sky130_fd_sc_hd__decap_3
XFILLER_81_113 VGND VGND VPWR VPWR sky130_fd_sc_hd__decap_3
XFILLER_94_474 VGND VGND VPWR VPWR sky130_fd_sc_hd__fill_2
X_7971_ _8384_/CLK _7971_/D VGND VGND VPWR VPWR _7971_/Q sky130_fd_sc_hd__dfxtp_2
XFILLER_35_530 VGND VGND VPWR VPWR sky130_fd_sc_hd__decap_3
XFILLER_47_390 VGND VGND VPWR VPWR sky130_fd_sc_hd__fill_2
X_6922_ _6645_/B _6921_/X _6059_/X _6647_/X _6819_/A _6648_/A VGND VGND VPWR VPWR
+ _6922_/X sky130_fd_sc_hd__mux4_2
XTAP_TAPCELL_ROW_68_1139 VGND VPWR sky130_fd_sc_hd__tapvpwrvgnd_1
XFILLER_35_552 VGND VGND VPWR VPWR sky130_fd_sc_hd__decap_3
X_6853_ _7067_/A _6853_/B VGND VGND VPWR VPWR _6899_/A sky130_fd_sc_hd__nor2_2
XTAP_TAPCELL_ROW_81_1306 VGND VPWR sky130_fd_sc_hd__tapvpwrvgnd_1
XFILLER_35_585 VGND VGND VPWR VPWR sky130_fd_sc_hd__decap_3
XFILLER_50_511 VGND VGND VPWR VPWR sky130_fd_sc_hd__decap_3
XFILLER_50_533 VGND VGND VPWR VPWR sky130_fd_sc_hd__decap_3
XFILLER_62_382 VGND VGND VPWR VPWR sky130_fd_sc_hd__decap_3
XFILLER_90_680 VGND VGND VPWR VPWR sky130_fd_sc_hd__decap_3
X_5804_ _5867_/B _5804_/B VGND VGND VPWR VPWR _5804_/Y sky130_fd_sc_hd__xnor2_2
XTAP_TAPCELL_ROW_81_1317 VGND VPWR sky130_fd_sc_hd__tapvpwrvgnd_1
XFILLER_10_408 VGND VGND VPWR VPWR sky130_fd_sc_hd__decap_3
XFILLER_22_268 VGND VGND VPWR VPWR sky130_fd_sc_hd__decap_3
X_6784_ _6784_/A _6784_/B VGND VGND VPWR VPWR _6784_/X sky130_fd_sc_hd__or2_2
X_3996_ _8351_/Q _7930_/B VGND VGND VPWR VPWR _3997_/A sky130_fd_sc_hd__and2_2
X_5735_ _5732_/X _5733_/X _5734_/X _5719_/Y VGND VGND VPWR VPWR _5735_/X sky130_fd_sc_hd__a211o_2
XFILLER_108_307 VGND VGND VPWR VPWR sky130_fd_sc_hd__fill_1
X_5666_ _5433_/X _5662_/X _5664_/X _5665_/X VGND VGND VPWR VPWR _5666_/X sky130_fd_sc_hd__a22o_2
XFILLER_108_318 VGND VGND VPWR VPWR sky130_fd_sc_hd__decap_3
X_7405_ _7370_/B _7370_/C _4769_/B VGND VGND VPWR VPWR _7407_/B sky130_fd_sc_hd__a21o_2
X_4617_ _4617_/A VGND VGND VPWR VPWR _8246_/D sky130_fd_sc_hd__buf_1
X_8385_ _8385_/CLK _8385_/D VGND VGND VPWR VPWR _8385_/Q sky130_fd_sc_hd__dfxtp_2
X_5597_ _6775_/B _6765_/B VGND VGND VPWR VPWR _5597_/X sky130_fd_sc_hd__and2_2
XFILLER_116_351 VGND VGND VPWR VPWR sky130_fd_sc_hd__decap_3
XFILLER_89_202 VGND VGND VPWR VPWR sky130_fd_sc_hd__decap_3
X_7336_ _7336_/A VGND VGND VPWR VPWR _8347_/D sky130_fd_sc_hd__buf_1
X_4548_ _7843_/A _8078_/Q VGND VGND VPWR VPWR _4549_/A sky130_fd_sc_hd__and2_2
XFILLER_104_524 VGND VGND VPWR VPWR sky130_fd_sc_hd__fill_1
XFILLER_116_395 VGND VGND VPWR VPWR sky130_fd_sc_hd__fill_2
XPHY_EDGE_ROW_8_Left_128 VGND VGND VPWR VPWR sky130_fd_sc_hd__decap_3
X_7267_ _8210_/Q _7267_/B VGND VGND VPWR VPWR _7267_/Y sky130_fd_sc_hd__nor2_2
X_4479_ _4479_/A VGND VGND VPWR VPWR _8177_/D sky130_fd_sc_hd__buf_1
XTAP_TAPCELL_ROW_92_1457 VGND VPWR sky130_fd_sc_hd__tapvpwrvgnd_1
XFILLER_89_268 VGND VGND VPWR VPWR sky130_fd_sc_hd__decap_3
X_6218_ _8245_/Q _6211_/Y _6217_/X VGND VGND VPWR VPWR _6218_/X sky130_fd_sc_hd__o21a_4
XFILLER_38_35 VGND VGND VPWR VPWR sky130_fd_sc_hd__decap_3
X_7198_ _6645_/Y _6648_/X _6784_/A _6650_/B VGND VGND VPWR VPWR _7198_/X sky130_fd_sc_hd__a211o_2
XFILLER_38_79 VGND VGND VPWR VPWR sky130_fd_sc_hd__decap_3
XFILLER_57_143 VGND VGND VPWR VPWR sky130_fd_sc_hd__fill_2
XFILLER_73_603 VGND VGND VPWR VPWR sky130_fd_sc_hd__decap_3
XFILLER_85_452 VGND VGND VPWR VPWR sky130_fd_sc_hd__decap_3
X_6149_ _8178_/Q _8179_/Q _6099_/Y _6149_/B1 _6148_/X VGND VGND VPWR VPWR _6149_/X
+ sky130_fd_sc_hd__a32o_2
XFILLER_18_519 VGND VGND VPWR VPWR sky130_fd_sc_hd__decap_3
XFILLER_45_327 VGND VGND VPWR VPWR sky130_fd_sc_hd__decap_3
XFILLER_57_154 VGND VGND VPWR VPWR sky130_fd_sc_hd__decap_3
XFILLER_73_636 VGND VGND VPWR VPWR sky130_fd_sc_hd__decap_3
XPHY_EDGE_ROW_79_Right_79 VGND VGND VPWR VPWR sky130_fd_sc_hd__decap_3
XFILLER_14_714 VGND VGND VPWR VPWR sky130_fd_sc_hd__fill_1
XFILLER_26_552 VGND VGND VPWR VPWR sky130_fd_sc_hd__decap_3
XFILLER_53_360 VGND VGND VPWR VPWR sky130_fd_sc_hd__decap_3
XFILLER_54_56 VGND VGND VPWR VPWR sky130_fd_sc_hd__decap_3
XFILLER_26_596 VGND VGND VPWR VPWR sky130_fd_sc_hd__decap_3
XFILLER_41_511 VGND VGND VPWR VPWR sky130_fd_sc_hd__decap_3
XFILLER_53_393 VGND VGND VPWR VPWR sky130_fd_sc_hd__decap_3
XFILLER_110_62 VGND VGND VPWR VPWR sky130_fd_sc_hd__decap_3
XFILLER_110_95 VGND VGND VPWR VPWR sky130_fd_sc_hd__decap_3
XFILLER_13_268 VGND VGND VPWR VPWR sky130_fd_sc_hd__decap_3
XFILLER_13_279 VGND VGND VPWR VPWR sky130_fd_sc_hd__fill_1
XFILLER_70_11 VGND VGND VPWR VPWR sky130_fd_sc_hd__decap_3
XFILLER_70_44 VGND VGND VPWR VPWR sky130_fd_sc_hd__decap_3
XTAP_TAPCELL_ROW_101_1575 VGND VPWR sky130_fd_sc_hd__tapvpwrvgnd_1
XTAP_TAPCELL_ROW_11_403 VGND VPWR sky130_fd_sc_hd__tapvpwrvgnd_1
XFILLER_21_290 VGND VGND VPWR VPWR sky130_fd_sc_hd__decap_3
XFILLER_70_77 VGND VGND VPWR VPWR sky130_fd_sc_hd__decap_3
XPHY_EDGE_ROW_88_Right_88 VGND VGND VPWR VPWR sky130_fd_sc_hd__decap_3
XFILLER_119_60 VGND VGND VPWR VPWR sky130_fd_sc_hd__decap_3
XFILLER_5_445 VGND VGND VPWR VPWR sky130_fd_sc_hd__decap_3
Xrebuffer572 _8182_/Q VGND VGND VPWR VPWR _4890_/B sky130_fd_sc_hd__buf_12
XFILLER_107_384 VGND VGND VPWR VPWR sky130_fd_sc_hd__decap_3
XFILLER_79_97 VGND VGND VPWR VPWR sky130_fd_sc_hd__fill_2
XFILLER_110_527 VGND VGND VPWR VPWR sky130_fd_sc_hd__decap_3
XFILLER_1_673 VGND VGND VPWR VPWR sky130_fd_sc_hd__decap_3
XFILLER_95_216 VGND VGND VPWR VPWR sky130_fd_sc_hd__decap_3
XFILLER_95_30 VGND VGND VPWR VPWR sky130_fd_sc_hd__decap_3
XFILLER_48_132 VGND VGND VPWR VPWR sky130_fd_sc_hd__decap_3
XFILLER_49_655 VGND VGND VPWR VPWR sky130_fd_sc_hd__decap_3
XFILLER_76_430 VGND VGND VPWR VPWR sky130_fd_sc_hd__decap_3
XFILLER_88_290 VGND VGND VPWR VPWR sky130_fd_sc_hd__decap_3
XPHY_EDGE_ROW_97_Right_97 VGND VGND VPWR VPWR sky130_fd_sc_hd__decap_3
XFILLER_36_327 VGND VGND VPWR VPWR sky130_fd_sc_hd__decap_3
XFILLER_49_688 VGND VGND VPWR VPWR sky130_fd_sc_hd__fill_2
XFILLER_64_636 VGND VGND VPWR VPWR sky130_fd_sc_hd__decap_3
XFILLER_76_474 VGND VGND VPWR VPWR sky130_fd_sc_hd__fill_2
XFILLER_91_411 VGND VGND VPWR VPWR sky130_fd_sc_hd__decap_3
XFILLER_95_96 VGND VGND VPWR VPWR sky130_fd_sc_hd__decap_3
XTAP_TAPCELL_ROW_19_503 VGND VPWR sky130_fd_sc_hd__tapvpwrvgnd_1
XFILLER_29_390 VGND VGND VPWR VPWR sky130_fd_sc_hd__fill_2
XFILLER_48_187 VGND VGND VPWR VPWR sky130_fd_sc_hd__decap_3
XFILLER_63_113 VGND VGND VPWR VPWR sky130_fd_sc_hd__decap_3
XFILLER_63_146 VGND VGND VPWR VPWR sky130_fd_sc_hd__decap_3
XFILLER_91_455 VGND VGND VPWR VPWR sky130_fd_sc_hd__decap_3
XFILLER_17_541 VGND VGND VPWR VPWR sky130_fd_sc_hd__decap_3
XFILLER_51_308 VGND VGND VPWR VPWR sky130_fd_sc_hd__decap_3
XFILLER_51_319 VGND VGND VPWR VPWR sky130_fd_sc_hd__decap_3
XFILLER_91_488 VGND VGND VPWR VPWR sky130_fd_sc_hd__decap_3
XTAP_TAPCELL_ROW_47_867 VGND VPWR sky130_fd_sc_hd__tapvpwrvgnd_1
XFILLER_44_371 VGND VGND VPWR VPWR sky130_fd_sc_hd__decap_3
XFILLER_12_290 VGND VGND VPWR VPWR sky130_fd_sc_hd__decap_3
XTAP_TAPCELL_ROW_119_1803 VGND VPWR sky130_fd_sc_hd__tapvpwrvgnd_1
XTAP_TAPCELL_ROW_119_1814 VGND VPWR sky130_fd_sc_hd__tapvpwrvgnd_1
XTAP_TAPCELL_ROW_119_1825 VGND VPWR sky130_fd_sc_hd__tapvpwrvgnd_1
X_5520_ _5227_/X _5231_/X _7623_/S VGND VGND VPWR VPWR _5520_/X sky130_fd_sc_hd__mux2_2
X_5451_ _5233_/X _5229_/X _5451_/S VGND VGND VPWR VPWR _5451_/X sky130_fd_sc_hd__mux2_2
XFILLER_99_500 VGND VGND VPWR VPWR sky130_fd_sc_hd__decap_3
XFILLER_99_511 VGND VGND VPWR VPWR sky130_fd_sc_hd__decap_3
X_8170_ _8360_/CLK _8170_/D VGND VGND VPWR VPWR _8170_/Q sky130_fd_sc_hd__dfxtp_4
X_5382_ _5943_/B _5943_/C _8172_/Q _8173_/Q _5780_/S _5127_/A VGND VGND VPWR VPWR
+ _5382_/X sky130_fd_sc_hd__mux4_2
X_4402_ _7930_/B _4402_/B VGND VGND VPWR VPWR _4403_/A sky130_fd_sc_hd__and2_2
XFILLER_113_321 VGND VGND VPWR VPWR sky130_fd_sc_hd__decap_3
XFILLER_99_555 VGND VGND VPWR VPWR sky130_fd_sc_hd__decap_3
X_7121_ _7121_/A _7121_/B VGND VGND VPWR VPWR _8341_/D sky130_fd_sc_hd__nor2_2
X_4333_ _4333_/A VGND VGND VPWR VPWR _8104_/D sky130_fd_sc_hd__buf_1
XFILLER_101_505 VGND VGND VPWR VPWR sky130_fd_sc_hd__decap_3
XFILLER_113_343 VGND VGND VPWR VPWR sky130_fd_sc_hd__decap_3
XFILLER_115_18 VGND VGND VPWR VPWR sky130_fd_sc_hd__decap_3
XFILLER_59_408 VGND VGND VPWR VPWR sky130_fd_sc_hd__decap_3
XFILLER_99_588 VGND VGND VPWR VPWR sky130_fd_sc_hd__decap_3
X_7052_ _8270_/Q _5718_/X _5601_/X _8206_/Q VGND VGND VPWR VPWR _7052_/X sky130_fd_sc_hd__o2bb2a_2
X_4264_ _7843_/A _4264_/B VGND VGND VPWR VPWR _4265_/A sky130_fd_sc_hd__and2_2
XFILLER_101_538 VGND VGND VPWR VPWR sky130_fd_sc_hd__decap_3
XFILLER_113_376 VGND VGND VPWR VPWR sky130_fd_sc_hd__decap_3
XFILLER_86_227 VGND VGND VPWR VPWR sky130_fd_sc_hd__decap_3
X_6003_ _6003_/A _6003_/B _6003_/C VGND VGND VPWR VPWR _6003_/X sky130_fd_sc_hd__and3_2
XFILLER_67_441 VGND VGND VPWR VPWR sky130_fd_sc_hd__decap_3
XFILLER_67_452 VGND VGND VPWR VPWR sky130_fd_sc_hd__decap_3
XFILLER_79_290 VGND VGND VPWR VPWR sky130_fd_sc_hd__decap_3
X_4195_ _4195_/A VGND VGND VPWR VPWR _8035_/D sky130_fd_sc_hd__buf_1
XFILLER_27_305 VGND VGND VPWR VPWR sky130_fd_sc_hd__decap_3
XFILLER_39_165 VGND VGND VPWR VPWR sky130_fd_sc_hd__decap_3
XFILLER_94_271 VGND VGND VPWR VPWR sky130_fd_sc_hd__decap_3
XFILLER_27_349 VGND VGND VPWR VPWR sky130_fd_sc_hd__decap_3
XFILLER_39_187 VGND VGND VPWR VPWR sky130_fd_sc_hd__decap_3
XFILLER_54_124 VGND VGND VPWR VPWR sky130_fd_sc_hd__decap_3
XFILLER_82_433 VGND VGND VPWR VPWR sky130_fd_sc_hd__decap_3
X_7954_ _8398_/CLK _7954_/D VGND VGND VPWR VPWR _7954_/Q sky130_fd_sc_hd__dfxtp_2
XFILLER_54_168 VGND VGND VPWR VPWR sky130_fd_sc_hd__decap_3
XFILLER_70_617 VGND VGND VPWR VPWR sky130_fd_sc_hd__decap_3
XFILLER_82_466 VGND VGND VPWR VPWR sky130_fd_sc_hd__fill_1
X_6905_ _5966_/X _6881_/Y _6882_/X _6904_/X _7930_/B VGND VGND VPWR VPWR _8334_/D
+ sky130_fd_sc_hd__o311a_2
XFILLER_23_533 VGND VGND VPWR VPWR sky130_fd_sc_hd__decap_3
XFILLER_35_382 VGND VGND VPWR VPWR sky130_fd_sc_hd__fill_1
X_7885_ _7885_/A VGND VGND VPWR VPWR _8379_/D sky130_fd_sc_hd__buf_1
XFILLER_35_393 VGND VGND VPWR VPWR sky130_fd_sc_hd__decap_3
XFILLER_50_330 VGND VGND VPWR VPWR sky130_fd_sc_hd__decap_3
X_6836_ _5627_/A _6831_/X _6835_/X _8290_/Q _6687_/X VGND VGND VPWR VPWR _6836_/X
+ sky130_fd_sc_hd__a221o_2
XFILLER_10_216 VGND VGND VPWR VPWR sky130_fd_sc_hd__decap_3
XFILLER_11_717 VGND VGND VPWR VPWR sky130_fd_sc_hd__fill_1
XFILLER_50_363 VGND VGND VPWR VPWR sky130_fd_sc_hd__fill_1
X_6767_ _6767_/A _8290_/Q VGND VGND VPWR VPWR _6767_/Y sky130_fd_sc_hd__nand2_2
X_5718_ _5718_/A VGND VGND VPWR VPWR _5718_/X sky130_fd_sc_hd__buf_1
X_3979_ _3979_/A VGND VGND VPWR VPWR _7938_/D sky130_fd_sc_hd__buf_1
XFILLER_40_14 VGND VGND VPWR VPWR sky130_fd_sc_hd__decap_3
X_6698_ _8195_/Q _8259_/Q VGND VGND VPWR VPWR _6698_/X sky130_fd_sc_hd__and2_2
XFILLER_108_159 VGND VGND VPWR VPWR sky130_fd_sc_hd__decap_3
X_5649_ _6277_/A _5642_/X _5644_/X _5648_/Y VGND VGND VPWR VPWR _5649_/X sky130_fd_sc_hd__a31o_2
XFILLER_117_671 VGND VGND VPWR VPWR sky130_fd_sc_hd__fill_1
X_8368_ _8388_/CLK _8368_/D VGND VGND VPWR VPWR _8368_/Q sky130_fd_sc_hd__dfxtp_2
XFILLER_116_181 VGND VGND VPWR VPWR sky130_fd_sc_hd__decap_3
X_7319_ _7319_/A _7384_/C VGND VGND VPWR VPWR _7319_/Y sky130_fd_sc_hd__xnor2_2
XFILLER_104_365 VGND VGND VPWR VPWR sky130_fd_sc_hd__decap_3
XFILLER_116_192 VGND VGND VPWR VPWR sky130_fd_sc_hd__decap_3
XFILLER_49_45 VGND VGND VPWR VPWR sky130_fd_sc_hd__fill_1
XFILLER_78_728 VGND VGND VPWR VPWR sky130_fd_sc_hd__decap_3
X_8299_ _8322_/CLK _8299_/D VGND VGND VPWR VPWR _8299_/Q sky130_fd_sc_hd__dfxtp_2
XFILLER_105_51 VGND VGND VPWR VPWR sky130_fd_sc_hd__decap_3
XFILLER_58_430 VGND VGND VPWR VPWR sky130_fd_sc_hd__decap_3
XFILLER_77_249 VGND VGND VPWR VPWR sky130_fd_sc_hd__decap_3
XFILLER_58_463 VGND VGND VPWR VPWR sky130_fd_sc_hd__decap_3
XFILLER_100_582 VGND VGND VPWR VPWR sky130_fd_sc_hd__decap_3
XFILLER_45_113 VGND VGND VPWR VPWR sky130_fd_sc_hd__decap_3
XFILLER_65_44 VGND VGND VPWR VPWR sky130_fd_sc_hd__decap_3
XFILLER_65_66 VGND VGND VPWR VPWR sky130_fd_sc_hd__decap_3
XFILLER_73_433 VGND VGND VPWR VPWR sky130_fd_sc_hd__decap_3
XFILLER_46_669 VGND VGND VPWR VPWR sky130_fd_sc_hd__fill_1
XFILLER_61_617 VGND VGND VPWR VPWR sky130_fd_sc_hd__decap_3
XFILLER_65_99 VGND VGND VPWR VPWR sky130_fd_sc_hd__decap_3
XFILLER_60_116 VGND VGND VPWR VPWR sky130_fd_sc_hd__decap_3
XFILLER_73_488 VGND VGND VPWR VPWR sky130_fd_sc_hd__decap_3
XTAP_TAPCELL_ROW_103_1604 VGND VPWR sky130_fd_sc_hd__tapvpwrvgnd_1
XTAP_TAPCELL_ROW_44_837 VGND VPWR sky130_fd_sc_hd__tapvpwrvgnd_1
XTAP_TAPCELL_ROW_44_826 VGND VPWR sky130_fd_sc_hd__tapvpwrvgnd_1
XFILLER_14_533 VGND VGND VPWR VPWR sky130_fd_sc_hd__decap_3
XFILLER_53_190 VGND VGND VPWR VPWR sky130_fd_sc_hd__fill_2
XFILLER_81_43 VGND VGND VPWR VPWR sky130_fd_sc_hd__decap_3
XFILLER_41_374 VGND VGND VPWR VPWR sky130_fd_sc_hd__decap_3
XFILLER_81_87 VGND VGND VPWR VPWR sky130_fd_sc_hd__fill_2
XTAP_TAPCELL_ROW_24_572 VGND VPWR sky130_fd_sc_hd__tapvpwrvgnd_1
XFILLER_41_396 VGND VGND VPWR VPWR sky130_fd_sc_hd__fill_1
XFILLER_81_98 VGND VGND VPWR VPWR sky130_fd_sc_hd__decap_3
XFILLER_6_721 VGND VGND VPWR VPWR sky130_fd_sc_hd__decap_3
XFILLER_108_660 VGND VGND VPWR VPWR sky130_fd_sc_hd__decap_3
XFILLER_114_107 VGND VGND VPWR VPWR sky130_fd_sc_hd__fill_2
XFILLER_5_242 VGND VGND VPWR VPWR sky130_fd_sc_hd__decap_3
XFILLER_107_181 VGND VGND VPWR VPWR sky130_fd_sc_hd__decap_3
XFILLER_108_693 VGND VGND VPWR VPWR sky130_fd_sc_hd__decap_3
XFILLER_114_118 VGND VGND VPWR VPWR sky130_fd_sc_hd__decap_3
XTAP_TAPCELL_ROW_114_1744 VGND VPWR sky130_fd_sc_hd__tapvpwrvgnd_1
XFILLER_96_536 VGND VGND VPWR VPWR sky130_fd_sc_hd__decap_3
XFILLER_110_357 VGND VGND VPWR VPWR sky130_fd_sc_hd__decap_3
XFILLER_49_441 VGND VGND VPWR VPWR sky130_fd_sc_hd__decap_3
XFILLER_37_614 VGND VGND VPWR VPWR sky130_fd_sc_hd__fill_2
XFILLER_49_452 VGND VGND VPWR VPWR sky130_fd_sc_hd__decap_3
XFILLER_83_208 VGND VGND VPWR VPWR sky130_fd_sc_hd__fill_2
XFILLER_83_219 VGND VGND VPWR VPWR sky130_fd_sc_hd__decap_3
Xinput7 operand_a[10] VGND VGND VPWR VPWR input7/X sky130_fd_sc_hd__clkdlybuf4s25_1
XFILLER_36_102 VGND VGND VPWR VPWR sky130_fd_sc_hd__decap_3
XFILLER_49_496 VGND VGND VPWR VPWR sky130_fd_sc_hd__fill_1
XFILLER_64_411 VGND VGND VPWR VPWR sky130_fd_sc_hd__decap_3
XFILLER_76_293 VGND VGND VPWR VPWR sky130_fd_sc_hd__decap_3
XFILLER_37_669 VGND VGND VPWR VPWR sky130_fd_sc_hd__decap_3
XFILLER_64_477 VGND VGND VPWR VPWR sky130_fd_sc_hd__decap_3
XFILLER_91_263 VGND VGND VPWR VPWR sky130_fd_sc_hd__decap_3
XTAP_TAPCELL_ROW_65_1109 VGND VPWR sky130_fd_sc_hd__tapvpwrvgnd_1
XFILLER_17_371 VGND VGND VPWR VPWR sky130_fd_sc_hd__fill_1
XFILLER_45_680 VGND VGND VPWR VPWR sky130_fd_sc_hd__decap_3
XFILLER_45_691 VGND VGND VPWR VPWR sky130_fd_sc_hd__decap_3
XFILLER_51_116 VGND VGND VPWR VPWR sky130_fd_sc_hd__decap_3
XFILLER_91_274 VGND VGND VPWR VPWR sky130_fd_sc_hd__decap_3
X_4951_ _5017_/B VGND VGND VPWR VPWR _4953_/A sky130_fd_sc_hd__inv_2
XFILLER_17_393 VGND VGND VPWR VPWR sky130_fd_sc_hd__decap_3
XFILLER_44_190 VGND VGND VPWR VPWR sky130_fd_sc_hd__decap_3
XFILLER_51_149 VGND VGND VPWR VPWR sky130_fd_sc_hd__decap_3
X_7670_ _7670_/A _7670_/B VGND VGND VPWR VPWR _7671_/A sky130_fd_sc_hd__or2_2
X_4882_ _4882_/A _6400_/B VGND VGND VPWR VPWR _6366_/S sky130_fd_sc_hd__nand2_2
XFILLER_32_352 VGND VGND VPWR VPWR sky130_fd_sc_hd__decap_3
X_6621_ _8192_/Q _8256_/Q _7619_/A VGND VGND VPWR VPWR _6621_/X sky130_fd_sc_hd__o21a_2
XFILLER_32_396 VGND VGND VPWR VPWR sky130_fd_sc_hd__decap_3
XPHY_EDGE_ROW_89_Left_209 VGND VGND VPWR VPWR sky130_fd_sc_hd__decap_3
X_6552_ _7475_/A _6578_/C _6569_/B _5319_/A VGND VGND VPWR VPWR _6552_/X sky130_fd_sc_hd__a2bb2o_2
XFILLER_9_592 VGND VGND VPWR VPWR sky130_fd_sc_hd__decap_3
X_6483_ _6483_/A _6483_/B VGND VGND VPWR VPWR _6484_/B sky130_fd_sc_hd__nand2_2
X_5503_ _6706_/S _5491_/C _8163_/Q _6707_/S VGND VGND VPWR VPWR _5503_/X sky130_fd_sc_hd__a22o_2
X_8222_ _8228_/CLK _8222_/D VGND VGND VPWR VPWR _8222_/Q sky130_fd_sc_hd__dfxtp_2
X_5434_ _6624_/A _5429_/X _5480_/A2 _5433_/X VGND VGND VPWR VPWR _5434_/X sky130_fd_sc_hd__a22o_2
XTAP_TAPCELL_ROW_76_1249 VGND VPWR sky130_fd_sc_hd__tapvpwrvgnd_1
X_8153_ _8285_/CLK _8153_/D VGND VGND VPWR VPWR _8153_/Q sky130_fd_sc_hd__dfxtp_2
X_7104_ _5492_/Y _5293_/Y _7228_/B VGND VGND VPWR VPWR _7104_/X sky130_fd_sc_hd__mux2_2
X_5365_ _5140_/X _5137_/X _5365_/S VGND VGND VPWR VPWR _5366_/A sky130_fd_sc_hd__mux2_2
XFILLER_101_302 VGND VGND VPWR VPWR sky130_fd_sc_hd__decap_3
XFILLER_114_674 VGND VGND VPWR VPWR sky130_fd_sc_hd__fill_1
XFILLER_59_216 VGND VGND VPWR VPWR sky130_fd_sc_hd__decap_3
XFILLER_87_514 VGND VGND VPWR VPWR sky130_fd_sc_hd__decap_3
XFILLER_99_385 VGND VGND VPWR VPWR sky130_fd_sc_hd__decap_3
XFILLER_99_396 VGND VGND VPWR VPWR sky130_fd_sc_hd__decap_3
X_8084_ _8218_/CLK _8084_/D VGND VGND VPWR VPWR _8084_/Q sky130_fd_sc_hd__dfxtp_2
X_5296_ _5296_/A VGND VGND VPWR VPWR _5296_/X sky130_fd_sc_hd__buf_1
X_4316_ _7898_/B _4316_/B VGND VGND VPWR VPWR _4317_/A sky130_fd_sc_hd__and2_2
XFILLER_19_37 VGND VGND VPWR VPWR sky130_fd_sc_hd__decap_3
X_7035_ _8205_/Q _6767_/Y _7034_/Y _5076_/Y VGND VGND VPWR VPWR _7035_/X sky130_fd_sc_hd__o22a_2
X_4247_ _4247_/A VGND VGND VPWR VPWR _8061_/D sky130_fd_sc_hd__buf_1
XFILLER_101_368 VGND VGND VPWR VPWR sky130_fd_sc_hd__decap_3
XFILLER_101_379 VGND VGND VPWR VPWR sky130_fd_sc_hd__decap_3
XPHY_EDGE_ROW_98_Left_218 VGND VGND VPWR VPWR sky130_fd_sc_hd__decap_3
X_4178_ _7898_/B _4178_/B VGND VGND VPWR VPWR _4179_/A sky130_fd_sc_hd__and2_2
XFILLER_27_113 VGND VGND VPWR VPWR sky130_fd_sc_hd__decap_3
XFILLER_55_411 VGND VGND VPWR VPWR sky130_fd_sc_hd__decap_3
XFILLER_27_157 VGND VGND VPWR VPWR sky130_fd_sc_hd__decap_3
XFILLER_43_617 VGND VGND VPWR VPWR sky130_fd_sc_hd__decap_3
XFILLER_82_230 VGND VGND VPWR VPWR sky130_fd_sc_hd__decap_3
XTAP_TAPCELL_ROW_2_289 VGND VPWR sky130_fd_sc_hd__tapvpwrvgnd_1
XFILLER_27_179 VGND VGND VPWR VPWR sky130_fd_sc_hd__decap_3
XFILLER_42_116 VGND VGND VPWR VPWR sky130_fd_sc_hd__decap_3
XFILLER_82_263 VGND VGND VPWR VPWR sky130_fd_sc_hd__decap_3
X_7937_ _8398_/CLK _7937_/D VGND VGND VPWR VPWR _7937_/Q sky130_fd_sc_hd__dfxtp_2
XTAP_TAPCELL_ROW_87_1389 VGND VPWR sky130_fd_sc_hd__tapvpwrvgnd_1
X_7868_ _8304_/Q _7930_/B VGND VGND VPWR VPWR _7869_/A sky130_fd_sc_hd__and2_2
XFILLER_11_514 VGND VGND VPWR VPWR sky130_fd_sc_hd__decap_3
XFILLER_23_374 VGND VGND VPWR VPWR sky130_fd_sc_hd__decap_3
X_6819_ _6819_/A _6819_/B VGND VGND VPWR VPWR _6819_/X sky130_fd_sc_hd__or2_2
XFILLER_11_547 VGND VGND VPWR VPWR sky130_fd_sc_hd__decap_3
XFILLER_23_396 VGND VGND VPWR VPWR sky130_fd_sc_hd__fill_1
XFILLER_50_171 VGND VGND VPWR VPWR sky130_fd_sc_hd__decap_3
X_7799_ _8199_/Q _7663_/B _7660_/X VGND VGND VPWR VPWR _7799_/Y sky130_fd_sc_hd__o21ai_2
XFILLER_51_57 VGND VGND VPWR VPWR sky130_fd_sc_hd__decap_3
XFILLER_7_529 VGND VGND VPWR VPWR sky130_fd_sc_hd__decap_3
XTAP_TAPCELL_ROW_21_531 VGND VPWR sky130_fd_sc_hd__tapvpwrvgnd_1
XFILLER_109_446 VGND VGND VPWR VPWR sky130_fd_sc_hd__fill_2
XFILLER_109_468 VGND VGND VPWR VPWR sky130_fd_sc_hd__decap_3
XFILLER_117_490 VGND VGND VPWR VPWR sky130_fd_sc_hd__decap_3
XFILLER_105_641 VGND VGND VPWR VPWR sky130_fd_sc_hd__decap_3
XFILLER_105_663 VGND VGND VPWR VPWR sky130_fd_sc_hd__decap_3
XFILLER_2_256 VGND VGND VPWR VPWR sky130_fd_sc_hd__decap_3
XFILLER_4_3 VGND VGND VPWR VPWR sky130_fd_sc_hd__fill_2
XFILLER_104_173 VGND VGND VPWR VPWR sky130_fd_sc_hd__fill_2
XFILLER_105_696 VGND VGND VPWR VPWR sky130_fd_sc_hd__fill_1
XFILLER_78_514 VGND VGND VPWR VPWR sky130_fd_sc_hd__decap_3
XFILLER_78_536 VGND VGND VPWR VPWR sky130_fd_sc_hd__decap_3
XFILLER_76_21 VGND VGND VPWR VPWR sky130_fd_sc_hd__decap_3
XFILLER_78_558 VGND VGND VPWR VPWR sky130_fd_sc_hd__decap_3
XFILLER_19_603 VGND VGND VPWR VPWR sky130_fd_sc_hd__fill_2
XFILLER_93_517 VGND VGND VPWR VPWR sky130_fd_sc_hd__decap_3
XFILLER_18_102 VGND VGND VPWR VPWR sky130_fd_sc_hd__decap_3
XFILLER_46_411 VGND VGND VPWR VPWR sky130_fd_sc_hd__decap_3
XFILLER_46_433 VGND VGND VPWR VPWR sky130_fd_sc_hd__fill_1
XFILLER_58_271 VGND VGND VPWR VPWR sky130_fd_sc_hd__decap_3
XFILLER_18_135 VGND VGND VPWR VPWR sky130_fd_sc_hd__decap_3
XFILLER_18_168 VGND VGND VPWR VPWR sky130_fd_sc_hd__decap_3
XFILLER_19_669 VGND VGND VPWR VPWR sky130_fd_sc_hd__decap_3
XFILLER_34_606 VGND VGND VPWR VPWR sky130_fd_sc_hd__decap_3
XFILLER_46_466 VGND VGND VPWR VPWR sky130_fd_sc_hd__decap_3
XFILLER_46_477 VGND VGND VPWR VPWR sky130_fd_sc_hd__decap_3
XTAP_TAPCELL_ROW_29_642 VGND VPWR sky130_fd_sc_hd__tapvpwrvgnd_1
XTAP_TAPCELL_ROW_29_631 VGND VPWR sky130_fd_sc_hd__tapvpwrvgnd_1
XFILLER_27_680 VGND VGND VPWR VPWR sky130_fd_sc_hd__decap_3
XFILLER_33_116 VGND VGND VPWR VPWR sky130_fd_sc_hd__decap_3
XFILLER_61_414 VGND VGND VPWR VPWR sky130_fd_sc_hd__decap_3
XTAP_TAPCELL_ROW_57_995 VGND VPWR sky130_fd_sc_hd__tapvpwrvgnd_1
XFILLER_61_447 VGND VGND VPWR VPWR sky130_fd_sc_hd__fill_1
XFILLER_61_458 VGND VGND VPWR VPWR sky130_fd_sc_hd__fill_1
XFILLER_92_97 VGND VGND VPWR VPWR sky130_fd_sc_hd__decap_3
XFILLER_14_352 VGND VGND VPWR VPWR sky130_fd_sc_hd__decap_3
XFILLER_41_193 VGND VGND VPWR VPWR sky130_fd_sc_hd__decap_3
XTAP_TAPCELL_ROW_60_1039 VGND VPWR sky130_fd_sc_hd__tapvpwrvgnd_1
XFILLER_115_416 VGND VGND VPWR VPWR sky130_fd_sc_hd__decap_3
XFILLER_41_90 VGND VGND VPWR VPWR sky130_fd_sc_hd__decap_3
XFILLER_115_449 VGND VGND VPWR VPWR sky130_fd_sc_hd__decap_3
XFILLER_6_595 VGND VGND VPWR VPWR sky130_fd_sc_hd__decap_3
XFILLER_37_3 VGND VGND VPWR VPWR sky130_fd_sc_hd__decap_3
XFILLER_69_503 VGND VGND VPWR VPWR sky130_fd_sc_hd__fill_1
XFILLER_69_514 VGND VGND VPWR VPWR sky130_fd_sc_hd__decap_3
X_5150_ _5148_/X _5149_/X _5634_/S VGND VGND VPWR VPWR _5150_/X sky130_fd_sc_hd__mux2_2
XFILLER_110_110 VGND VGND VPWR VPWR sky130_fd_sc_hd__decap_3
XFILLER_69_547 VGND VGND VPWR VPWR sky130_fd_sc_hd__decap_3
XFILLER_96_322 VGND VGND VPWR VPWR sky130_fd_sc_hd__decap_3
X_5081_ _7776_/A VGND VGND VPWR VPWR _7787_/A sky130_fd_sc_hd__clkbuf_1
X_4101_ _4101_/A VGND VGND VPWR VPWR _7988_/D sky130_fd_sc_hd__buf_1
XTAP_TAPCELL_ROW_71_1179 VGND VPWR sky130_fd_sc_hd__tapvpwrvgnd_1
XFILLER_2_62 VGND VGND VPWR VPWR sky130_fd_sc_hd__decap_3
XFILLER_96_377 VGND VGND VPWR VPWR sky130_fd_sc_hd__decap_3
X_4032_ _4032_/A _4032_/B _4032_/C _4032_/D VGND VGND VPWR VPWR _4033_/C sky130_fd_sc_hd__or4_2
XFILLER_110_176 VGND VGND VPWR VPWR sky130_fd_sc_hd__decap_3
XFILLER_37_411 VGND VGND VPWR VPWR sky130_fd_sc_hd__decap_3
XFILLER_37_433 VGND VGND VPWR VPWR sky130_fd_sc_hd__decap_3
XFILLER_49_271 VGND VGND VPWR VPWR sky130_fd_sc_hd__fill_1
XFILLER_49_293 VGND VGND VPWR VPWR sky130_fd_sc_hd__decap_3
XFILLER_77_580 VGND VGND VPWR VPWR sky130_fd_sc_hd__decap_3
XFILLER_84_539 VGND VGND VPWR VPWR sky130_fd_sc_hd__decap_3
XFILLER_37_455 VGND VGND VPWR VPWR sky130_fd_sc_hd__decap_3
XFILLER_92_561 VGND VGND VPWR VPWR sky130_fd_sc_hd__decap_3
XFILLER_25_617 VGND VGND VPWR VPWR sky130_fd_sc_hd__fill_2
XFILLER_64_285 VGND VGND VPWR VPWR sky130_fd_sc_hd__decap_3
XFILLER_92_583 VGND VGND VPWR VPWR sky130_fd_sc_hd__decap_3
X_5983_ _7827_/A _5983_/B VGND VGND VPWR VPWR _5983_/X sky130_fd_sc_hd__or2_2
X_7722_ _7797_/A1 _7716_/X _7719_/Y _5363_/X _7721_/Y VGND VGND VPWR VPWR _7722_/X
+ sky130_fd_sc_hd__o221a_2
X_4934_ _8168_/Q _8232_/Q VGND VGND VPWR VPWR _5867_/A sky130_fd_sc_hd__xor2_2
XFILLER_33_650 VGND VGND VPWR VPWR sky130_fd_sc_hd__decap_3
XANTENNA_12 _5036_/X VGND VGND VPWR VPWR sky130_fd_sc_hd__diode_2
XANTENNA_23 _7273_/X VGND VGND VPWR VPWR sky130_fd_sc_hd__diode_2
XFILLER_20_333 VGND VGND VPWR VPWR sky130_fd_sc_hd__decap_3
XFILLER_60_480 VGND VGND VPWR VPWR sky130_fd_sc_hd__decap_3
X_7653_ _7653_/A VGND VGND VPWR VPWR _7653_/X sky130_fd_sc_hd__buf_1
X_4865_ _8191_/Q VGND VGND VPWR VPWR _6605_/A sky130_fd_sc_hd__inv_2
XFILLER_119_722 VGND VGND VPWR VPWR sky130_fd_sc_hd__decap_3
X_7584_ _8220_/Q _8221_/Q VGND VGND VPWR VPWR _7612_/D sky130_fd_sc_hd__nand2_2
X_6604_ _6550_/X _6605_/A _6794_/A VGND VGND VPWR VPWR _6604_/X sky130_fd_sc_hd__and3b_2
X_4796_ _8204_/Q _8268_/Q VGND VGND VPWR VPWR _6992_/A sky130_fd_sc_hd__nor2b_2
XFILLER_20_377 VGND VGND VPWR VPWR sky130_fd_sc_hd__decap_3
X_6535_ _5528_/A _6534_/X _5124_/A VGND VGND VPWR VPWR _6535_/Y sky130_fd_sc_hd__o21ai_2
XFILLER_106_427 VGND VGND VPWR VPWR sky130_fd_sc_hd__decap_3
XFILLER_108_9 VGND VGND VPWR VPWR sky130_fd_sc_hd__decap_3
X_8205_ _8207_/CLK _8205_/D VGND VGND VPWR VPWR _8205_/Q sky130_fd_sc_hd__dfxtp_4
X_6466_ _8289_/Q _6592_/B _6465_/X VGND VGND VPWR VPWR _6466_/X sky130_fd_sc_hd__o21a_2
Xoutput152 _7979_/Q VGND VGND VPWR VPWR result[21] sky130_fd_sc_hd__clkdlybuf4s25_1
Xoutput141 _7969_/Q VGND VGND VPWR VPWR result[11] sky130_fd_sc_hd__clkdlybuf4s25_1
X_6397_ _8245_/Q _6398_/B _8181_/Q VGND VGND VPWR VPWR _6397_/Y sky130_fd_sc_hd__o21bai_2
X_5417_ _5417_/A _5417_/B VGND VGND VPWR VPWR _5417_/Y sky130_fd_sc_hd__nand2_2
X_8136_ _8355_/CLK _8136_/D VGND VGND VPWR VPWR _8136_/Q sky130_fd_sc_hd__dfxtp_2
Xoutput185 _8009_/Q VGND VGND VPWR VPWR result[51] sky130_fd_sc_hd__clkdlybuf4s25_1
Xoutput174 _7999_/Q VGND VGND VPWR VPWR result[41] sky130_fd_sc_hd__clkdlybuf4s25_1
Xoutput163 _7989_/Q VGND VGND VPWR VPWR result[31] sky130_fd_sc_hd__clkdlybuf4s25_1
X_5348_ _5348_/A VGND VGND VPWR VPWR _5348_/Y sky130_fd_sc_hd__inv_2
XTAP_TAPCELL_ROW_7_348 VGND VPWR sky130_fd_sc_hd__tapvpwrvgnd_1
XFILLER_101_110 VGND VGND VPWR VPWR sky130_fd_sc_hd__fill_2
X_8067_ _8207_/CLK _8067_/D VGND VGND VPWR VPWR _8067_/Q sky130_fd_sc_hd__dfxtp_2
Xoutput196 _8019_/Q VGND VGND VPWR VPWR result[61] sky130_fd_sc_hd__clkdlybuf4s25_1
XFILLER_101_165 VGND VGND VPWR VPWR sky130_fd_sc_hd__decap_3
XFILLER_75_517 VGND VGND VPWR VPWR sky130_fd_sc_hd__decap_3
X_7018_ _7016_/Y _7017_/X _5714_/A VGND VGND VPWR VPWR _7024_/C sky130_fd_sc_hd__a21oi_2
X_5279_ _7783_/A _7619_/A _6763_/A VGND VGND VPWR VPWR _5279_/X sky130_fd_sc_hd__or3_2
XTAP_TAPCELL_ROW_89_1418 VGND VPWR sky130_fd_sc_hd__tapvpwrvgnd_1
XFILLER_28_455 VGND VGND VPWR VPWR sky130_fd_sc_hd__decap_3
XFILLER_46_35 VGND VGND VPWR VPWR sky130_fd_sc_hd__decap_3
XFILLER_46_57 VGND VGND VPWR VPWR sky130_fd_sc_hd__decap_3
XFILLER_83_561 VGND VGND VPWR VPWR sky130_fd_sc_hd__decap_3
XFILLER_43_414 VGND VGND VPWR VPWR sky130_fd_sc_hd__decap_3
XFILLER_55_263 VGND VGND VPWR VPWR sky130_fd_sc_hd__decap_3
XFILLER_70_200 VGND VGND VPWR VPWR sky130_fd_sc_hd__decap_3
XTAP_TAPCELL_ROW_26_601 VGND VPWR sky130_fd_sc_hd__tapvpwrvgnd_1
XFILLER_102_41 VGND VGND VPWR VPWR sky130_fd_sc_hd__decap_3
XFILLER_15_149 VGND VGND VPWR VPWR sky130_fd_sc_hd__decap_3
XFILLER_55_296 VGND VGND VPWR VPWR sky130_fd_sc_hd__decap_3
XFILLER_70_233 VGND VGND VPWR VPWR sky130_fd_sc_hd__decap_3
XTAP_TAPCELL_ROW_54_965 VGND VPWR sky130_fd_sc_hd__tapvpwrvgnd_1
XFILLER_102_96 VGND VGND VPWR VPWR sky130_fd_sc_hd__decap_3
XFILLER_24_650 VGND VGND VPWR VPWR sky130_fd_sc_hd__decap_3
XFILLER_43_469 VGND VGND VPWR VPWR sky130_fd_sc_hd__decap_3
XFILLER_62_23 VGND VGND VPWR VPWR sky130_fd_sc_hd__decap_3
XFILLER_11_311 VGND VGND VPWR VPWR sky130_fd_sc_hd__decap_3
XFILLER_24_694 VGND VGND VPWR VPWR sky130_fd_sc_hd__decap_3
XFILLER_51_491 VGND VGND VPWR VPWR sky130_fd_sc_hd__decap_3
XFILLER_62_56 VGND VGND VPWR VPWR sky130_fd_sc_hd__decap_3
XFILLER_62_78 VGND VGND VPWR VPWR sky130_fd_sc_hd__fill_1
XFILLER_11_366 VGND VGND VPWR VPWR sky130_fd_sc_hd__decap_3
XFILLER_7_29 VGND VGND VPWR VPWR sky130_fd_sc_hd__decap_3
XFILLER_7_326 VGND VGND VPWR VPWR sky130_fd_sc_hd__decap_3
XFILLER_7_337 VGND VGND VPWR VPWR sky130_fd_sc_hd__decap_3
XFILLER_109_243 VGND VGND VPWR VPWR sky130_fd_sc_hd__decap_3
XFILLER_11_60 VGND VGND VPWR VPWR sky130_fd_sc_hd__fill_2
XFILLER_11_82 VGND VGND VPWR VPWR sky130_fd_sc_hd__fill_2
XFILLER_3_554 VGND VGND VPWR VPWR sky130_fd_sc_hd__decap_3
XTAP_TAPCELL_ROW_111_1703 VGND VPWR sky130_fd_sc_hd__tapvpwrvgnd_1
XFILLER_105_471 VGND VGND VPWR VPWR sky130_fd_sc_hd__decap_3
XFILLER_112_419 VGND VGND VPWR VPWR sky130_fd_sc_hd__fill_1
XFILLER_87_31 VGND VGND VPWR VPWR sky130_fd_sc_hd__fill_1
XFILLER_87_42 VGND VGND VPWR VPWR sky130_fd_sc_hd__decap_3
XFILLER_78_333 VGND VGND VPWR VPWR sky130_fd_sc_hd__decap_3
XFILLER_87_75 VGND VGND VPWR VPWR sky130_fd_sc_hd__decap_3
XFILLER_66_517 VGND VGND VPWR VPWR sky130_fd_sc_hd__decap_3
XFILLER_78_377 VGND VGND VPWR VPWR sky130_fd_sc_hd__decap_3
XFILLER_66_539 VGND VGND VPWR VPWR sky130_fd_sc_hd__decap_3
XFILLER_93_325 VGND VGND VPWR VPWR sky130_fd_sc_hd__fill_2
XFILLER_19_455 VGND VGND VPWR VPWR sky130_fd_sc_hd__fill_1
XFILLER_46_230 VGND VGND VPWR VPWR sky130_fd_sc_hd__fill_2
XFILLER_62_701 VGND VGND VPWR VPWR sky130_fd_sc_hd__decap_3
XFILLER_93_358 VGND VGND VPWR VPWR sky130_fd_sc_hd__decap_3
XFILLER_34_403 VGND VGND VPWR VPWR sky130_fd_sc_hd__decap_3
XFILLER_74_583 VGND VGND VPWR VPWR sky130_fd_sc_hd__decap_3
XTAP_TAPCELL_ROW_109_1676 VGND VPWR sky130_fd_sc_hd__tapvpwrvgnd_1
XFILLER_61_222 VGND VGND VPWR VPWR sky130_fd_sc_hd__fill_2
XFILLER_61_244 VGND VGND VPWR VPWR sky130_fd_sc_hd__decap_3
XFILLER_42_480 VGND VGND VPWR VPWR sky130_fd_sc_hd__fill_1
X_4650_ _7930_/B _8129_/Q VGND VGND VPWR VPWR _4651_/A sky130_fd_sc_hd__and2_2
XFILLER_30_675 VGND VGND VPWR VPWR sky130_fd_sc_hd__fill_2
Xinput10 operand_a[13] VGND VGND VPWR VPWR _4202_/B sky130_fd_sc_hd__clkdlybuf4s25_1
Xinput21 operand_a[23] VGND VGND VPWR VPWR _4222_/B sky130_fd_sc_hd__clkdlybuf4s25_1
Xinput54 operand_a[53] VGND VGND VPWR VPWR _4282_/B sky130_fd_sc_hd__clkdlybuf4s25_1
Xinput43 operand_a[43] VGND VGND VPWR VPWR _4262_/B sky130_fd_sc_hd__clkdlybuf4s25_1
Xinput32 operand_a[33] VGND VGND VPWR VPWR _4242_/B sky130_fd_sc_hd__clkdlybuf4s25_1
X_6320_ _5673_/A _6426_/B _6272_/Y VGND VGND VPWR VPWR _6320_/Y sky130_fd_sc_hd__o21ai_2
X_4581_ _4581_/A VGND VGND VPWR VPWR _8228_/D sky130_fd_sc_hd__buf_1
XFILLER_115_202 VGND VGND VPWR VPWR sky130_fd_sc_hd__decap_3
XFILLER_115_213 VGND VGND VPWR VPWR sky130_fd_sc_hd__fill_1
Xinput98 operand_b[35] VGND VGND VPWR VPWR _4374_/B sky130_fd_sc_hd__clkdlybuf4s25_1
Xinput87 operand_b[25] VGND VGND VPWR VPWR _4354_/B sky130_fd_sc_hd__clkdlybuf4s25_1
Xinput76 operand_b[15] VGND VGND VPWR VPWR _4334_/B sky130_fd_sc_hd__clkdlybuf4s25_1
Xinput65 operand_a[63] VGND VGND VPWR VPWR _4302_/B sky130_fd_sc_hd__clkdlybuf4s25_1
X_6251_ _6251_/A _6251_/B _6250_/X VGND VGND VPWR VPWR _6251_/X sky130_fd_sc_hd__or3b_2
XTAP_TAPCELL_ROW_73_1208 VGND VPWR sky130_fd_sc_hd__tapvpwrvgnd_1
XFILLER_103_408 VGND VGND VPWR VPWR sky130_fd_sc_hd__decap_3
XFILLER_115_279 VGND VGND VPWR VPWR sky130_fd_sc_hd__fill_1
XFILLER_69_311 VGND VGND VPWR VPWR sky130_fd_sc_hd__decap_3
XFILLER_97_620 VGND VGND VPWR VPWR sky130_fd_sc_hd__decap_3
X_6182_ _6297_/C _6183_/B VGND VGND VPWR VPWR _6184_/A sky130_fd_sc_hd__nor2_2
X_5202_ _8223_/Q _5201_/X _5444_/S VGND VGND VPWR VPWR _5911_/B sky130_fd_sc_hd__mux2_2
XFILLER_97_653 VGND VGND VPWR VPWR sky130_fd_sc_hd__decap_3
X_5133_ _8212_/Q _8213_/Q _5484_/S VGND VGND VPWR VPWR _5133_/X sky130_fd_sc_hd__mux2_2
XFILLER_69_355 VGND VGND VPWR VPWR sky130_fd_sc_hd__fill_1
XFILLER_69_366 VGND VGND VPWR VPWR sky130_fd_sc_hd__decap_3
XFILLER_96_141 VGND VGND VPWR VPWR sky130_fd_sc_hd__decap_3
XTAP_TAPCELL_ROW_4_307 VGND VPWR sky130_fd_sc_hd__tapvpwrvgnd_1
XFILLER_69_399 VGND VGND VPWR VPWR sky130_fd_sc_hd__fill_2
XFILLER_84_336 VGND VGND VPWR VPWR sky130_fd_sc_hd__decap_3
XFILLER_96_174 VGND VGND VPWR VPWR sky130_fd_sc_hd__decap_3
X_5064_ _8266_/Q _5063_/Y _4817_/A VGND VGND VPWR VPWR _5064_/X sky130_fd_sc_hd__a21o_2
X_4015_ _8306_/Q _8310_/Q _8313_/Q _8315_/Q VGND VGND VPWR VPWR _4017_/C sky130_fd_sc_hd__or4_2
XFILLER_65_561 VGND VGND VPWR VPWR sky130_fd_sc_hd__decap_3
XFILLER_16_27 VGND VGND VPWR VPWR sky130_fd_sc_hd__fill_1
XFILLER_52_244 VGND VGND VPWR VPWR sky130_fd_sc_hd__decap_3
XFILLER_92_380 VGND VGND VPWR VPWR sky130_fd_sc_hd__decap_3
XTAP_TAPCELL_ROW_84_1348 VGND VPWR sky130_fd_sc_hd__tapvpwrvgnd_1
XFILLER_40_406 VGND VGND VPWR VPWR sky130_fd_sc_hd__decap_3
XFILLER_80_575 VGND VGND VPWR VPWR sky130_fd_sc_hd__decap_3
X_5966_ _5966_/A VGND VGND VPWR VPWR _5966_/X sky130_fd_sc_hd__buf_1
XFILLER_33_491 VGND VGND VPWR VPWR sky130_fd_sc_hd__decap_3
XFILLER_40_439 VGND VGND VPWR VPWR sky130_fd_sc_hd__decap_3
X_7705_ _7652_/Y _7705_/B _7705_/C VGND VGND VPWR VPWR _7705_/X sky130_fd_sc_hd__and3b_2
X_5897_ _5897_/A _8172_/Q _5897_/C VGND VGND VPWR VPWR _7010_/B sky130_fd_sc_hd__and3_2
X_4917_ _4917_/A _4917_/B _4917_/C VGND VGND VPWR VPWR _4971_/C sky130_fd_sc_hd__or3_2
XTAP_TAPCELL_ROW_51_924 VGND VPWR sky130_fd_sc_hd__tapvpwrvgnd_1
XFILLER_20_141 VGND VGND VPWR VPWR sky130_fd_sc_hd__decap_3
XFILLER_32_26 VGND VGND VPWR VPWR sky130_fd_sc_hd__fill_2
X_7636_ _7631_/X _7844_/D VGND VGND VPWR VPWR _7636_/Y sky130_fd_sc_hd__nand2b_4
X_4848_ _8258_/Q _8194_/Q VGND VGND VPWR VPWR _4849_/B sky130_fd_sc_hd__and2b_2
XFILLER_20_174 VGND VGND VPWR VPWR sky130_fd_sc_hd__decap_3
XFILLER_32_59 VGND VGND VPWR VPWR sky130_fd_sc_hd__decap_3
XFILLER_4_307 VGND VGND VPWR VPWR sky130_fd_sc_hd__fill_1
X_7567_ _7567_/A _7567_/B _7567_/C _7567_/D VGND VGND VPWR VPWR _7567_/X sky130_fd_sc_hd__or4_4
X_4779_ _7195_/A _8273_/Q VGND VGND VPWR VPWR _4780_/A sky130_fd_sc_hd__nor2_2
XFILLER_106_224 VGND VGND VPWR VPWR sky130_fd_sc_hd__decap_3
XFILLER_4_318 VGND VGND VPWR VPWR sky130_fd_sc_hd__decap_3
X_7498_ _8283_/Q _5292_/X _5111_/X VGND VGND VPWR VPWR _7498_/X sky130_fd_sc_hd__a21o_2
X_6518_ _6184_/B _6484_/Y _6486_/Y _5508_/A _6517_/X VGND VGND VPWR VPWR _6519_/B
+ sky130_fd_sc_hd__o221a_4
X_6449_ _8251_/Q _6439_/X _6448_/X VGND VGND VPWR VPWR _6450_/B sky130_fd_sc_hd__o21ai_2
XTAP_TAPCELL_ROW_95_1488 VGND VPWR sky130_fd_sc_hd__tapvpwrvgnd_1
XFILLER_106_268 VGND VGND VPWR VPWR sky130_fd_sc_hd__decap_3
XFILLER_79_108 VGND VGND VPWR VPWR sky130_fd_sc_hd__decap_3
XTAP_TAPCELL_ROW_95_1499 VGND VPWR sky130_fd_sc_hd__tapvpwrvgnd_1
XFILLER_102_430 VGND VGND VPWR VPWR sky130_fd_sc_hd__decap_3
XFILLER_88_631 VGND VGND VPWR VPWR sky130_fd_sc_hd__decap_3
X_8119_ _8389_/CLK _8119_/D VGND VGND VPWR VPWR _8119_/Q sky130_fd_sc_hd__dfxtp_2
XFILLER_48_517 VGND VGND VPWR VPWR sky130_fd_sc_hd__decap_3
XFILLER_87_152 VGND VGND VPWR VPWR sky130_fd_sc_hd__decap_3
XFILLER_48_539 VGND VGND VPWR VPWR sky130_fd_sc_hd__decap_3
XFILLER_87_196 VGND VGND VPWR VPWR sky130_fd_sc_hd__decap_3
XFILLER_75_347 VGND VGND VPWR VPWR sky130_fd_sc_hd__decap_3
XFILLER_113_51 VGND VGND VPWR VPWR sky130_fd_sc_hd__decap_3
XFILLER_44_701 VGND VGND VPWR VPWR sky130_fd_sc_hd__fill_1
XFILLER_90_306 VGND VGND VPWR VPWR sky130_fd_sc_hd__fill_2
XTAP_TAPCELL_ROW_39_770 VGND VPWR sky130_fd_sc_hd__tapvpwrvgnd_1
XFILLER_16_436 VGND VGND VPWR VPWR sky130_fd_sc_hd__decap_3
XFILLER_43_222 VGND VGND VPWR VPWR sky130_fd_sc_hd__fill_2
XFILLER_83_391 VGND VGND VPWR VPWR sky130_fd_sc_hd__fill_1
XFILLER_71_564 VGND VGND VPWR VPWR sky130_fd_sc_hd__decap_3
XFILLER_12_620 VGND VGND VPWR VPWR sky130_fd_sc_hd__decap_3
XFILLER_71_597 VGND VGND VPWR VPWR sky130_fd_sc_hd__fill_1
XFILLER_12_664 VGND VGND VPWR VPWR sky130_fd_sc_hd__fill_2
XFILLER_11_163 VGND VGND VPWR VPWR sky130_fd_sc_hd__decap_3
XFILLER_7_101 VGND VGND VPWR VPWR sky130_fd_sc_hd__decap_3
XTAP_TAPCELL_ROW_59_1030 VGND VPWR sky130_fd_sc_hd__tapvpwrvgnd_1
XFILLER_112_205 VGND VGND VPWR VPWR sky130_fd_sc_hd__decap_3
XFILLER_3_340 VGND VGND VPWR VPWR sky130_fd_sc_hd__decap_3
XFILLER_98_417 VGND VGND VPWR VPWR sky130_fd_sc_hd__decap_3
XFILLER_98_74 VGND VGND VPWR VPWR sky130_fd_sc_hd__decap_3
XFILLER_98_85 VGND VGND VPWR VPWR sky130_fd_sc_hd__decap_3
XFILLER_79_620 VGND VGND VPWR VPWR sky130_fd_sc_hd__decap_3
XFILLER_105_290 VGND VGND VPWR VPWR sky130_fd_sc_hd__decap_3
XFILLER_66_303 VGND VGND VPWR VPWR sky130_fd_sc_hd__decap_3
XFILLER_78_130 VGND VGND VPWR VPWR sky130_fd_sc_hd__decap_3
XFILLER_78_141 VGND VGND VPWR VPWR sky130_fd_sc_hd__decap_3
XFILLER_79_653 VGND VGND VPWR VPWR sky130_fd_sc_hd__decap_3
XFILLER_39_528 VGND VGND VPWR VPWR sky130_fd_sc_hd__decap_3
XFILLER_78_163 VGND VGND VPWR VPWR sky130_fd_sc_hd__fill_1
XFILLER_93_111 VGND VGND VPWR VPWR sky130_fd_sc_hd__fill_1
XFILLER_93_122 VGND VGND VPWR VPWR sky130_fd_sc_hd__fill_1
XFILLER_94_645 VGND VGND VPWR VPWR sky130_fd_sc_hd__fill_2
XFILLER_93_144 VGND VGND VPWR VPWR sky130_fd_sc_hd__decap_3
XFILLER_94_656 VGND VGND VPWR VPWR sky130_fd_sc_hd__decap_3
XFILLER_19_263 VGND VGND VPWR VPWR sky130_fd_sc_hd__decap_3
XFILLER_19_274 VGND VGND VPWR VPWR sky130_fd_sc_hd__decap_3
XFILLER_34_200 VGND VGND VPWR VPWR sky130_fd_sc_hd__decap_3
XFILLER_35_701 VGND VGND VPWR VPWR sky130_fd_sc_hd__fill_1
XFILLER_47_561 VGND VGND VPWR VPWR sky130_fd_sc_hd__decap_3
XFILLER_81_328 VGND VGND VPWR VPWR sky130_fd_sc_hd__decap_3
XFILLER_47_594 VGND VGND VPWR VPWR sky130_fd_sc_hd__decap_3
XFILLER_62_531 VGND VGND VPWR VPWR sky130_fd_sc_hd__fill_1
XFILLER_74_380 VGND VGND VPWR VPWR sky130_fd_sc_hd__decap_3
XFILLER_50_704 VGND VGND VPWR VPWR sky130_fd_sc_hd__decap_3
XFILLER_62_553 VGND VGND VPWR VPWR sky130_fd_sc_hd__decap_3
XFILLER_62_575 VGND VGND VPWR VPWR sky130_fd_sc_hd__decap_3
X_5820_ _5453_/X _5445_/X _6648_/A VGND VGND VPWR VPWR _5820_/X sky130_fd_sc_hd__mux2_2
XFILLER_34_277 VGND VGND VPWR VPWR sky130_fd_sc_hd__fill_2
XFILLER_34_299 VGND VGND VPWR VPWR sky130_fd_sc_hd__decap_3
X_5751_ _5262_/X _5267_/X _5228_/X _5250_/X _6784_/A _6648_/A VGND VGND VPWR VPWR
+ _5752_/B sky130_fd_sc_hd__mux4_2
XTAP_TAPCELL_ROW_17_486 VGND VPWR sky130_fd_sc_hd__tapvpwrvgnd_1
XTAP_TAPCELL_ROW_17_475 VGND VPWR sky130_fd_sc_hd__tapvpwrvgnd_1
XFILLER_15_491 VGND VGND VPWR VPWR sky130_fd_sc_hd__decap_3
X_4702_ _7898_/B _8155_/Q VGND VGND VPWR VPWR _4703_/A sky130_fd_sc_hd__and2_2
X_7421_ _7193_/A _7420_/X _6454_/A VGND VGND VPWR VPWR _7421_/Y sky130_fd_sc_hd__o21ai_2
X_5682_ _6648_/A _5680_/Y _5681_/Y _7745_/B VGND VGND VPWR VPWR _5683_/B sky130_fd_sc_hd__o22a_2
XFILLER_8_83 VGND VGND VPWR VPWR sky130_fd_sc_hd__fill_1
X_4633_ _4633_/A VGND VGND VPWR VPWR _8254_/D sky130_fd_sc_hd__buf_1
XFILLER_116_522 VGND VGND VPWR VPWR sky130_fd_sc_hd__decap_3
XFILLER_118_18 VGND VGND VPWR VPWR sky130_fd_sc_hd__decap_3
XFILLER_118_29 VGND VGND VPWR VPWR sky130_fd_sc_hd__decap_3
X_7352_ _6248_/Y _7193_/Y _6243_/Y VGND VGND VPWR VPWR _7352_/Y sky130_fd_sc_hd__a21oi_2
X_4564_ _7843_/A _8086_/Q VGND VGND VPWR VPWR _4565_/A sky130_fd_sc_hd__and2_2
X_7283_ _7283_/A VGND VGND VPWR VPWR _7284_/C sky130_fd_sc_hd__inv_2
X_6303_ _6303_/A _6303_/B VGND VGND VPWR VPWR _6359_/B sky130_fd_sc_hd__or2_2
XFILLER_103_205 VGND VGND VPWR VPWR sky130_fd_sc_hd__decap_3
XFILLER_89_428 VGND VGND VPWR VPWR sky130_fd_sc_hd__decap_3
X_6234_ _8181_/Q _6548_/C VGND VGND VPWR VPWR _6235_/B sky130_fd_sc_hd__nand2_2
X_4495_ _4495_/A VGND VGND VPWR VPWR _8185_/D sky130_fd_sc_hd__buf_1
XFILLER_103_249 VGND VGND VPWR VPWR sky130_fd_sc_hd__decap_3
XFILLER_69_141 VGND VGND VPWR VPWR sky130_fd_sc_hd__decap_3
XFILLER_97_461 VGND VGND VPWR VPWR sky130_fd_sc_hd__decap_3
X_6165_ _8180_/Q _8179_/Q _6380_/S VGND VGND VPWR VPWR _6165_/X sky130_fd_sc_hd__mux2_2
XFILLER_111_271 VGND VGND VPWR VPWR sky130_fd_sc_hd__decap_3
XFILLER_85_612 VGND VGND VPWR VPWR sky130_fd_sc_hd__decap_3
XFILLER_85_634 VGND VGND VPWR VPWR sky130_fd_sc_hd__decap_3
XFILLER_97_494 VGND VGND VPWR VPWR sky130_fd_sc_hd__fill_2
X_6096_ _6096_/A _6147_/D VGND VGND VPWR VPWR _6114_/B sky130_fd_sc_hd__or2_4
X_5116_ _5116_/A VGND VGND VPWR VPWR _6247_/B sky130_fd_sc_hd__buf_1
XFILLER_27_26 VGND VGND VPWR VPWR sky130_fd_sc_hd__fill_1
XFILLER_57_358 VGND VGND VPWR VPWR sky130_fd_sc_hd__decap_3
XFILLER_69_196 VGND VGND VPWR VPWR sky130_fd_sc_hd__decap_3
XFILLER_84_155 VGND VGND VPWR VPWR sky130_fd_sc_hd__decap_3
XFILLER_85_656 VGND VGND VPWR VPWR sky130_fd_sc_hd__decap_3
X_5047_ _5046_/X _4882_/A _4881_/A _4887_/A VGND VGND VPWR VPWR _5048_/B sky130_fd_sc_hd__a211oi_2
XFILLER_26_701 VGND VGND VPWR VPWR sky130_fd_sc_hd__decap_3
XFILLER_27_48 VGND VGND VPWR VPWR sky130_fd_sc_hd__decap_3
XFILLER_72_306 VGND VGND VPWR VPWR sky130_fd_sc_hd__fill_2
XFILLER_85_689 VGND VGND VPWR VPWR sky130_fd_sc_hd__decap_3
XFILLER_53_520 VGND VGND VPWR VPWR sky130_fd_sc_hd__fill_1
XFILLER_65_391 VGND VGND VPWR VPWR sky130_fd_sc_hd__fill_1
XFILLER_72_339 VGND VGND VPWR VPWR sky130_fd_sc_hd__decap_3
XFILLER_25_266 VGND VGND VPWR VPWR sky130_fd_sc_hd__decap_3
XFILLER_53_575 VGND VGND VPWR VPWR sky130_fd_sc_hd__decap_3
X_6998_ _8204_/Q _8268_/Q VGND VGND VPWR VPWR _6998_/X sky130_fd_sc_hd__and2_2
XFILLER_40_203 VGND VGND VPWR VPWR sky130_fd_sc_hd__fill_1
XFILLER_40_225 VGND VGND VPWR VPWR sky130_fd_sc_hd__decap_3
XFILLER_43_36 VGND VGND VPWR VPWR sky130_fd_sc_hd__decap_3
X_5949_ _5579_/X _5576_/B _6818_/S VGND VGND VPWR VPWR _5949_/X sky130_fd_sc_hd__mux2_2
XFILLER_40_247 VGND VGND VPWR VPWR sky130_fd_sc_hd__decap_3
XFILLER_43_69 VGND VGND VPWR VPWR sky130_fd_sc_hd__decap_3
X_7619_ _7619_/A _7631_/B _8290_/Q _8287_/Q VGND VGND VPWR VPWR _7619_/X sky130_fd_sc_hd__and4_2
Xrebuffer732 _6211_/Y VGND VGND VPWR VPWR _6213_/B1 sky130_fd_sc_hd__buf_2
XTAP_TAPCELL_ROW_97_1517 VGND VPWR sky130_fd_sc_hd__tapvpwrvgnd_1
XFILLER_107_522 VGND VGND VPWR VPWR sky130_fd_sc_hd__decap_3
XFILLER_119_382 VGND VGND VPWR VPWR sky130_fd_sc_hd__decap_3
XFILLER_4_115 VGND VGND VPWR VPWR sky130_fd_sc_hd__decap_3
Xrebuffer765 _4963_/X VGND VGND VPWR VPWR _5194_/B sky130_fd_sc_hd__buf_2
XFILLER_104_3 VGND VGND VPWR VPWR sky130_fd_sc_hd__fill_2
XFILLER_119_393 VGND VGND VPWR VPWR sky130_fd_sc_hd__decap_3
Xrebuffer798 _6306_/X VGND VGND VPWR VPWR _6307_/B sky130_fd_sc_hd__buf_4
XFILLER_68_11 VGND VGND VPWR VPWR sky130_fd_sc_hd__decap_3
XFILLER_0_343 VGND VGND VPWR VPWR sky130_fd_sc_hd__fill_2
XFILLER_0_354 VGND VGND VPWR VPWR sky130_fd_sc_hd__decap_3
XFILLER_68_55 VGND VGND VPWR VPWR sky130_fd_sc_hd__fill_2
XFILLER_0_365 VGND VGND VPWR VPWR sky130_fd_sc_hd__fill_2
XFILLER_48_325 VGND VGND VPWR VPWR sky130_fd_sc_hd__fill_2
XFILLER_68_88 VGND VGND VPWR VPWR sky130_fd_sc_hd__decap_3
XFILLER_76_623 VGND VGND VPWR VPWR sky130_fd_sc_hd__decap_3
XFILLER_88_472 VGND VGND VPWR VPWR sky130_fd_sc_hd__decap_3
XFILLER_88_483 VGND VGND VPWR VPWR sky130_fd_sc_hd__decap_3
XFILLER_102_293 VGND VGND VPWR VPWR sky130_fd_sc_hd__decap_3
XFILLER_75_122 VGND VGND VPWR VPWR sky130_fd_sc_hd__decap_3
XFILLER_76_678 VGND VGND VPWR VPWR sky130_fd_sc_hd__decap_3
XFILLER_84_32 VGND VGND VPWR VPWR sky130_fd_sc_hd__decap_3
XFILLER_29_561 VGND VGND VPWR VPWR sky130_fd_sc_hd__decap_3
XFILLER_29_572 VGND VGND VPWR VPWR sky130_fd_sc_hd__decap_3
XFILLER_63_306 VGND VGND VPWR VPWR sky130_fd_sc_hd__decap_3
XFILLER_84_43 VGND VGND VPWR VPWR sky130_fd_sc_hd__fill_2
XFILLER_16_233 VGND VGND VPWR VPWR sky130_fd_sc_hd__fill_1
XFILLER_56_380 VGND VGND VPWR VPWR sky130_fd_sc_hd__decap_3
XTAP_TAPCELL_ROW_106_1635 VGND VPWR sky130_fd_sc_hd__tapvpwrvgnd_1
XFILLER_32_704 VGND VGND VPWR VPWR sky130_fd_sc_hd__decap_3
XFILLER_71_361 VGND VGND VPWR VPWR sky130_fd_sc_hd__decap_3
XFILLER_90_158 VGND VGND VPWR VPWR sky130_fd_sc_hd__decap_3
XFILLER_31_225 VGND VGND VPWR VPWR sky130_fd_sc_hd__decap_3
XTAP_TAPCELL_ROW_14_445 VGND VPWR sky130_fd_sc_hd__tapvpwrvgnd_1
XFILLER_12_472 VGND VGND VPWR VPWR sky130_fd_sc_hd__decap_3
XFILLER_31_269 VGND VGND VPWR VPWR sky130_fd_sc_hd__decap_3
XFILLER_33_91 VGND VGND VPWR VPWR sky130_fd_sc_hd__decap_3
XFILLER_8_465 VGND VGND VPWR VPWR sky130_fd_sc_hd__decap_3
XFILLER_8_498 VGND VGND VPWR VPWR sky130_fd_sc_hd__decap_3
XTAP_TAPCELL_ROW_117_1775 VGND VPWR sky130_fd_sc_hd__tapvpwrvgnd_1
XFILLER_4_660 VGND VGND VPWR VPWR sky130_fd_sc_hd__decap_3
XFILLER_98_203 VGND VGND VPWR VPWR sky130_fd_sc_hd__decap_3
XTAP_TAPCELL_ROW_117_1786 VGND VPWR sky130_fd_sc_hd__tapvpwrvgnd_1
XFILLER_4_693 VGND VGND VPWR VPWR sky130_fd_sc_hd__decap_3
X_4280_ _7843_/A _4280_/B VGND VGND VPWR VPWR _4281_/A sky130_fd_sc_hd__and2_2
XFILLER_100_208 VGND VGND VPWR VPWR sky130_fd_sc_hd__decap_3
XFILLER_39_314 VGND VGND VPWR VPWR sky130_fd_sc_hd__decap_3
XFILLER_67_623 VGND VGND VPWR VPWR sky130_fd_sc_hd__decap_3
XFILLER_94_442 VGND VGND VPWR VPWR sky130_fd_sc_hd__decap_3
XFILLER_54_306 VGND VGND VPWR VPWR sky130_fd_sc_hd__fill_2
XFILLER_66_177 VGND VGND VPWR VPWR sky130_fd_sc_hd__decap_3
XFILLER_82_615 VGND VGND VPWR VPWR sky130_fd_sc_hd__decap_3
X_7970_ _8382_/CLK _7970_/D VGND VGND VPWR VPWR _7970_/Q sky130_fd_sc_hd__dfxtp_2
Xsplit396 _8167_/Q VGND VGND VPWR VPWR _7809_/A1 sky130_fd_sc_hd__buf_4
XFILLER_35_520 VGND VGND VPWR VPWR sky130_fd_sc_hd__decap_3
XFILLER_81_125 VGND VGND VPWR VPWR sky130_fd_sc_hd__decap_3
XFILLER_82_648 VGND VGND VPWR VPWR sky130_fd_sc_hd__decap_3
X_6921_ _6920_/X _6781_/X _7670_/A VGND VGND VPWR VPWR _6921_/X sky130_fd_sc_hd__mux2_2
XFILLER_35_542 VGND VGND VPWR VPWR sky130_fd_sc_hd__decap_3
XFILLER_35_564 VGND VGND VPWR VPWR sky130_fd_sc_hd__decap_3
XFILLER_62_350 VGND VGND VPWR VPWR sky130_fd_sc_hd__decap_3
XFILLER_81_169 VGND VGND VPWR VPWR sky130_fd_sc_hd__decap_3
X_6852_ _6852_/A _6852_/B VGND VGND VPWR VPWR _6852_/Y sky130_fd_sc_hd__xnor2_2
XTAP_TAPCELL_ROW_81_1307 VGND VPWR sky130_fd_sc_hd__tapvpwrvgnd_1
XFILLER_22_203 VGND VGND VPWR VPWR sky130_fd_sc_hd__decap_3
XFILLER_62_394 VGND VGND VPWR VPWR sky130_fd_sc_hd__decap_3
X_5803_ _8234_/Q _5793_/X _5802_/X VGND VGND VPWR VPWR _5804_/B sky130_fd_sc_hd__o21a_2
XTAP_TAPCELL_ROW_81_1318 VGND VPWR sky130_fd_sc_hd__tapvpwrvgnd_1
XFILLER_50_545 VGND VGND VPWR VPWR sky130_fd_sc_hd__decap_3
XFILLER_50_567 VGND VGND VPWR VPWR sky130_fd_sc_hd__decap_3
X_6783_ _6782_/X _6506_/X _7745_/A VGND VGND VPWR VPWR _6783_/X sky130_fd_sc_hd__mux2_2
X_3995_ _3995_/A VGND VGND VPWR VPWR _7946_/D sky130_fd_sc_hd__buf_1
X_5734_ _7613_/B _5896_/A VGND VGND VPWR VPWR _5734_/X sky130_fd_sc_hd__and2_2
XFILLER_30_291 VGND VGND VPWR VPWR sky130_fd_sc_hd__decap_3
X_5665_ _6624_/A VGND VGND VPWR VPWR _5665_/X sky130_fd_sc_hd__clkbuf_1
X_7404_ _7407_/A _7404_/B VGND VGND VPWR VPWR _7404_/X sky130_fd_sc_hd__xor2_2
X_8384_ _8384_/CLK _8384_/D VGND VGND VPWR VPWR _8384_/Q sky130_fd_sc_hd__dfxtp_2
X_4616_ _7898_/B _8112_/Q VGND VGND VPWR VPWR _4617_/A sky130_fd_sc_hd__and2_2
XPHY_EDGE_ROW_111_Right_111 VGND VGND VPWR VPWR sky130_fd_sc_hd__decap_3
X_7335_ _7930_/B _7335_/B VGND VGND VPWR VPWR _7336_/A sky130_fd_sc_hd__and2_4
X_5596_ _5595_/X _5350_/Y _5596_/S VGND VGND VPWR VPWR _5596_/X sky130_fd_sc_hd__mux2_2
XFILLER_104_503 VGND VGND VPWR VPWR sky130_fd_sc_hd__fill_2
XFILLER_116_363 VGND VGND VPWR VPWR sky130_fd_sc_hd__fill_1
XFILLER_116_374 VGND VGND VPWR VPWR sky130_fd_sc_hd__decap_3
X_4547_ _4547_/A VGND VGND VPWR VPWR _8211_/D sky130_fd_sc_hd__buf_1
XFILLER_89_214 VGND VGND VPWR VPWR sky130_fd_sc_hd__decap_3
XFILLER_89_225 VGND VGND VPWR VPWR sky130_fd_sc_hd__decap_3
X_7266_ _7231_/X _7264_/A _8211_/Q VGND VGND VPWR VPWR _7267_/B sky130_fd_sc_hd__mux2_2
X_4478_ _7898_/B _8043_/Q VGND VGND VPWR VPWR _4479_/A sky130_fd_sc_hd__and2_2
XTAP_TAPCELL_ROW_92_1458 VGND VPWR sky130_fd_sc_hd__tapvpwrvgnd_1
X_7197_ _8208_/Q _7197_/B VGND VGND VPWR VPWR _7204_/C sky130_fd_sc_hd__nand2_2
X_6217_ _6211_/Y _8245_/Q _7732_/B VGND VGND VPWR VPWR _6217_/X sky130_fd_sc_hd__a21o_2
XFILLER_38_25 VGND VGND VPWR VPWR sky130_fd_sc_hd__decap_3
XFILLER_57_111 VGND VGND VPWR VPWR sky130_fd_sc_hd__fill_1
XFILLER_58_623 VGND VGND VPWR VPWR sky130_fd_sc_hd__decap_3
X_6148_ _6148_/A VGND VGND VPWR VPWR _6148_/X sky130_fd_sc_hd__buf_1
XFILLER_38_58 VGND VGND VPWR VPWR sky130_fd_sc_hd__decap_3
XFILLER_57_122 VGND VGND VPWR VPWR sky130_fd_sc_hd__decap_3
XFILLER_85_431 VGND VGND VPWR VPWR sky130_fd_sc_hd__fill_1
XFILLER_57_166 VGND VGND VPWR VPWR sky130_fd_sc_hd__fill_2
XFILLER_58_689 VGND VGND VPWR VPWR sky130_fd_sc_hd__fill_2
XFILLER_73_626 VGND VGND VPWR VPWR sky130_fd_sc_hd__decap_3
X_6079_ _6079_/A _6079_/B VGND VGND VPWR VPWR _6081_/B sky130_fd_sc_hd__nand2_2
XFILLER_26_520 VGND VGND VPWR VPWR sky130_fd_sc_hd__fill_2
XFILLER_38_380 VGND VGND VPWR VPWR sky130_fd_sc_hd__decap_3
XFILLER_72_136 VGND VGND VPWR VPWR sky130_fd_sc_hd__decap_3
XFILLER_14_704 VGND VGND VPWR VPWR sky130_fd_sc_hd__decap_3
XFILLER_26_564 VGND VGND VPWR VPWR sky130_fd_sc_hd__decap_3
XFILLER_54_24 VGND VGND VPWR VPWR sky130_fd_sc_hd__decap_3
XFILLER_54_35 VGND VGND VPWR VPWR sky130_fd_sc_hd__decap_3
XFILLER_72_147 VGND VGND VPWR VPWR sky130_fd_sc_hd__fill_1
XFILLER_13_225 VGND VGND VPWR VPWR sky130_fd_sc_hd__decap_3
XFILLER_26_586 VGND VGND VPWR VPWR sky130_fd_sc_hd__fill_2
XFILLER_41_523 VGND VGND VPWR VPWR sky130_fd_sc_hd__decap_3
XFILLER_53_372 VGND VGND VPWR VPWR sky130_fd_sc_hd__decap_3
XFILLER_110_52 VGND VGND VPWR VPWR sky130_fd_sc_hd__decap_3
XFILLER_13_247 VGND VGND VPWR VPWR sky130_fd_sc_hd__decap_3
XFILLER_41_567 VGND VGND VPWR VPWR sky130_fd_sc_hd__decap_3
XPHY_EDGE_ROW_109_Left_229 VGND VGND VPWR VPWR sky130_fd_sc_hd__decap_3
XFILLER_110_85 VGND VGND VPWR VPWR sky130_fd_sc_hd__decap_3
XFILLER_70_23 VGND VGND VPWR VPWR sky130_fd_sc_hd__decap_3
XFILLER_9_218 VGND VGND VPWR VPWR sky130_fd_sc_hd__decap_3
XTAP_TAPCELL_ROW_11_404 VGND VPWR sky130_fd_sc_hd__tapvpwrvgnd_1
XFILLER_70_56 VGND VGND VPWR VPWR sky130_fd_sc_hd__decap_3
XTAP_TAPCELL_ROW_101_1576 VGND VPWR sky130_fd_sc_hd__tapvpwrvgnd_1
XFILLER_107_330 VGND VGND VPWR VPWR sky130_fd_sc_hd__decap_3
XFILLER_119_50 VGND VGND VPWR VPWR sky130_fd_sc_hd__decap_3
Xrebuffer573 _4890_/B VGND VGND VPWR VPWR _6490_/A sky130_fd_sc_hd__buf_2
XFILLER_119_94 VGND VGND VPWR VPWR sky130_fd_sc_hd__fill_2
XFILLER_107_396 VGND VGND VPWR VPWR sky130_fd_sc_hd__decap_3
XPHY_EDGE_ROW_118_Left_238 VGND VGND VPWR VPWR sky130_fd_sc_hd__decap_3
XFILLER_110_506 VGND VGND VPWR VPWR sky130_fd_sc_hd__decap_3
XFILLER_68_409 VGND VGND VPWR VPWR sky130_fd_sc_hd__decap_3
XFILLER_110_539 VGND VGND VPWR VPWR sky130_fd_sc_hd__decap_3
XFILLER_49_634 VGND VGND VPWR VPWR sky130_fd_sc_hd__decap_3
XFILLER_95_239 VGND VGND VPWR VPWR sky130_fd_sc_hd__decap_3
XFILLER_49_667 VGND VGND VPWR VPWR sky130_fd_sc_hd__decap_3
XFILLER_88_280 VGND VGND VPWR VPWR sky130_fd_sc_hd__fill_2
XFILLER_95_75 VGND VGND VPWR VPWR sky130_fd_sc_hd__decap_3
XFILLER_64_604 VGND VGND VPWR VPWR sky130_fd_sc_hd__decap_3
XFILLER_64_615 VGND VGND VPWR VPWR sky130_fd_sc_hd__decap_3
XFILLER_76_486 VGND VGND VPWR VPWR sky130_fd_sc_hd__decap_3
XTAP_TAPCELL_ROW_19_504 VGND VPWR sky130_fd_sc_hd__tapvpwrvgnd_1
XFILLER_28_91 VGND VGND VPWR VPWR sky130_fd_sc_hd__decap_3
XFILLER_36_339 VGND VGND VPWR VPWR sky130_fd_sc_hd__decap_3
XFILLER_63_125 VGND VGND VPWR VPWR sky130_fd_sc_hd__decap_3
XFILLER_91_423 VGND VGND VPWR VPWR sky130_fd_sc_hd__decap_3
XFILLER_17_564 VGND VGND VPWR VPWR sky130_fd_sc_hd__fill_2
XFILLER_44_350 VGND VGND VPWR VPWR sky130_fd_sc_hd__decap_3
XFILLER_63_158 VGND VGND VPWR VPWR sky130_fd_sc_hd__fill_1
XFILLER_63_169 VGND VGND VPWR VPWR sky130_fd_sc_hd__decap_3
XTAP_TAPCELL_ROW_47_868 VGND VPWR sky130_fd_sc_hd__tapvpwrvgnd_1
XFILLER_17_575 VGND VGND VPWR VPWR sky130_fd_sc_hd__decap_3
XFILLER_17_597 VGND VGND VPWR VPWR sky130_fd_sc_hd__decap_3
XFILLER_44_383 VGND VGND VPWR VPWR sky130_fd_sc_hd__decap_3
XFILLER_32_545 VGND VGND VPWR VPWR sky130_fd_sc_hd__decap_3
XFILLER_32_567 VGND VGND VPWR VPWR sky130_fd_sc_hd__decap_3
XFILLER_32_589 VGND VGND VPWR VPWR sky130_fd_sc_hd__decap_3
XTAP_TAPCELL_ROW_119_1804 VGND VPWR sky130_fd_sc_hd__tapvpwrvgnd_1
XTAP_TAPCELL_ROW_119_1815 VGND VPWR sky130_fd_sc_hd__tapvpwrvgnd_1
XFILLER_8_240 VGND VGND VPWR VPWR sky130_fd_sc_hd__decap_3
XFILLER_8_262 VGND VGND VPWR VPWR sky130_fd_sc_hd__decap_3
X_5450_ _5448_/X _5449_/X _5579_/S VGND VGND VPWR VPWR _5450_/X sky130_fd_sc_hd__mux2_2
XFILLER_117_149 VGND VGND VPWR VPWR sky130_fd_sc_hd__decap_3
XFILLER_67_3 VGND VGND VPWR VPWR sky130_fd_sc_hd__decap_3
XFILLER_8_284 VGND VGND VPWR VPWR sky130_fd_sc_hd__decap_3
X_4401_ _4401_/A VGND VGND VPWR VPWR _8138_/D sky130_fd_sc_hd__buf_1
X_5381_ _5379_/X _5380_/X _7670_/A VGND VGND VPWR VPWR _5381_/X sky130_fd_sc_hd__mux2_2
XFILLER_99_523 VGND VGND VPWR VPWR sky130_fd_sc_hd__fill_2
XFILLER_99_534 VGND VGND VPWR VPWR sky130_fd_sc_hd__decap_3
X_7120_ _5508_/A _7098_/X _7100_/Y _7844_/C _7119_/X VGND VGND VPWR VPWR _7121_/B
+ sky130_fd_sc_hd__o221a_4
X_4332_ _7898_/B _4332_/B VGND VGND VPWR VPWR _4333_/A sky130_fd_sc_hd__and2_2
XFILLER_113_333 VGND VGND VPWR VPWR sky130_fd_sc_hd__decap_3
XFILLER_113_355 VGND VGND VPWR VPWR sky130_fd_sc_hd__decap_3
XFILLER_87_729 VGND VGND VPWR VPWR sky130_fd_sc_hd__decap_3
XFILLER_99_567 VGND VGND VPWR VPWR sky130_fd_sc_hd__fill_1
X_7051_ _7166_/D _7051_/B VGND VGND VPWR VPWR _7051_/Y sky130_fd_sc_hd__xnor2_2
X_4263_ _4263_/A VGND VGND VPWR VPWR _8069_/D sky130_fd_sc_hd__buf_1
XFILLER_101_517 VGND VGND VPWR VPWR sky130_fd_sc_hd__decap_3
XFILLER_86_206 VGND VGND VPWR VPWR sky130_fd_sc_hd__decap_3
XFILLER_86_239 VGND VGND VPWR VPWR sky130_fd_sc_hd__decap_3
X_6002_ _8239_/Q _5993_/A _5992_/X _6024_/B VGND VGND VPWR VPWR _6003_/C sky130_fd_sc_hd__a31o_4
XFILLER_39_111 VGND VGND VPWR VPWR sky130_fd_sc_hd__fill_1
X_4194_ _7898_/B _4194_/B VGND VGND VPWR VPWR _4195_/A sky130_fd_sc_hd__and2_2
XFILLER_67_475 VGND VGND VPWR VPWR sky130_fd_sc_hd__fill_1
XFILLER_82_401 VGND VGND VPWR VPWR sky130_fd_sc_hd__decap_3
XFILLER_94_250 VGND VGND VPWR VPWR sky130_fd_sc_hd__fill_2
XFILLER_54_136 VGND VGND VPWR VPWR sky130_fd_sc_hd__decap_3
XFILLER_82_445 VGND VGND VPWR VPWR sky130_fd_sc_hd__decap_3
XFILLER_94_283 VGND VGND VPWR VPWR sky130_fd_sc_hd__decap_3
X_7953_ _8359_/CLK _7953_/D VGND VGND VPWR VPWR _7953_/Q sky130_fd_sc_hd__dfxtp_2
XFILLER_42_309 VGND VGND VPWR VPWR sky130_fd_sc_hd__decap_3
XFILLER_54_147 VGND VGND VPWR VPWR sky130_fd_sc_hd__decap_3
XFILLER_70_607 VGND VGND VPWR VPWR sky130_fd_sc_hd__decap_3
X_6904_ _7209_/A _6885_/Y _6897_/Y _6903_/X VGND VGND VPWR VPWR _6904_/X sky130_fd_sc_hd__a211o_2
XFILLER_23_512 VGND VGND VPWR VPWR sky130_fd_sc_hd__fill_1
XFILLER_23_523 VGND VGND VPWR VPWR sky130_fd_sc_hd__fill_1
XFILLER_35_361 VGND VGND VPWR VPWR sky130_fd_sc_hd__decap_3
X_7884_ _8312_/Q _7898_/B VGND VGND VPWR VPWR _7885_/A sky130_fd_sc_hd__and2_2
XFILLER_23_556 VGND VGND VPWR VPWR sky130_fd_sc_hd__decap_3
XFILLER_24_49 VGND VGND VPWR VPWR sky130_fd_sc_hd__decap_3
XFILLER_50_342 VGND VGND VPWR VPWR sky130_fd_sc_hd__decap_3
XFILLER_62_191 VGND VGND VPWR VPWR sky130_fd_sc_hd__decap_3
X_6835_ _6999_/A1 _6832_/X _6834_/X VGND VGND VPWR VPWR _6835_/X sky130_fd_sc_hd__a21o_2
XFILLER_11_729 VGND VGND VPWR VPWR sky130_fd_sc_hd__decap_3
X_6766_ _6769_/B _8197_/Q _7551_/B _6765_/Y _7617_/A VGND VGND VPWR VPWR _6766_/X
+ sky130_fd_sc_hd__o32a_2
X_3978_ _8342_/Q _7930_/B VGND VGND VPWR VPWR _3979_/A sky130_fd_sc_hd__and2_2
XFILLER_10_239 VGND VGND VPWR VPWR sky130_fd_sc_hd__decap_3
XFILLER_50_386 VGND VGND VPWR VPWR sky130_fd_sc_hd__decap_3
X_5717_ _5710_/X _5716_/X _7844_/A VGND VGND VPWR VPWR _8302_/D sky130_fd_sc_hd__a21oi_2
XFILLER_109_617 VGND VGND VPWR VPWR sky130_fd_sc_hd__decap_3
XFILLER_109_639 VGND VGND VPWR VPWR sky130_fd_sc_hd__decap_3
X_6697_ _8195_/Q _8259_/Q VGND VGND VPWR VPWR _6697_/X sky130_fd_sc_hd__or2_2
XFILLER_108_138 VGND VGND VPWR VPWR sky130_fd_sc_hd__fill_2
X_5648_ _7825_/A _5647_/X _5857_/A VGND VGND VPWR VPWR _5648_/Y sky130_fd_sc_hd__o21ai_2
XFILLER_117_650 VGND VGND VPWR VPWR sky130_fd_sc_hd__decap_3
X_8367_ _8385_/CLK _8367_/D VGND VGND VPWR VPWR _8367_/Q sky130_fd_sc_hd__dfxtp_2
X_5579_ _5357_/X _5360_/X _5579_/S VGND VGND VPWR VPWR _5579_/X sky130_fd_sc_hd__mux2_2
XFILLER_104_300 VGND VGND VPWR VPWR sky130_fd_sc_hd__decap_3
XFILLER_116_171 VGND VGND VPWR VPWR sky130_fd_sc_hd__decap_3
X_8298_ _8365_/CLK _8298_/D VGND VGND VPWR VPWR _8298_/Q sky130_fd_sc_hd__dfxtp_2
X_7318_ _8210_/Q _8211_/Q _8212_/Q _7318_/D VGND VGND VPWR VPWR _7384_/C sky130_fd_sc_hd__and4_2
X_7249_ _8274_/Q _7226_/B _7233_/S VGND VGND VPWR VPWR _7249_/X sky130_fd_sc_hd__o21a_2
XFILLER_104_377 VGND VGND VPWR VPWR sky130_fd_sc_hd__decap_3
XFILLER_49_57 VGND VGND VPWR VPWR sky130_fd_sc_hd__decap_3
XFILLER_77_206 VGND VGND VPWR VPWR sky130_fd_sc_hd__decap_3
XFILLER_77_228 VGND VGND VPWR VPWR sky130_fd_sc_hd__decap_3
XFILLER_58_442 VGND VGND VPWR VPWR sky130_fd_sc_hd__decap_3
XFILLER_100_561 VGND VGND VPWR VPWR sky130_fd_sc_hd__decap_3
XFILLER_46_626 VGND VGND VPWR VPWR sky130_fd_sc_hd__decap_3
XFILLER_58_475 VGND VGND VPWR VPWR sky130_fd_sc_hd__fill_1
XFILLER_65_23 VGND VGND VPWR VPWR sky130_fd_sc_hd__decap_3
XFILLER_92_209 VGND VGND VPWR VPWR sky130_fd_sc_hd__decap_3
XFILLER_45_136 VGND VGND VPWR VPWR sky130_fd_sc_hd__decap_3
XFILLER_58_486 VGND VGND VPWR VPWR sky130_fd_sc_hd__decap_3
XFILLER_73_412 VGND VGND VPWR VPWR sky130_fd_sc_hd__decap_3
XFILLER_33_309 VGND VGND VPWR VPWR sky130_fd_sc_hd__decap_3
XFILLER_45_169 VGND VGND VPWR VPWR sky130_fd_sc_hd__decap_3
XFILLER_61_607 VGND VGND VPWR VPWR sky130_fd_sc_hd__decap_3
XFILLER_65_78 VGND VGND VPWR VPWR sky130_fd_sc_hd__decap_3
XFILLER_73_467 VGND VGND VPWR VPWR sky130_fd_sc_hd__decap_3
XFILLER_14_523 VGND VGND VPWR VPWR sky130_fd_sc_hd__decap_3
XFILLER_54_681 VGND VGND VPWR VPWR sky130_fd_sc_hd__decap_3
XFILLER_60_128 VGND VGND VPWR VPWR sky130_fd_sc_hd__decap_3
XFILLER_61_629 VGND VGND VPWR VPWR sky130_fd_sc_hd__decap_3
XFILLER_81_11 VGND VGND VPWR VPWR sky130_fd_sc_hd__decap_3
XTAP_TAPCELL_ROW_44_827 VGND VPWR sky130_fd_sc_hd__tapvpwrvgnd_1
XFILLER_14_589 VGND VGND VPWR VPWR sky130_fd_sc_hd__decap_3
XFILLER_81_66 VGND VGND VPWR VPWR sky130_fd_sc_hd__decap_3
XFILLER_41_386 VGND VGND VPWR VPWR sky130_fd_sc_hd__decap_3
XTAP_TAPCELL_ROW_62_1070 VGND VPWR sky130_fd_sc_hd__tapvpwrvgnd_1
XTAP_TAPCELL_ROW_24_573 VGND VPWR sky130_fd_sc_hd__tapvpwrvgnd_1
XFILLER_5_221 VGND VGND VPWR VPWR sky130_fd_sc_hd__decap_3
XFILLER_108_672 VGND VGND VPWR VPWR sky130_fd_sc_hd__decap_3
XFILLER_107_160 VGND VGND VPWR VPWR sky130_fd_sc_hd__decap_3
XTAP_TAPCELL_ROW_114_1745 VGND VPWR sky130_fd_sc_hd__tapvpwrvgnd_1
XFILLER_107_193 VGND VGND VPWR VPWR sky130_fd_sc_hd__decap_3
XFILLER_110_303 VGND VGND VPWR VPWR sky130_fd_sc_hd__decap_3
XFILLER_68_228 VGND VGND VPWR VPWR sky130_fd_sc_hd__decap_3
XFILLER_69_729 VGND VGND VPWR VPWR sky130_fd_sc_hd__decap_3
XFILLER_110_325 VGND VGND VPWR VPWR sky130_fd_sc_hd__decap_3
XFILLER_49_420 VGND VGND VPWR VPWR sky130_fd_sc_hd__decap_3
XFILLER_68_239 VGND VGND VPWR VPWR sky130_fd_sc_hd__decap_3
XFILLER_96_559 VGND VGND VPWR VPWR sky130_fd_sc_hd__decap_3
XFILLER_49_464 VGND VGND VPWR VPWR sky130_fd_sc_hd__decap_3
Xinput8 operand_a[11] VGND VGND VPWR VPWR input8/X sky130_fd_sc_hd__clkdlybuf4s25_1
XFILLER_36_114 VGND VGND VPWR VPWR sky130_fd_sc_hd__decap_3
XFILLER_37_648 VGND VGND VPWR VPWR sky130_fd_sc_hd__fill_2
XFILLER_37_659 VGND VGND VPWR VPWR sky130_fd_sc_hd__fill_1
XFILLER_64_434 VGND VGND VPWR VPWR sky130_fd_sc_hd__decap_3
XFILLER_24_309 VGND VGND VPWR VPWR sky130_fd_sc_hd__decap_3
XFILLER_64_456 VGND VGND VPWR VPWR sky130_fd_sc_hd__decap_3
XFILLER_91_242 VGND VGND VPWR VPWR sky130_fd_sc_hd__decap_3
XFILLER_45_670 VGND VGND VPWR VPWR sky130_fd_sc_hd__fill_2
XFILLER_51_106 VGND VGND VPWR VPWR sky130_fd_sc_hd__decap_3
XFILLER_51_128 VGND VGND VPWR VPWR sky130_fd_sc_hd__decap_3
XFILLER_64_489 VGND VGND VPWR VPWR sky130_fd_sc_hd__decap_3
XFILLER_91_286 VGND VGND VPWR VPWR sky130_fd_sc_hd__decap_3
X_4950_ _6620_/A _8164_/Q VGND VGND VPWR VPWR _5017_/B sky130_fd_sc_hd__nor2b_2
XFILLER_60_640 VGND VGND VPWR VPWR sky130_fd_sc_hd__decap_3
X_4881_ _4881_/A VGND VGND VPWR VPWR _6400_/B sky130_fd_sc_hd__inv_2
XFILLER_32_342 VGND VGND VPWR VPWR sky130_fd_sc_hd__fill_1
XFILLER_60_651 VGND VGND VPWR VPWR sky130_fd_sc_hd__decap_3
X_6620_ _6620_/A _7825_/B VGND VGND VPWR VPWR _7651_/B sky130_fd_sc_hd__nor2_2
XFILLER_60_695 VGND VGND VPWR VPWR sky130_fd_sc_hd__decap_3
X_6551_ _7474_/A _6569_/B _5615_/A _6550_/X VGND VGND VPWR VPWR _6551_/X sky130_fd_sc_hd__a2bb2o_2
X_5502_ _5477_/X _5479_/X _5481_/X _6589_/B2 _5501_/X VGND VGND VPWR VPWR _5502_/X
+ sky130_fd_sc_hd__a221o_2
X_6482_ _6476_/B _6476_/C _4863_/B VGND VGND VPWR VPWR _6483_/B sky130_fd_sc_hd__o21ai_4
X_8221_ _8226_/CLK _8221_/D VGND VGND VPWR VPWR _8221_/Q sky130_fd_sc_hd__dfxtp_2
X_5433_ _5433_/A VGND VGND VPWR VPWR _5433_/X sky130_fd_sc_hd__clkbuf_1
XFILLER_10_29 VGND VGND VPWR VPWR sky130_fd_sc_hd__decap_3
XFILLER_99_320 VGND VGND VPWR VPWR sky130_fd_sc_hd__decap_3
X_8152_ _8285_/CLK _8152_/D VGND VGND VPWR VPWR _8152_/Q sky130_fd_sc_hd__dfxtp_2
X_5364_ _5579_/S _8223_/Q VGND VGND VPWR VPWR _5364_/Y sky130_fd_sc_hd__nand2_2
XFILLER_99_353 VGND VGND VPWR VPWR sky130_fd_sc_hd__decap_3
X_7103_ _7166_/C _7095_/B _7102_/X VGND VGND VPWR VPWR _7103_/Y sky130_fd_sc_hd__o21ai_2
X_4315_ _4315_/A VGND VGND VPWR VPWR _8095_/D sky130_fd_sc_hd__buf_1
XFILLER_113_163 VGND VGND VPWR VPWR sky130_fd_sc_hd__decap_3
X_8083_ _8218_/CLK _8083_/D VGND VGND VPWR VPWR _8083_/Q sky130_fd_sc_hd__dfxtp_2
X_5295_ _7617_/A _5415_/A VGND VGND VPWR VPWR _5296_/A sky130_fd_sc_hd__nor2_2
XFILLER_101_347 VGND VGND VPWR VPWR sky130_fd_sc_hd__fill_2
X_7034_ _8205_/Q _8269_/Q VGND VGND VPWR VPWR _7034_/Y sky130_fd_sc_hd__nor2_2
X_4246_ _7898_/B _4246_/B VGND VGND VPWR VPWR _4247_/A sky130_fd_sc_hd__and2_2
XFILLER_19_49 VGND VGND VPWR VPWR sky130_fd_sc_hd__decap_3
XFILLER_28_604 VGND VGND VPWR VPWR sky130_fd_sc_hd__decap_3
XFILLER_67_261 VGND VGND VPWR VPWR sky130_fd_sc_hd__decap_3
XFILLER_74_209 VGND VGND VPWR VPWR sky130_fd_sc_hd__decap_3
XFILLER_95_570 VGND VGND VPWR VPWR sky130_fd_sc_hd__fill_2
X_4177_ _4177_/A VGND VGND VPWR VPWR _8026_/D sky130_fd_sc_hd__buf_1
XFILLER_28_648 VGND VGND VPWR VPWR sky130_fd_sc_hd__decap_3
XFILLER_55_423 VGND VGND VPWR VPWR sky130_fd_sc_hd__decap_3
XFILLER_83_732 VGND VGND VPWR VPWR sky130_fd_sc_hd__fill_1
XFILLER_95_581 VGND VGND VPWR VPWR sky130_fd_sc_hd__decap_3
XFILLER_27_136 VGND VGND VPWR VPWR sky130_fd_sc_hd__decap_3
XFILLER_55_445 VGND VGND VPWR VPWR sky130_fd_sc_hd__decap_3
XFILLER_82_242 VGND VGND VPWR VPWR sky130_fd_sc_hd__fill_2
XFILLER_82_253 VGND VGND VPWR VPWR sky130_fd_sc_hd__decap_3
XTAP_TAPCELL_ROW_2_279 VGND VPWR sky130_fd_sc_hd__tapvpwrvgnd_1
XFILLER_15_309 VGND VGND VPWR VPWR sky130_fd_sc_hd__decap_3
XFILLER_27_169 VGND VGND VPWR VPWR sky130_fd_sc_hd__fill_1
XFILLER_82_286 VGND VGND VPWR VPWR sky130_fd_sc_hd__decap_3
X_7936_ _8398_/CLK _7936_/D VGND VGND VPWR VPWR _7936_/Q sky130_fd_sc_hd__dfxtp_2
XFILLER_23_320 VGND VGND VPWR VPWR sky130_fd_sc_hd__decap_3
XFILLER_42_139 VGND VGND VPWR VPWR sky130_fd_sc_hd__fill_1
XFILLER_70_437 VGND VGND VPWR VPWR sky130_fd_sc_hd__decap_3
XFILLER_70_448 VGND VGND VPWR VPWR sky130_fd_sc_hd__decap_3
X_7867_ _7867_/A VGND VGND VPWR VPWR _8370_/D sky130_fd_sc_hd__buf_1
XFILLER_23_353 VGND VGND VPWR VPWR sky130_fd_sc_hd__decap_3
XFILLER_51_651 VGND VGND VPWR VPWR sky130_fd_sc_hd__decap_3
XFILLER_51_673 VGND VGND VPWR VPWR sky130_fd_sc_hd__decap_3
X_6818_ _6817_/X _6531_/X _6818_/S VGND VGND VPWR VPWR _6818_/X sky130_fd_sc_hd__mux2_2
XFILLER_51_14 VGND VGND VPWR VPWR sky130_fd_sc_hd__decap_3
XFILLER_51_36 VGND VGND VPWR VPWR sky130_fd_sc_hd__decap_3
X_7798_ _7670_/A _5785_/A _7796_/Y _7797_/Y VGND VGND VPWR VPWR _7798_/X sky130_fd_sc_hd__a31o_2
XFILLER_11_559 VGND VGND VPWR VPWR sky130_fd_sc_hd__fill_1
XFILLER_51_69 VGND VGND VPWR VPWR sky130_fd_sc_hd__decap_3
XFILLER_7_508 VGND VGND VPWR VPWR sky130_fd_sc_hd__decap_3
X_6749_ _8260_/Q _5337_/A _5093_/X VGND VGND VPWR VPWR _6749_/Y sky130_fd_sc_hd__o21ai_2
XTAP_TAPCELL_ROW_21_532 VGND VPWR sky130_fd_sc_hd__tapvpwrvgnd_1
XFILLER_3_725 VGND VGND VPWR VPWR sky130_fd_sc_hd__decap_3
XFILLER_104_141 VGND VGND VPWR VPWR sky130_fd_sc_hd__decap_3
XFILLER_2_268 VGND VGND VPWR VPWR sky130_fd_sc_hd__fill_1
XFILLER_104_185 VGND VGND VPWR VPWR sky130_fd_sc_hd__fill_1
XFILLER_58_250 VGND VGND VPWR VPWR sky130_fd_sc_hd__fill_2
XFILLER_93_529 VGND VGND VPWR VPWR sky130_fd_sc_hd__decap_3
XFILLER_18_114 VGND VGND VPWR VPWR sky130_fd_sc_hd__decap_3
XFILLER_19_626 VGND VGND VPWR VPWR sky130_fd_sc_hd__decap_3
XFILLER_19_648 VGND VGND VPWR VPWR sky130_fd_sc_hd__decap_3
XFILLER_58_283 VGND VGND VPWR VPWR sky130_fd_sc_hd__decap_3
XFILLER_76_77 VGND VGND VPWR VPWR sky130_fd_sc_hd__decap_3
XFILLER_76_99 VGND VGND VPWR VPWR sky130_fd_sc_hd__decap_3
XFILLER_86_581 VGND VGND VPWR VPWR sky130_fd_sc_hd__decap_3
XFILLER_18_147 VGND VGND VPWR VPWR sky130_fd_sc_hd__decap_3
XFILLER_46_445 VGND VGND VPWR VPWR sky130_fd_sc_hd__decap_3
XFILLER_73_242 VGND VGND VPWR VPWR sky130_fd_sc_hd__decap_3
XTAP_TAPCELL_ROW_29_632 VGND VPWR sky130_fd_sc_hd__tapvpwrvgnd_1
XFILLER_46_489 VGND VGND VPWR VPWR sky130_fd_sc_hd__decap_3
XFILLER_61_426 VGND VGND VPWR VPWR sky130_fd_sc_hd__decap_3
XTAP_TAPCELL_ROW_57_996 VGND VPWR sky130_fd_sc_hd__tapvpwrvgnd_1
XFILLER_27_692 VGND VGND VPWR VPWR sky130_fd_sc_hd__fill_1
XFILLER_33_128 VGND VGND VPWR VPWR sky130_fd_sc_hd__decap_3
XFILLER_73_297 VGND VGND VPWR VPWR sky130_fd_sc_hd__decap_3
XFILLER_25_70 VGND VGND VPWR VPWR sky130_fd_sc_hd__decap_3
XFILLER_41_150 VGND VGND VPWR VPWR sky130_fd_sc_hd__decap_3
XFILLER_42_651 VGND VGND VPWR VPWR sky130_fd_sc_hd__decap_3
XFILLER_14_397 VGND VGND VPWR VPWR sky130_fd_sc_hd__decap_3
XFILLER_41_161 VGND VGND VPWR VPWR sky130_fd_sc_hd__decap_3
XFILLER_41_172 VGND VGND VPWR VPWR sky130_fd_sc_hd__decap_3
XFILLER_108_480 VGND VGND VPWR VPWR sky130_fd_sc_hd__decap_3
XFILLER_115_428 VGND VGND VPWR VPWR sky130_fd_sc_hd__decap_3
XFILLER_69_526 VGND VGND VPWR VPWR sky130_fd_sc_hd__fill_1
XFILLER_111_623 VGND VGND VPWR VPWR sky130_fd_sc_hd__decap_3
XFILLER_111_645 VGND VGND VPWR VPWR sky130_fd_sc_hd__fill_1
XFILLER_69_559 VGND VGND VPWR VPWR sky130_fd_sc_hd__fill_1
XFILLER_96_334 VGND VGND VPWR VPWR sky130_fd_sc_hd__decap_3
X_5080_ _5346_/A VGND VGND VPWR VPWR _5080_/X sky130_fd_sc_hd__buf_1
X_4100_ _7930_/B _8391_/Q VGND VGND VPWR VPWR _4101_/A sky130_fd_sc_hd__and2_2
XFILLER_110_133 VGND VGND VPWR VPWR sky130_fd_sc_hd__decap_3
XFILLER_56_209 VGND VGND VPWR VPWR sky130_fd_sc_hd__decap_3
XFILLER_84_518 VGND VGND VPWR VPWR sky130_fd_sc_hd__decap_3
XFILLER_96_389 VGND VGND VPWR VPWR sky130_fd_sc_hd__decap_3
X_4031_ _4031_/A _4031_/B _4031_/C _4031_/D VGND VGND VPWR VPWR _4032_/D sky130_fd_sc_hd__or4_2
XFILLER_2_74 VGND VGND VPWR VPWR sky130_fd_sc_hd__decap_3
XFILLER_2_85 VGND VGND VPWR VPWR sky130_fd_sc_hd__decap_3
XFILLER_65_710 VGND VGND VPWR VPWR sky130_fd_sc_hd__fill_1
XFILLER_65_732 VGND VGND VPWR VPWR sky130_fd_sc_hd__fill_1
Xclone841 _8229_/Q VGND VGND VPWR VPWR _6109_/A sky130_fd_sc_hd__clkbuf_16
XFILLER_37_445 VGND VGND VPWR VPWR sky130_fd_sc_hd__decap_3
XFILLER_37_467 VGND VGND VPWR VPWR sky130_fd_sc_hd__decap_3
XFILLER_37_489 VGND VGND VPWR VPWR sky130_fd_sc_hd__decap_3
XFILLER_52_404 VGND VGND VPWR VPWR sky130_fd_sc_hd__decap_3
XFILLER_64_264 VGND VGND VPWR VPWR sky130_fd_sc_hd__decap_3
XFILLER_80_724 VGND VGND VPWR VPWR sky130_fd_sc_hd__decap_3
X_5982_ _6784_/A _5980_/X _5981_/X VGND VGND VPWR VPWR _5983_/B sky130_fd_sc_hd__a21oi_2
XFILLER_24_139 VGND VGND VPWR VPWR sky130_fd_sc_hd__fill_1
XFILLER_52_448 VGND VGND VPWR VPWR sky130_fd_sc_hd__decap_3
XFILLER_52_459 VGND VGND VPWR VPWR sky130_fd_sc_hd__fill_2
XFILLER_64_297 VGND VGND VPWR VPWR sky130_fd_sc_hd__decap_3
X_7721_ _7754_/A _7721_/B VGND VGND VPWR VPWR _7721_/Y sky130_fd_sc_hd__nand2_2
X_4933_ _5894_/A _5998_/S _5876_/A _5965_/A VGND VGND VPWR VPWR _4941_/A sky130_fd_sc_hd__or4_2
XFILLER_33_662 VGND VGND VPWR VPWR sky130_fd_sc_hd__decap_3
XFILLER_33_673 VGND VGND VPWR VPWR sky130_fd_sc_hd__decap_3
XANTENNA_13 _5299_/X VGND VGND VPWR VPWR sky130_fd_sc_hd__diode_2
XFILLER_20_312 VGND VGND VPWR VPWR sky130_fd_sc_hd__decap_3
XFILLER_33_684 VGND VGND VPWR VPWR sky130_fd_sc_hd__fill_1
X_7652_ _7747_/A _7652_/B VGND VGND VPWR VPWR _7652_/Y sky130_fd_sc_hd__xnor2_2
X_4864_ _4864_/A _6561_/C VGND VGND VPWR VPWR _6592_/B sky130_fd_sc_hd__nor2_2
XANTENNA_24 _7531_/Y VGND VGND VPWR VPWR sky130_fd_sc_hd__diode_2
XFILLER_119_701 VGND VGND VPWR VPWR sky130_fd_sc_hd__decap_3
XFILLER_32_194 VGND VGND VPWR VPWR sky130_fd_sc_hd__fill_2
X_7583_ _8220_/Q _8221_/Q _7583_/C _7583_/D VGND VGND VPWR VPWR _7587_/C sky130_fd_sc_hd__and4_2
X_6603_ _6610_/A _6603_/B VGND VGND VPWR VPWR _6603_/Y sky130_fd_sc_hd__nor2_2
X_4795_ _7159_/A _4795_/B VGND VGND VPWR VPWR _7166_/A sky130_fd_sc_hd__nand2_2
XFILLER_118_222 VGND VGND VPWR VPWR sky130_fd_sc_hd__fill_1
XFILLER_20_389 VGND VGND VPWR VPWR sky130_fd_sc_hd__decap_3
X_6534_ _5569_/X _5579_/X _5578_/X _5576_/B _6620_/A _6818_/S VGND VGND VPWR VPWR
+ _6534_/X sky130_fd_sc_hd__mux4_2
X_6465_ _8289_/Q _6464_/Y _8290_/Q VGND VGND VPWR VPWR _6465_/X sky130_fd_sc_hd__a21o_2
X_8204_ _8228_/CLK _8204_/D VGND VGND VPWR VPWR _8204_/Q sky130_fd_sc_hd__dfxtp_4
X_5416_ _7231_/A VGND VGND VPWR VPWR _6023_/A sky130_fd_sc_hd__clkbuf_1
Xoutput142 _7970_/Q VGND VGND VPWR VPWR result[12] sky130_fd_sc_hd__clkdlybuf4s25_1
X_6396_ _4897_/A _4915_/B _6394_/A VGND VGND VPWR VPWR _6398_/B sky130_fd_sc_hd__a21o_2
XFILLER_102_601 VGND VGND VPWR VPWR sky130_fd_sc_hd__decap_3
X_8135_ _8269_/CLK _8135_/D VGND VGND VPWR VPWR _8135_/Q sky130_fd_sc_hd__dfxtp_2
Xoutput186 _8010_/Q VGND VGND VPWR VPWR result[52] sky130_fd_sc_hd__clkdlybuf4s25_1
Xoutput175 _8000_/Q VGND VGND VPWR VPWR result[42] sky130_fd_sc_hd__clkdlybuf4s25_1
Xoutput164 _7990_/Q VGND VGND VPWR VPWR result[32] sky130_fd_sc_hd__clkdlybuf4s25_1
Xoutput153 _7980_/Q VGND VGND VPWR VPWR result[22] sky130_fd_sc_hd__clkdlybuf4s25_1
X_5347_ _5430_/A _5346_/A _5346_/Y VGND VGND VPWR VPWR _5348_/A sky130_fd_sc_hd__o21ai_2
XFILLER_101_122 VGND VGND VPWR VPWR sky130_fd_sc_hd__decap_3
XFILLER_102_645 VGND VGND VPWR VPWR sky130_fd_sc_hd__decap_3
XFILLER_87_334 VGND VGND VPWR VPWR sky130_fd_sc_hd__fill_2
XFILLER_99_194 VGND VGND VPWR VPWR sky130_fd_sc_hd__decap_3
X_8066_ _8207_/CLK _8066_/D VGND VGND VPWR VPWR _8066_/Q sky130_fd_sc_hd__dfxtp_2
Xoutput197 _8020_/Q VGND VGND VPWR VPWR result[62] sky130_fd_sc_hd__clkdlybuf4s25_1
X_5278_ _6086_/A VGND VGND VPWR VPWR _5278_/X sky130_fd_sc_hd__clkbuf_1
XTAP_TAPCELL_ROW_7_349 VGND VPWR sky130_fd_sc_hd__tapvpwrvgnd_1
XFILLER_47_209 VGND VGND VPWR VPWR sky130_fd_sc_hd__decap_3
X_7017_ _7017_/A _7017_/B VGND VGND VPWR VPWR _7017_/X sky130_fd_sc_hd__or2_2
X_4229_ _4229_/A VGND VGND VPWR VPWR _8052_/D sky130_fd_sc_hd__buf_1
XTAP_TAPCELL_ROW_89_1419 VGND VPWR sky130_fd_sc_hd__tapvpwrvgnd_1
XFILLER_101_199 VGND VGND VPWR VPWR sky130_fd_sc_hd__fill_1
XFILLER_28_401 VGND VGND VPWR VPWR sky130_fd_sc_hd__decap_3
XFILLER_46_14 VGND VGND VPWR VPWR sky130_fd_sc_hd__decap_3
XFILLER_68_592 VGND VGND VPWR VPWR sky130_fd_sc_hd__decap_3
XFILLER_75_529 VGND VGND VPWR VPWR sky130_fd_sc_hd__decap_3
XFILLER_16_618 VGND VGND VPWR VPWR sky130_fd_sc_hd__decap_3
XFILLER_55_275 VGND VGND VPWR VPWR sky130_fd_sc_hd__decap_3
XFILLER_83_595 VGND VGND VPWR VPWR sky130_fd_sc_hd__fill_1
XTAP_TAPCELL_ROW_26_602 VGND VPWR sky130_fd_sc_hd__tapvpwrvgnd_1
XFILLER_102_53 VGND VGND VPWR VPWR sky130_fd_sc_hd__decap_3
XFILLER_43_437 VGND VGND VPWR VPWR sky130_fd_sc_hd__fill_2
XFILLER_43_459 VGND VGND VPWR VPWR sky130_fd_sc_hd__fill_1
XFILLER_70_212 VGND VGND VPWR VPWR sky130_fd_sc_hd__decap_3
XFILLER_70_245 VGND VGND VPWR VPWR sky130_fd_sc_hd__decap_3
X_7919_ _7919_/A VGND VGND VPWR VPWR _8396_/D sky130_fd_sc_hd__buf_1
XTAP_TAPCELL_ROW_54_955 VGND VPWR sky130_fd_sc_hd__tapvpwrvgnd_1
XFILLER_70_256 VGND VGND VPWR VPWR sky130_fd_sc_hd__decap_3
XTAP_TAPCELL_ROW_54_966 VGND VPWR sky130_fd_sc_hd__tapvpwrvgnd_1
XFILLER_11_323 VGND VGND VPWR VPWR sky130_fd_sc_hd__decap_3
XFILLER_23_150 VGND VGND VPWR VPWR sky130_fd_sc_hd__decap_3
XFILLER_23_172 VGND VGND VPWR VPWR sky130_fd_sc_hd__decap_3
XFILLER_51_470 VGND VGND VPWR VPWR sky130_fd_sc_hd__decap_3
XFILLER_109_211 VGND VGND VPWR VPWR sky130_fd_sc_hd__decap_3
XFILLER_11_378 VGND VGND VPWR VPWR sky130_fd_sc_hd__decap_3
Xwire225 _5400_/X VGND VGND VPWR VPWR wire225/X sky130_fd_sc_hd__buf_6
XFILLER_109_255 VGND VGND VPWR VPWR sky130_fd_sc_hd__decap_3
XFILLER_7_349 VGND VGND VPWR VPWR sky130_fd_sc_hd__decap_3
XFILLER_11_50 VGND VGND VPWR VPWR sky130_fd_sc_hd__decap_3
XFILLER_3_533 VGND VGND VPWR VPWR sky130_fd_sc_hd__fill_1
XTAP_TAPCELL_ROW_111_1704 VGND VPWR sky130_fd_sc_hd__tapvpwrvgnd_1
XFILLER_97_109 VGND VGND VPWR VPWR sky130_fd_sc_hd__decap_3
XFILLER_105_494 VGND VGND VPWR VPWR sky130_fd_sc_hd__decap_3
XFILLER_78_312 VGND VGND VPWR VPWR sky130_fd_sc_hd__decap_3
XFILLER_78_345 VGND VGND VPWR VPWR sky130_fd_sc_hd__decap_3
XFILLER_87_54 VGND VGND VPWR VPWR sky130_fd_sc_hd__fill_2
XFILLER_93_304 VGND VGND VPWR VPWR sky130_fd_sc_hd__decap_3
XFILLER_19_412 VGND VGND VPWR VPWR sky130_fd_sc_hd__decap_3
XFILLER_19_423 VGND VGND VPWR VPWR sky130_fd_sc_hd__decap_3
XFILLER_47_732 VGND VGND VPWR VPWR sky130_fd_sc_hd__fill_1
XFILLER_66_529 VGND VGND VPWR VPWR sky130_fd_sc_hd__decap_3
XFILLER_78_389 VGND VGND VPWR VPWR sky130_fd_sc_hd__decap_3
XFILLER_93_337 VGND VGND VPWR VPWR sky130_fd_sc_hd__decap_3
XFILLER_19_478 VGND VGND VPWR VPWR sky130_fd_sc_hd__decap_3
XFILLER_46_253 VGND VGND VPWR VPWR sky130_fd_sc_hd__decap_3
XFILLER_74_562 VGND VGND VPWR VPWR sky130_fd_sc_hd__decap_3
XTAP_TAPCELL_ROW_109_1677 VGND VPWR sky130_fd_sc_hd__tapvpwrvgnd_1
XFILLER_34_459 VGND VGND VPWR VPWR sky130_fd_sc_hd__decap_3
XFILLER_46_286 VGND VGND VPWR VPWR sky130_fd_sc_hd__decap_3
XFILLER_15_673 VGND VGND VPWR VPWR sky130_fd_sc_hd__decap_3
XFILLER_61_256 VGND VGND VPWR VPWR sky130_fd_sc_hd__decap_3
XFILLER_14_150 VGND VGND VPWR VPWR sky130_fd_sc_hd__decap_3
XFILLER_30_621 VGND VGND VPWR VPWR sky130_fd_sc_hd__decap_3
XFILLER_30_643 VGND VGND VPWR VPWR sky130_fd_sc_hd__fill_1
XFILLER_30_654 VGND VGND VPWR VPWR sky130_fd_sc_hd__decap_3
Xinput11 operand_a[14] VGND VGND VPWR VPWR _4204_/B sky130_fd_sc_hd__clkdlybuf4s25_1
Xinput22 operand_a[24] VGND VGND VPWR VPWR _4224_/B sky130_fd_sc_hd__clkdlybuf4s25_1
X_4580_ _7843_/A _8094_/Q VGND VGND VPWR VPWR _4581_/A sky130_fd_sc_hd__and2_2
XFILLER_116_704 VGND VGND VPWR VPWR sky130_fd_sc_hd__decap_3
Xinput55 operand_a[54] VGND VGND VPWR VPWR _4284_/B sky130_fd_sc_hd__clkdlybuf4s25_1
Xinput44 operand_a[44] VGND VGND VPWR VPWR _4264_/B sky130_fd_sc_hd__clkdlybuf4s25_1
Xinput33 operand_a[34] VGND VGND VPWR VPWR _4244_/B sky130_fd_sc_hd__clkdlybuf4s25_1
XFILLER_6_371 VGND VGND VPWR VPWR sky130_fd_sc_hd__decap_3
Xinput88 operand_b[26] VGND VGND VPWR VPWR _4356_/B sky130_fd_sc_hd__clkdlybuf4s25_1
Xinput77 operand_b[16] VGND VGND VPWR VPWR _4336_/B sky130_fd_sc_hd__clkdlybuf4s25_1
Xinput66 operand_a[6] VGND VGND VPWR VPWR _4188_/B sky130_fd_sc_hd__clkdlybuf4s25_1
XFILLER_115_225 VGND VGND VPWR VPWR sky130_fd_sc_hd__decap_3
Xinput99 operand_b[36] VGND VGND VPWR VPWR _4376_/B sky130_fd_sc_hd__clkdlybuf4s25_1
X_6250_ _6243_/Y _6245_/Y _6249_/X _7193_/A VGND VGND VPWR VPWR _6250_/X sky130_fd_sc_hd__a22o_2
XTAP_TAPCELL_ROW_73_1209 VGND VPWR sky130_fd_sc_hd__tapvpwrvgnd_1
XFILLER_88_109 VGND VGND VPWR VPWR sky130_fd_sc_hd__decap_3
X_6181_ _8243_/Q _6140_/Y _6180_/X VGND VGND VPWR VPWR _6181_/X sky130_fd_sc_hd__o21a_4
X_5201_ _5346_/A _8221_/Q _5200_/Y VGND VGND VPWR VPWR _5201_/X sky130_fd_sc_hd__a21bo_2
XFILLER_69_334 VGND VGND VPWR VPWR sky130_fd_sc_hd__fill_2
XFILLER_97_632 VGND VGND VPWR VPWR sky130_fd_sc_hd__decap_3
X_5132_ _8214_/Q _8215_/Q _5484_/S VGND VGND VPWR VPWR _5132_/X sky130_fd_sc_hd__mux2_2
XFILLER_57_518 VGND VGND VPWR VPWR sky130_fd_sc_hd__fill_2
XFILLER_69_378 VGND VGND VPWR VPWR sky130_fd_sc_hd__decap_3
XFILLER_84_304 VGND VGND VPWR VPWR sky130_fd_sc_hd__decap_3
XFILLER_97_665 VGND VGND VPWR VPWR sky130_fd_sc_hd__decap_3
XFILLER_97_687 VGND VGND VPWR VPWR sky130_fd_sc_hd__fill_2
XTAP_TAPCELL_ROW_4_308 VGND VPWR sky130_fd_sc_hd__tapvpwrvgnd_1
XFILLER_57_529 VGND VGND VPWR VPWR sky130_fd_sc_hd__decap_3
XFILLER_84_315 VGND VGND VPWR VPWR sky130_fd_sc_hd__decap_3
XFILLER_96_186 VGND VGND VPWR VPWR sky130_fd_sc_hd__decap_3
XFILLER_96_197 VGND VGND VPWR VPWR sky130_fd_sc_hd__decap_3
X_5063_ _6873_/A _7078_/A _4823_/B VGND VGND VPWR VPWR _5063_/Y sky130_fd_sc_hd__a21oi_2
XFILLER_37_231 VGND VGND VPWR VPWR sky130_fd_sc_hd__decap_3
XFILLER_84_348 VGND VGND VPWR VPWR sky130_fd_sc_hd__decap_3
X_4014_ _8309_/Q _8308_/Q _8311_/Q _8312_/Q VGND VGND VPWR VPWR _4017_/B sky130_fd_sc_hd__or4_2
XFILLER_65_595 VGND VGND VPWR VPWR sky130_fd_sc_hd__decap_3
XFILLER_80_521 VGND VGND VPWR VPWR sky130_fd_sc_hd__decap_3
XFILLER_92_392 VGND VGND VPWR VPWR sky130_fd_sc_hd__decap_3
XTAP_TAPCELL_ROW_84_1349 VGND VPWR sky130_fd_sc_hd__tapvpwrvgnd_1
XFILLER_40_418 VGND VGND VPWR VPWR sky130_fd_sc_hd__fill_2
XFILLER_52_256 VGND VGND VPWR VPWR sky130_fd_sc_hd__decap_3
XFILLER_80_554 VGND VGND VPWR VPWR sky130_fd_sc_hd__decap_3
X_5965_ _5965_/A _5965_/B VGND VGND VPWR VPWR _5965_/Y sky130_fd_sc_hd__nor2_2
XFILLER_52_278 VGND VGND VPWR VPWR sky130_fd_sc_hd__decap_3
XFILLER_80_587 VGND VGND VPWR VPWR sky130_fd_sc_hd__fill_1
X_7704_ _5363_/X _8184_/Q _7655_/A _7702_/Y _7703_/X VGND VGND VPWR VPWR _7705_/C
+ sky130_fd_sc_hd__a311o_2
X_5896_ _5896_/A _6095_/D VGND VGND VPWR VPWR _5941_/B sky130_fd_sc_hd__or2_4
X_4916_ _6007_/A _6046_/A _6084_/A _6299_/B VGND VGND VPWR VPWR _4917_/C sky130_fd_sc_hd__or4b_2
XTAP_TAPCELL_ROW_51_925 VGND VPWR sky130_fd_sc_hd__tapvpwrvgnd_1
XFILLER_20_120 VGND VGND VPWR VPWR sky130_fd_sc_hd__decap_3
XFILLER_32_38 VGND VGND VPWR VPWR sky130_fd_sc_hd__decap_3
X_7635_ _4722_/B _7588_/B _7634_/X VGND VGND VPWR VPWR _7844_/D sky130_fd_sc_hd__a21bo_2
X_4847_ _8194_/Q _8258_/Q VGND VGND VPWR VPWR _4849_/A sky130_fd_sc_hd__and2b_2
XFILLER_119_520 VGND VGND VPWR VPWR sky130_fd_sc_hd__fill_1
XFILLER_20_153 VGND VGND VPWR VPWR sky130_fd_sc_hd__decap_3
XFILLER_21_676 VGND VGND VPWR VPWR sky130_fd_sc_hd__decap_3
XTAP_TAPCELL_ROW_31_660 VGND VPWR sky130_fd_sc_hd__tapvpwrvgnd_1
XFILLER_119_564 VGND VGND VPWR VPWR sky130_fd_sc_hd__fill_1
XFILLER_20_197 VGND VGND VPWR VPWR sky130_fd_sc_hd__decap_3
X_7566_ _7563_/Y _7565_/Y _8221_/Q VGND VGND VPWR VPWR _7567_/D sky130_fd_sc_hd__mux2_4
Xrebuffer947 _8171_/Q VGND VGND VPWR VPWR rebuffer947/X sky130_fd_sc_hd__buf_6
X_4778_ _7195_/A _8273_/Q VGND VGND VPWR VPWR _4781_/A sky130_fd_sc_hd__nand2_2
XFILLER_106_203 VGND VGND VPWR VPWR sky130_fd_sc_hd__decap_3
X_7497_ _7497_/A _7497_/B VGND VGND VPWR VPWR _7497_/Y sky130_fd_sc_hd__xnor2_2
X_6517_ _8188_/Q _6488_/X _6495_/X _6496_/Y _6516_/Y VGND VGND VPWR VPWR _6517_/X
+ sky130_fd_sc_hd__o221a_2
XFILLER_106_236 VGND VGND VPWR VPWR sky130_fd_sc_hd__decap_3
X_6448_ _8251_/Q _6439_/X _8187_/Q VGND VGND VPWR VPWR _6448_/X sky130_fd_sc_hd__a21o_2
X_6379_ _8185_/Q _6379_/B VGND VGND VPWR VPWR _6390_/B sky130_fd_sc_hd__nand2_2
XTAP_TAPCELL_ROW_95_1489 VGND VPWR sky130_fd_sc_hd__tapvpwrvgnd_1
XFILLER_0_536 VGND VGND VPWR VPWR sky130_fd_sc_hd__fill_1
XFILLER_114_280 VGND VGND VPWR VPWR sky130_fd_sc_hd__decap_3
X_8118_ _8389_/CLK _8118_/D VGND VGND VPWR VPWR _8118_/Q sky130_fd_sc_hd__dfxtp_2
XFILLER_102_442 VGND VGND VPWR VPWR sky130_fd_sc_hd__decap_3
XFILLER_57_24 VGND VGND VPWR VPWR sky130_fd_sc_hd__decap_3
XFILLER_102_486 VGND VGND VPWR VPWR sky130_fd_sc_hd__decap_3
XFILLER_48_529 VGND VGND VPWR VPWR sky130_fd_sc_hd__decap_3
XFILLER_57_57 VGND VGND VPWR VPWR sky130_fd_sc_hd__decap_3
XFILLER_75_326 VGND VGND VPWR VPWR sky130_fd_sc_hd__decap_3
X_8049_ _8224_/CLK _8049_/D VGND VGND VPWR VPWR _8049_/Q sky130_fd_sc_hd__dfxtp_2
XFILLER_113_30 VGND VGND VPWR VPWR sky130_fd_sc_hd__decap_3
XFILLER_28_231 VGND VGND VPWR VPWR sky130_fd_sc_hd__decap_3
XFILLER_29_732 VGND VGND VPWR VPWR sky130_fd_sc_hd__fill_1
XFILLER_75_359 VGND VGND VPWR VPWR sky130_fd_sc_hd__decap_3
XFILLER_113_63 VGND VGND VPWR VPWR sky130_fd_sc_hd__fill_2
XFILLER_16_404 VGND VGND VPWR VPWR sky130_fd_sc_hd__decap_3
XFILLER_28_253 VGND VGND VPWR VPWR sky130_fd_sc_hd__fill_2
XFILLER_90_318 VGND VGND VPWR VPWR sky130_fd_sc_hd__fill_2
XFILLER_90_329 VGND VGND VPWR VPWR sky130_fd_sc_hd__decap_3
XTAP_TAPCELL_ROW_39_771 VGND VPWR sky130_fd_sc_hd__tapvpwrvgnd_1
XTAP_TAPCELL_ROW_39_760 VGND VPWR sky130_fd_sc_hd__tapvpwrvgnd_1
XFILLER_113_74 VGND VGND VPWR VPWR sky130_fd_sc_hd__decap_3
XFILLER_113_96 VGND VGND VPWR VPWR sky130_fd_sc_hd__decap_3
XFILLER_16_448 VGND VGND VPWR VPWR sky130_fd_sc_hd__decap_3
XFILLER_73_45 VGND VGND VPWR VPWR sky130_fd_sc_hd__decap_3
XFILLER_83_370 VGND VGND VPWR VPWR sky130_fd_sc_hd__decap_3
XFILLER_31_407 VGND VGND VPWR VPWR sky130_fd_sc_hd__decap_3
XFILLER_71_576 VGND VGND VPWR VPWR sky130_fd_sc_hd__decap_3
XFILLER_12_643 VGND VGND VPWR VPWR sky130_fd_sc_hd__fill_1
XFILLER_12_654 VGND VGND VPWR VPWR sky130_fd_sc_hd__fill_2
XFILLER_24_492 VGND VGND VPWR VPWR sky130_fd_sc_hd__decap_3
XFILLER_11_142 VGND VGND VPWR VPWR sky130_fd_sc_hd__decap_3
XFILLER_7_113 VGND VGND VPWR VPWR sky130_fd_sc_hd__decap_3
XFILLER_8_614 VGND VGND VPWR VPWR sky130_fd_sc_hd__decap_3
XFILLER_7_135 VGND VGND VPWR VPWR sky130_fd_sc_hd__decap_3
XFILLER_22_82 VGND VGND VPWR VPWR sky130_fd_sc_hd__fill_2
XTAP_TAPCELL_ROW_59_1031 VGND VPWR sky130_fd_sc_hd__tapvpwrvgnd_1
XTAP_TAPCELL_ROW_59_1020 VGND VPWR sky130_fd_sc_hd__tapvpwrvgnd_1
XFILLER_113_707 VGND VGND VPWR VPWR sky130_fd_sc_hd__fill_1
XFILLER_113_729 VGND VGND VPWR VPWR sky130_fd_sc_hd__decap_3
XFILLER_3_352 VGND VGND VPWR VPWR sky130_fd_sc_hd__fill_2
XFILLER_3_363 VGND VGND VPWR VPWR sky130_fd_sc_hd__decap_3
XFILLER_79_676 VGND VGND VPWR VPWR sky130_fd_sc_hd__decap_3
XFILLER_47_540 VGND VGND VPWR VPWR sky130_fd_sc_hd__decap_3
XFILLER_66_337 VGND VGND VPWR VPWR sky130_fd_sc_hd__decap_3
XFILLER_78_197 VGND VGND VPWR VPWR sky130_fd_sc_hd__decap_3
XFILLER_93_134 VGND VGND VPWR VPWR sky130_fd_sc_hd__decap_3
XFILLER_94_668 VGND VGND VPWR VPWR sky130_fd_sc_hd__decap_3
XFILLER_47_573 VGND VGND VPWR VPWR sky130_fd_sc_hd__decap_3
XFILLER_81_307 VGND VGND VPWR VPWR sky130_fd_sc_hd__decap_3
XFILLER_93_167 VGND VGND VPWR VPWR sky130_fd_sc_hd__fill_1
XFILLER_93_178 VGND VGND VPWR VPWR sky130_fd_sc_hd__decap_3
XFILLER_62_543 VGND VGND VPWR VPWR sky130_fd_sc_hd__fill_1
XFILLER_74_392 VGND VGND VPWR VPWR sky130_fd_sc_hd__decap_3
XFILLER_62_587 VGND VGND VPWR VPWR sky130_fd_sc_hd__fill_1
XFILLER_62_598 VGND VGND VPWR VPWR sky130_fd_sc_hd__decap_3
X_5750_ _5745_/X _5746_/X _5749_/Y _6707_/S VGND VGND VPWR VPWR _5750_/X sky130_fd_sc_hd__o22a_2
XTAP_TAPCELL_ROW_17_476 VGND VPWR sky130_fd_sc_hd__tapvpwrvgnd_1
XFILLER_30_440 VGND VGND VPWR VPWR sky130_fd_sc_hd__decap_3
X_5681_ split/X _6648_/A VGND VGND VPWR VPWR _5681_/Y sky130_fd_sc_hd__nand2_2
X_4701_ _4701_/A VGND VGND VPWR VPWR _8288_/D sky130_fd_sc_hd__buf_1
XFILLER_30_462 VGND VGND VPWR VPWR sky130_fd_sc_hd__fill_1
X_7420_ _6890_/X _7419_/X _6617_/X _7124_/X _5182_/A _7745_/A VGND VGND VPWR VPWR
+ _7420_/X sky130_fd_sc_hd__mux4_2
X_4632_ _7930_/B _8120_/Q VGND VGND VPWR VPWR _4633_/A sky130_fd_sc_hd__and2_2
XFILLER_8_73 VGND VGND VPWR VPWR sky130_fd_sc_hd__decap_3
X_7351_ _6533_/A _7350_/X _6249_/X VGND VGND VPWR VPWR _7351_/X sky130_fd_sc_hd__a21bo_2
X_4563_ _4563_/A VGND VGND VPWR VPWR _8219_/D sky130_fd_sc_hd__buf_1
XFILLER_116_545 VGND VGND VPWR VPWR sky130_fd_sc_hd__decap_3
X_7282_ _7306_/B VGND VGND VPWR VPWR _7282_/Y sky130_fd_sc_hd__bufinv_8
X_6302_ _6300_/B _6302_/B _6302_/C _6302_/D VGND VGND VPWR VPWR _6303_/B sky130_fd_sc_hd__and4b_2
X_4494_ _7898_/B _8051_/Q VGND VGND VPWR VPWR _4495_/A sky130_fd_sc_hd__and2_2
XFILLER_116_567 VGND VGND VPWR VPWR sky130_fd_sc_hd__decap_3
XFILLER_116_589 VGND VGND VPWR VPWR sky130_fd_sc_hd__decap_3
XFILLER_89_407 VGND VGND VPWR VPWR sky130_fd_sc_hd__decap_3
X_6233_ _7613_/B _6233_/B VGND VGND VPWR VPWR _6236_/A sky130_fd_sc_hd__and2_2
XFILLER_103_217 VGND VGND VPWR VPWR sky130_fd_sc_hd__decap_3
XFILLER_103_228 VGND VGND VPWR VPWR sky130_fd_sc_hd__decap_3
XFILLER_69_153 VGND VGND VPWR VPWR sky130_fd_sc_hd__decap_3
X_6164_ _7193_/B VGND VGND VPWR VPWR _6787_/A sky130_fd_sc_hd__clkbuf_1
XFILLER_97_473 VGND VGND VPWR VPWR sky130_fd_sc_hd__decap_3
X_6095_ _6095_/A _8173_/Q _6095_/C _6095_/D VGND VGND VPWR VPWR _6147_/D sky130_fd_sc_hd__or4_4
X_5115_ _7617_/A _6775_/B VGND VGND VPWR VPWR _5116_/A sky130_fd_sc_hd__or2_2
XFILLER_84_134 VGND VGND VPWR VPWR sky130_fd_sc_hd__decap_3
X_5046_ _8248_/Q _8184_/Q VGND VGND VPWR VPWR _5046_/X sky130_fd_sc_hd__and2b_2
XFILLER_38_551 VGND VGND VPWR VPWR sky130_fd_sc_hd__decap_3
XFILLER_38_573 VGND VGND VPWR VPWR sky130_fd_sc_hd__decap_3
XFILLER_72_318 VGND VGND VPWR VPWR sky130_fd_sc_hd__decap_3
XFILLER_65_370 VGND VGND VPWR VPWR sky130_fd_sc_hd__decap_3
XTAP_TAPCELL_ROW_36_730 VGND VPWR sky130_fd_sc_hd__tapvpwrvgnd_1
XFILLER_25_245 VGND VGND VPWR VPWR sky130_fd_sc_hd__decap_3
XFILLER_80_340 VGND VGND VPWR VPWR sky130_fd_sc_hd__fill_2
X_6997_ _8204_/Q _8268_/Q VGND VGND VPWR VPWR _6997_/X sky130_fd_sc_hd__or2_2
XFILLER_13_418 VGND VGND VPWR VPWR sky130_fd_sc_hd__decap_3
XFILLER_13_429 VGND VGND VPWR VPWR sky130_fd_sc_hd__decap_3
XFILLER_25_278 VGND VGND VPWR VPWR sky130_fd_sc_hd__fill_2
XFILLER_43_26 VGND VGND VPWR VPWR sky130_fd_sc_hd__decap_3
X_5948_ _5942_/Y _5946_/X _7767_/B _5977_/B VGND VGND VPWR VPWR _5963_/B sky130_fd_sc_hd__a2bb2o_2
XFILLER_40_237 VGND VGND VPWR VPWR sky130_fd_sc_hd__decap_3
XFILLER_43_48 VGND VGND VPWR VPWR sky130_fd_sc_hd__decap_3
X_5879_ _6076_/A _5879_/B VGND VGND VPWR VPWR _8306_/D sky130_fd_sc_hd__nor2_2
XFILLER_21_495 VGND VGND VPWR VPWR sky130_fd_sc_hd__decap_3
X_7618_ _7844_/B _7551_/B _7615_/Y _7616_/X _7617_/X VGND VGND VPWR VPWR _7618_/X
+ sky130_fd_sc_hd__o221a_2
Xrebuffer733 _6077_/B VGND VGND VPWR VPWR _6046_/B sky130_fd_sc_hd__buf_2
XTAP_TAPCELL_ROW_97_1518 VGND VPWR sky130_fd_sc_hd__tapvpwrvgnd_1
XFILLER_119_361 VGND VGND VPWR VPWR sky130_fd_sc_hd__decap_3
XFILLER_5_617 VGND VGND VPWR VPWR sky130_fd_sc_hd__decap_3
X_7549_ _5492_/Y _7548_/X _8221_/Q VGND VGND VPWR VPWR _7567_/A sky130_fd_sc_hd__mux2_2
XFILLER_107_534 VGND VGND VPWR VPWR sky130_fd_sc_hd__fill_1
XFILLER_107_545 VGND VGND VPWR VPWR sky130_fd_sc_hd__decap_3
Xrebuffer788 _6140_/Y VGND VGND VPWR VPWR _6144_/B1 sky130_fd_sc_hd__buf_2
Xrebuffer799 _6362_/X VGND VGND VPWR VPWR _6365_/A2 sky130_fd_sc_hd__buf_2
XFILLER_107_567 VGND VGND VPWR VPWR sky130_fd_sc_hd__decap_3
XFILLER_107_589 VGND VGND VPWR VPWR sky130_fd_sc_hd__decap_3
XFILLER_108_85 VGND VGND VPWR VPWR sky130_fd_sc_hd__fill_2
XFILLER_68_45 VGND VGND VPWR VPWR sky130_fd_sc_hd__fill_1
XFILLER_68_78 VGND VGND VPWR VPWR sky130_fd_sc_hd__decap_3
XFILLER_102_250 VGND VGND VPWR VPWR sky130_fd_sc_hd__fill_2
XFILLER_102_272 VGND VGND VPWR VPWR sky130_fd_sc_hd__decap_3
XFILLER_0_399 VGND VGND VPWR VPWR sky130_fd_sc_hd__fill_2
XFILLER_48_359 VGND VGND VPWR VPWR sky130_fd_sc_hd__decap_3
XFILLER_84_11 VGND VGND VPWR VPWR sky130_fd_sc_hd__decap_3
XFILLER_63_318 VGND VGND VPWR VPWR sky130_fd_sc_hd__decap_3
XFILLER_29_584 VGND VGND VPWR VPWR sky130_fd_sc_hd__decap_3
XFILLER_44_510 VGND VGND VPWR VPWR sky130_fd_sc_hd__decap_3
XFILLER_56_392 VGND VGND VPWR VPWR sky130_fd_sc_hd__decap_3
XFILLER_75_189 VGND VGND VPWR VPWR sky130_fd_sc_hd__decap_3
XFILLER_84_690 VGND VGND VPWR VPWR sky130_fd_sc_hd__fill_2
XFILLER_91_638 VGND VGND VPWR VPWR sky130_fd_sc_hd__decap_3
XTAP_TAPCELL_ROW_106_1636 VGND VPWR sky130_fd_sc_hd__tapvpwrvgnd_1
XFILLER_16_256 VGND VGND VPWR VPWR sky130_fd_sc_hd__decap_3
XFILLER_71_340 VGND VGND VPWR VPWR sky130_fd_sc_hd__fill_1
XFILLER_16_278 VGND VGND VPWR VPWR sky130_fd_sc_hd__fill_2
XFILLER_44_576 VGND VGND VPWR VPWR sky130_fd_sc_hd__fill_1
XFILLER_71_373 VGND VGND VPWR VPWR sky130_fd_sc_hd__decap_3
XFILLER_31_237 VGND VGND VPWR VPWR sky130_fd_sc_hd__decap_3
XTAP_TAPCELL_ROW_14_435 VGND VPWR sky130_fd_sc_hd__tapvpwrvgnd_1
XTAP_TAPCELL_ROW_14_446 VGND VPWR sky130_fd_sc_hd__tapvpwrvgnd_1
XFILLER_12_451 VGND VGND VPWR VPWR sky130_fd_sc_hd__decap_3
XFILLER_8_433 VGND VGND VPWR VPWR sky130_fd_sc_hd__decap_3
XTAP_TAPCELL_ROW_42_799 VGND VPWR sky130_fd_sc_hd__tapvpwrvgnd_1
XFILLER_8_477 VGND VGND VPWR VPWR sky130_fd_sc_hd__fill_1
XFILLER_113_515 VGND VGND VPWR VPWR sky130_fd_sc_hd__decap_3
XTAP_TAPCELL_ROW_117_1776 VGND VPWR sky130_fd_sc_hd__tapvpwrvgnd_1
XFILLER_113_548 VGND VGND VPWR VPWR sky130_fd_sc_hd__decap_3
XFILLER_98_237 VGND VGND VPWR VPWR sky130_fd_sc_hd__decap_3
XFILLER_98_259 VGND VGND VPWR VPWR sky130_fd_sc_hd__decap_3
XFILLER_67_613 VGND VGND VPWR VPWR sky130_fd_sc_hd__decap_3
XFILLER_67_635 VGND VGND VPWR VPWR sky130_fd_sc_hd__fill_1
XFILLER_94_410 VGND VGND VPWR VPWR sky130_fd_sc_hd__decap_3
XFILLER_39_337 VGND VGND VPWR VPWR sky130_fd_sc_hd__decap_3
XFILLER_39_348 VGND VGND VPWR VPWR sky130_fd_sc_hd__decap_3
XFILLER_94_421 VGND VGND VPWR VPWR sky130_fd_sc_hd__decap_3
XFILLER_54_318 VGND VGND VPWR VPWR sky130_fd_sc_hd__decap_3
XFILLER_81_104 VGND VGND VPWR VPWR sky130_fd_sc_hd__decap_3
XFILLER_82_627 VGND VGND VPWR VPWR sky130_fd_sc_hd__decap_3
XFILLER_94_465 VGND VGND VPWR VPWR sky130_fd_sc_hd__decap_3
XFILLER_47_381 VGND VGND VPWR VPWR sky130_fd_sc_hd__decap_3
XFILLER_66_189 VGND VGND VPWR VPWR sky130_fd_sc_hd__decap_3
XFILLER_94_498 VGND VGND VPWR VPWR sky130_fd_sc_hd__decap_3
X_6920_ _8201_/Q _8200_/Q _8199_/Q _8198_/Q _7796_/A _7812_/A VGND VGND VPWR VPWR
+ _6920_/X sky130_fd_sc_hd__mux4_2
X_6851_ _4834_/B _6815_/B _6850_/X VGND VGND VPWR VPWR _6852_/B sky130_fd_sc_hd__a21o_2
XFILLER_35_576 VGND VGND VPWR VPWR sky130_fd_sc_hd__decap_3
XFILLER_90_671 VGND VGND VPWR VPWR sky130_fd_sc_hd__decap_3
X_5802_ _8234_/Q _5793_/X _7776_/B VGND VGND VPWR VPWR _5802_/X sky130_fd_sc_hd__a21bo_2
XTAP_TAPCELL_ROW_81_1308 VGND VPWR sky130_fd_sc_hd__tapvpwrvgnd_1
XFILLER_22_259 VGND VGND VPWR VPWR sky130_fd_sc_hd__decap_3
X_6782_ _6781_/X _6646_/X _7670_/A VGND VGND VPWR VPWR _6782_/X sky130_fd_sc_hd__mux2_2
X_3994_ _8350_/Q _7930_/B VGND VGND VPWR VPWR _3995_/A sky130_fd_sc_hd__and2_2
X_5733_ _7613_/B _5733_/B VGND VGND VPWR VPWR _5733_/X sky130_fd_sc_hd__or2_2
X_5664_ _8230_/Q _5562_/B _5663_/X VGND VGND VPWR VPWR _5664_/X sky130_fd_sc_hd__o21a_2
XFILLER_108_309 VGND VGND VPWR VPWR sky130_fd_sc_hd__decap_3
X_7403_ _7280_/B _7398_/X _7402_/X VGND VGND VPWR VPWR _7404_/B sky130_fd_sc_hd__a21o_2
X_8383_ _8386_/CLK _8383_/D VGND VGND VPWR VPWR _8383_/Q sky130_fd_sc_hd__dfxtp_2
X_5595_ _5484_/X _5594_/X _5634_/S VGND VGND VPWR VPWR _5595_/X sky130_fd_sc_hd__mux2_2
X_4615_ _4615_/A VGND VGND VPWR VPWR _8245_/D sky130_fd_sc_hd__buf_1
X_7334_ _6148_/X _7309_/Y _7316_/Y _7315_/X _7333_/X VGND VGND VPWR VPWR _7335_/B
+ sky130_fd_sc_hd__a221o_2
X_4546_ _7843_/A _8077_/Q VGND VGND VPWR VPWR _4547_/A sky130_fd_sc_hd__and2_2
XFILLER_104_515 VGND VGND VPWR VPWR sky130_fd_sc_hd__decap_3
XFILLER_116_386 VGND VGND VPWR VPWR sky130_fd_sc_hd__decap_3
XFILLER_89_237 VGND VGND VPWR VPWR sky130_fd_sc_hd__decap_3
X_7265_ _7264_/Y _7613_/B _8211_/Q VGND VGND VPWR VPWR _7265_/X sky130_fd_sc_hd__mux2_2
X_4477_ _4477_/A VGND VGND VPWR VPWR _8176_/D sky130_fd_sc_hd__buf_1
XTAP_TAPCELL_ROW_92_1459 VGND VPWR sky130_fd_sc_hd__tapvpwrvgnd_1
X_7196_ _7195_/A _5817_/A _7317_/C _7195_/Y VGND VGND VPWR VPWR _7197_/B sky130_fd_sc_hd__a31o_2
X_6216_ _6297_/A VGND VGND VPWR VPWR _6219_/A sky130_fd_sc_hd__inv_2
XFILLER_58_602 VGND VGND VPWR VPWR sky130_fd_sc_hd__decap_3
X_6147_ _8178_/Q _8179_/Q _6147_/C _6147_/D VGND VGND VPWR VPWR _6838_/C sky130_fd_sc_hd__nor4_4
XFILLER_112_592 VGND VGND VPWR VPWR sky130_fd_sc_hd__decap_3
XFILLER_57_134 VGND VGND VPWR VPWR sky130_fd_sc_hd__decap_3
XFILLER_85_443 VGND VGND VPWR VPWR sky130_fd_sc_hd__decap_3
XFILLER_97_292 VGND VGND VPWR VPWR sky130_fd_sc_hd__fill_2
XFILLER_57_178 VGND VGND VPWR VPWR sky130_fd_sc_hd__decap_3
X_6078_ _8241_/Q _6045_/B _6045_/A _8177_/Q VGND VGND VPWR VPWR _6079_/B sky130_fd_sc_hd__a31o_2
XFILLER_72_104 VGND VGND VPWR VPWR sky130_fd_sc_hd__decap_3
XFILLER_85_498 VGND VGND VPWR VPWR sky130_fd_sc_hd__decap_3
X_5029_ _8235_/Q _5022_/A VGND VGND VPWR VPWR _5029_/X sky130_fd_sc_hd__or2b_4
XFILLER_38_392 VGND VGND VPWR VPWR sky130_fd_sc_hd__decap_3
XFILLER_53_340 VGND VGND VPWR VPWR sky130_fd_sc_hd__decap_3
XFILLER_53_351 VGND VGND VPWR VPWR sky130_fd_sc_hd__decap_3
XFILLER_54_47 VGND VGND VPWR VPWR sky130_fd_sc_hd__decap_3
XFILLER_72_159 VGND VGND VPWR VPWR sky130_fd_sc_hd__decap_3
XFILLER_13_215 VGND VGND VPWR VPWR sky130_fd_sc_hd__decap_3
XFILLER_14_727 VGND VGND VPWR VPWR sky130_fd_sc_hd__decap_3
XFILLER_41_502 VGND VGND VPWR VPWR sky130_fd_sc_hd__fill_2
XFILLER_81_682 VGND VGND VPWR VPWR sky130_fd_sc_hd__decap_3
XFILLER_41_535 VGND VGND VPWR VPWR sky130_fd_sc_hd__decap_3
XFILLER_80_192 VGND VGND VPWR VPWR sky130_fd_sc_hd__decap_3
XFILLER_13_259 VGND VGND VPWR VPWR sky130_fd_sc_hd__decap_3
XFILLER_70_35 VGND VGND VPWR VPWR sky130_fd_sc_hd__decap_3
XTAP_TAPCELL_ROW_101_1566 VGND VPWR sky130_fd_sc_hd__tapvpwrvgnd_1
XTAP_TAPCELL_ROW_11_405 VGND VPWR sky130_fd_sc_hd__tapvpwrvgnd_1
XFILLER_21_270 VGND VGND VPWR VPWR sky130_fd_sc_hd__decap_3
XFILLER_21_281 VGND VGND VPWR VPWR sky130_fd_sc_hd__fill_2
XFILLER_70_68 VGND VGND VPWR VPWR sky130_fd_sc_hd__decap_3
XTAP_TAPCELL_ROW_101_1577 VGND VPWR sky130_fd_sc_hd__tapvpwrvgnd_1
Xrebuffer574 _4890_/B VGND VGND VPWR VPWR _6257_/B1_N sky130_fd_sc_hd__buf_2
XFILLER_107_364 VGND VGND VPWR VPWR sky130_fd_sc_hd__decap_3
XFILLER_119_73 VGND VGND VPWR VPWR sky130_fd_sc_hd__decap_3
XFILLER_5_458 VGND VGND VPWR VPWR sky130_fd_sc_hd__decap_3
XFILLER_107_375 VGND VGND VPWR VPWR sky130_fd_sc_hd__decap_3
XFILLER_1_642 VGND VGND VPWR VPWR sky130_fd_sc_hd__fill_2
XFILLER_110_518 VGND VGND VPWR VPWR sky130_fd_sc_hd__decap_3
XFILLER_1_664 VGND VGND VPWR VPWR sky130_fd_sc_hd__decap_3
XFILLER_76_410 VGND VGND VPWR VPWR sky130_fd_sc_hd__decap_3
XFILLER_95_207 VGND VGND VPWR VPWR sky130_fd_sc_hd__decap_3
XFILLER_95_21 VGND VGND VPWR VPWR sky130_fd_sc_hd__decap_3
XFILLER_1_697 VGND VGND VPWR VPWR sky130_fd_sc_hd__fill_2
XFILLER_48_123 VGND VGND VPWR VPWR sky130_fd_sc_hd__decap_3
XFILLER_49_646 VGND VGND VPWR VPWR sky130_fd_sc_hd__decap_3
XFILLER_76_421 VGND VGND VPWR VPWR sky130_fd_sc_hd__decap_3
XFILLER_95_54 VGND VGND VPWR VPWR sky130_fd_sc_hd__fill_2
XFILLER_36_307 VGND VGND VPWR VPWR sky130_fd_sc_hd__fill_1
XFILLER_36_318 VGND VGND VPWR VPWR sky130_fd_sc_hd__decap_3
XFILLER_64_627 VGND VGND VPWR VPWR sky130_fd_sc_hd__decap_3
XFILLER_76_465 VGND VGND VPWR VPWR sky130_fd_sc_hd__decap_3
XFILLER_91_402 VGND VGND VPWR VPWR sky130_fd_sc_hd__decap_3
XFILLER_95_87 VGND VGND VPWR VPWR sky130_fd_sc_hd__decap_3
XTAP_TAPCELL_ROW_19_505 VGND VPWR sky130_fd_sc_hd__tapvpwrvgnd_1
XFILLER_29_381 VGND VGND VPWR VPWR sky130_fd_sc_hd__decap_3
XFILLER_63_104 VGND VGND VPWR VPWR sky130_fd_sc_hd__decap_3
XFILLER_63_137 VGND VGND VPWR VPWR sky130_fd_sc_hd__decap_3
XFILLER_17_532 VGND VGND VPWR VPWR sky130_fd_sc_hd__decap_3
XFILLER_91_479 VGND VGND VPWR VPWR sky130_fd_sc_hd__decap_3
XTAP_TAPCELL_ROW_67_1130 VGND VPWR sky130_fd_sc_hd__tapvpwrvgnd_1
XTAP_TAPCELL_ROW_47_869 VGND VPWR sky130_fd_sc_hd__tapvpwrvgnd_1
XFILLER_44_395 VGND VGND VPWR VPWR sky130_fd_sc_hd__decap_3
XFILLER_32_579 VGND VGND VPWR VPWR sky130_fd_sc_hd__decap_3
XFILLER_44_91 VGND VGND VPWR VPWR sky130_fd_sc_hd__fill_2
XFILLER_12_281 VGND VGND VPWR VPWR sky130_fd_sc_hd__decap_3
XTAP_TAPCELL_ROW_119_1805 VGND VPWR sky130_fd_sc_hd__tapvpwrvgnd_1
XTAP_TAPCELL_ROW_119_1816 VGND VPWR sky130_fd_sc_hd__tapvpwrvgnd_1
XFILLER_8_296 VGND VGND VPWR VPWR sky130_fd_sc_hd__decap_3
X_4400_ _7930_/B _4400_/B VGND VGND VPWR VPWR _4401_/A sky130_fd_sc_hd__and2_2
X_5380_ _5146_/X _5170_/X _5384_/S VGND VGND VPWR VPWR _5380_/X sky130_fd_sc_hd__mux2_2
XTAP_TAPCELL_ROW_78_1270 VGND VPWR sky130_fd_sc_hd__tapvpwrvgnd_1
XFILLER_113_312 VGND VGND VPWR VPWR sky130_fd_sc_hd__decap_3
XFILLER_99_546 VGND VGND VPWR VPWR sky130_fd_sc_hd__decap_3
X_4331_ _4331_/A VGND VGND VPWR VPWR _8103_/D sky130_fd_sc_hd__buf_1
XFILLER_87_708 VGND VGND VPWR VPWR sky130_fd_sc_hd__decap_3
X_7050_ _7166_/A _7031_/Y _7159_/A VGND VGND VPWR VPWR _7051_/B sky130_fd_sc_hd__o21ai_4
X_4262_ _7898_/B _4262_/B VGND VGND VPWR VPWR _4263_/A sky130_fd_sc_hd__and2_2
XFILLER_101_529 VGND VGND VPWR VPWR sky130_fd_sc_hd__fill_1
XFILLER_113_367 VGND VGND VPWR VPWR sky130_fd_sc_hd__decap_3
XFILLER_113_389 VGND VGND VPWR VPWR sky130_fd_sc_hd__decap_3
X_6001_ _5993_/A _5992_/X _8239_/Q VGND VGND VPWR VPWR _6003_/B sky130_fd_sc_hd__a21o_2
XFILLER_67_432 VGND VGND VPWR VPWR sky130_fd_sc_hd__decap_3
XFILLER_79_281 VGND VGND VPWR VPWR sky130_fd_sc_hd__decap_3
X_4193_ _4193_/A VGND VGND VPWR VPWR _8034_/D sky130_fd_sc_hd__buf_1
XFILLER_39_145 VGND VGND VPWR VPWR sky130_fd_sc_hd__fill_2
XFILLER_55_605 VGND VGND VPWR VPWR sky130_fd_sc_hd__decap_3
XFILLER_94_262 VGND VGND VPWR VPWR sky130_fd_sc_hd__decap_3
XFILLER_27_329 VGND VGND VPWR VPWR sky130_fd_sc_hd__decap_3
XFILLER_48_690 VGND VGND VPWR VPWR sky130_fd_sc_hd__decap_3
XFILLER_54_115 VGND VGND VPWR VPWR sky130_fd_sc_hd__decap_3
XFILLER_82_413 VGND VGND VPWR VPWR sky130_fd_sc_hd__decap_3
XFILLER_82_424 VGND VGND VPWR VPWR sky130_fd_sc_hd__decap_3
XFILLER_94_295 VGND VGND VPWR VPWR sky130_fd_sc_hd__decap_3
X_7952_ _8269_/CLK _7952_/D VGND VGND VPWR VPWR _7952_/Q sky130_fd_sc_hd__dfxtp_2
XFILLER_82_457 VGND VGND VPWR VPWR sky130_fd_sc_hd__decap_3
X_6903_ _6901_/X _6902_/X _6903_/S VGND VGND VPWR VPWR _6903_/X sky130_fd_sc_hd__mux2_2
XFILLER_35_373 VGND VGND VPWR VPWR sky130_fd_sc_hd__decap_3
XFILLER_63_671 VGND VGND VPWR VPWR sky130_fd_sc_hd__fill_1
X_7883_ _7883_/A VGND VGND VPWR VPWR _8378_/D sky130_fd_sc_hd__buf_1
XFILLER_50_321 VGND VGND VPWR VPWR sky130_fd_sc_hd__decap_3
X_6834_ _6462_/A _8198_/Q _6833_/Y _5332_/A _6956_/C VGND VGND VPWR VPWR _6834_/X
+ sky130_fd_sc_hd__a32o_2
XFILLER_10_207 VGND VGND VPWR VPWR sky130_fd_sc_hd__fill_2
XFILLER_11_708 VGND VGND VPWR VPWR sky130_fd_sc_hd__decap_3
XFILLER_23_579 VGND VGND VPWR VPWR sky130_fd_sc_hd__decap_3
XFILLER_50_365 VGND VGND VPWR VPWR sky130_fd_sc_hd__decap_3
X_6765_ _6775_/B _6765_/B VGND VGND VPWR VPWR _6765_/Y sky130_fd_sc_hd__nand2_2
X_3977_ _3977_/A VGND VGND VPWR VPWR _7937_/D sky130_fd_sc_hd__buf_1
X_5716_ _5716_/A _6184_/B _5715_/Y VGND VGND VPWR VPWR _5716_/X sky130_fd_sc_hd__or3b_2
XFILLER_109_607 VGND VGND VPWR VPWR sky130_fd_sc_hd__decap_3
X_6696_ _6695_/X _6694_/Y _7844_/C VGND VGND VPWR VPWR _6696_/Y sky130_fd_sc_hd__a21oi_4
XFILLER_108_117 VGND VGND VPWR VPWR sky130_fd_sc_hd__decap_3
X_5647_ _5645_/X _5646_/X _6321_/B VGND VGND VPWR VPWR _5647_/X sky130_fd_sc_hd__mux2_2
X_8366_ _8387_/CLK _8366_/D VGND VGND VPWR VPWR _8366_/Q sky130_fd_sc_hd__dfxtp_2
X_5578_ _5354_/X _5356_/X _5596_/S VGND VGND VPWR VPWR _5578_/X sky130_fd_sc_hd__mux2_2
XFILLER_104_312 VGND VGND VPWR VPWR sky130_fd_sc_hd__decap_3
XFILLER_116_150 VGND VGND VPWR VPWR sky130_fd_sc_hd__decap_3
XFILLER_2_439 VGND VGND VPWR VPWR sky130_fd_sc_hd__fill_1
X_8297_ _8365_/CLK _8297_/D VGND VGND VPWR VPWR _8297_/Q sky130_fd_sc_hd__dfxtp_2
X_7317_ _8208_/Q _8209_/Q _7317_/C VGND VGND VPWR VPWR _7318_/D sky130_fd_sc_hd__and3_2
X_4529_ _4529_/A VGND VGND VPWR VPWR _8202_/D sky130_fd_sc_hd__buf_1
X_7248_ _7305_/A1 _7219_/Y _7247_/X _7930_/B VGND VGND VPWR VPWR _8344_/D sky130_fd_sc_hd__o211a_2
XFILLER_49_69 VGND VGND VPWR VPWR sky130_fd_sc_hd__decap_3
XFILLER_77_218 VGND VGND VPWR VPWR sky130_fd_sc_hd__decap_3
XFILLER_58_410 VGND VGND VPWR VPWR sky130_fd_sc_hd__decap_3
XFILLER_58_421 VGND VGND VPWR VPWR sky130_fd_sc_hd__decap_3
XFILLER_86_730 VGND VGND VPWR VPWR sky130_fd_sc_hd__decap_3
X_7179_ _6733_/X _6735_/B _6874_/X _7167_/X _7178_/X VGND VGND VPWR VPWR _7179_/X
+ sky130_fd_sc_hd__a41o_4
XFILLER_18_307 VGND VGND VPWR VPWR sky130_fd_sc_hd__fill_1
XFILLER_85_240 VGND VGND VPWR VPWR sky130_fd_sc_hd__decap_3
XFILLER_100_573 VGND VGND VPWR VPWR sky130_fd_sc_hd__decap_3
XFILLER_18_318 VGND VGND VPWR VPWR sky130_fd_sc_hd__decap_3
XFILLER_65_35 VGND VGND VPWR VPWR sky130_fd_sc_hd__decap_3
XFILLER_65_57 VGND VGND VPWR VPWR sky130_fd_sc_hd__decap_3
XFILLER_73_424 VGND VGND VPWR VPWR sky130_fd_sc_hd__decap_3
XFILLER_85_284 VGND VGND VPWR VPWR sky130_fd_sc_hd__decap_3
XFILLER_26_340 VGND VGND VPWR VPWR sky130_fd_sc_hd__decap_3
XFILLER_45_148 VGND VGND VPWR VPWR sky130_fd_sc_hd__decap_3
XFILLER_54_660 VGND VGND VPWR VPWR sky130_fd_sc_hd__decap_3
XFILLER_73_479 VGND VGND VPWR VPWR sky130_fd_sc_hd__decap_3
XTAP_TAPCELL_ROW_44_828 VGND VPWR sky130_fd_sc_hd__tapvpwrvgnd_1
XFILLER_26_395 VGND VGND VPWR VPWR sky130_fd_sc_hd__decap_3
XFILLER_53_181 VGND VGND VPWR VPWR sky130_fd_sc_hd__decap_3
XFILLER_81_23 VGND VGND VPWR VPWR sky130_fd_sc_hd__decap_3
XFILLER_81_490 VGND VGND VPWR VPWR sky130_fd_sc_hd__decap_3
XFILLER_14_579 VGND VGND VPWR VPWR sky130_fd_sc_hd__decap_3
XFILLER_41_343 VGND VGND VPWR VPWR sky130_fd_sc_hd__decap_3
XFILLER_41_365 VGND VGND VPWR VPWR sky130_fd_sc_hd__decap_3
XFILLER_10_730 VGND VGND VPWR VPWR sky130_fd_sc_hd__decap_3
XTAP_TAPCELL_ROW_62_1071 VGND VPWR sky130_fd_sc_hd__tapvpwrvgnd_1
XTAP_TAPCELL_ROW_62_1060 VGND VPWR sky130_fd_sc_hd__tapvpwrvgnd_1
XTAP_TAPCELL_ROW_24_574 VGND VPWR sky130_fd_sc_hd__tapvpwrvgnd_1
XFILLER_108_651 VGND VGND VPWR VPWR sky130_fd_sc_hd__decap_3
XFILLER_5_233 VGND VGND VPWR VPWR sky130_fd_sc_hd__decap_3
XFILLER_107_172 VGND VGND VPWR VPWR sky130_fd_sc_hd__decap_3
XFILLER_108_684 VGND VGND VPWR VPWR sky130_fd_sc_hd__decap_3
XTAP_TAPCELL_ROW_114_1735 VGND VPWR sky130_fd_sc_hd__tapvpwrvgnd_1
XTAP_TAPCELL_ROW_114_1746 VGND VPWR sky130_fd_sc_hd__tapvpwrvgnd_1
XFILLER_96_527 VGND VGND VPWR VPWR sky130_fd_sc_hd__decap_3
XFILLER_110_348 VGND VGND VPWR VPWR sky130_fd_sc_hd__fill_2
XFILLER_1_472 VGND VGND VPWR VPWR sky130_fd_sc_hd__decap_3
XFILLER_49_410 VGND VGND VPWR VPWR sky130_fd_sc_hd__fill_2
XFILLER_49_432 VGND VGND VPWR VPWR sky130_fd_sc_hd__decap_3
XFILLER_37_605 VGND VGND VPWR VPWR sky130_fd_sc_hd__decap_3
XFILLER_49_476 VGND VGND VPWR VPWR sky130_fd_sc_hd__decap_3
XFILLER_76_251 VGND VGND VPWR VPWR sky130_fd_sc_hd__fill_1
XFILLER_36_126 VGND VGND VPWR VPWR sky130_fd_sc_hd__decap_3
XFILLER_49_487 VGND VGND VPWR VPWR sky130_fd_sc_hd__decap_3
XFILLER_64_402 VGND VGND VPWR VPWR sky130_fd_sc_hd__decap_3
XFILLER_64_424 VGND VGND VPWR VPWR sky130_fd_sc_hd__fill_1
XFILLER_76_273 VGND VGND VPWR VPWR sky130_fd_sc_hd__decap_3
Xinput9 operand_a[12] VGND VGND VPWR VPWR input9/X sky130_fd_sc_hd__clkdlybuf4s25_1
XFILLER_36_159 VGND VGND VPWR VPWR sky130_fd_sc_hd__fill_1
XFILLER_64_446 VGND VGND VPWR VPWR sky130_fd_sc_hd__decap_3
XFILLER_91_254 VGND VGND VPWR VPWR sky130_fd_sc_hd__decap_3
XFILLER_45_660 VGND VGND VPWR VPWR sky130_fd_sc_hd__decap_3
XFILLER_17_384 VGND VGND VPWR VPWR sky130_fd_sc_hd__decap_3
XFILLER_32_321 VGND VGND VPWR VPWR sky130_fd_sc_hd__fill_2
XFILLER_44_181 VGND VGND VPWR VPWR sky130_fd_sc_hd__decap_3
X_4880_ _4880_/A _8249_/Q VGND VGND VPWR VPWR _4881_/A sky130_fd_sc_hd__nor2_2
XFILLER_20_505 VGND VGND VPWR VPWR sky130_fd_sc_hd__decap_3
XFILLER_32_365 VGND VGND VPWR VPWR sky130_fd_sc_hd__decap_3
XFILLER_32_387 VGND VGND VPWR VPWR sky130_fd_sc_hd__decap_3
XFILLER_60_685 VGND VGND VPWR VPWR sky130_fd_sc_hd__fill_1
X_6550_ _6550_/A _6655_/A VGND VGND VPWR VPWR _6550_/X sky130_fd_sc_hd__or2_4
XFILLER_9_561 VGND VGND VPWR VPWR sky130_fd_sc_hd__fill_1
X_5501_ _5487_/X _5488_/X _5496_/X _5500_/X VGND VGND VPWR VPWR _5501_/X sky130_fd_sc_hd__a211o_2
XFILLER_9_583 VGND VGND VPWR VPWR sky130_fd_sc_hd__fill_1
X_6481_ _4861_/A _6563_/A _6440_/Y _6479_/Y _6480_/Y VGND VGND VPWR VPWR _6481_/X
+ sky130_fd_sc_hd__o41a_4
X_8220_ _8228_/CLK _8220_/D VGND VGND VPWR VPWR _8220_/Q sky130_fd_sc_hd__dfxtp_2
X_5432_ _5318_/B _5430_/X _5431_/X _5315_/X _6706_/S VGND VGND VPWR VPWR _5656_/B
+ sky130_fd_sc_hd__o32a_4
XFILLER_114_621 VGND VGND VPWR VPWR sky130_fd_sc_hd__decap_3
XFILLER_99_310 VGND VGND VPWR VPWR sky130_fd_sc_hd__fill_2
X_8151_ _8285_/CLK _8151_/D VGND VGND VPWR VPWR _8151_/Q sky130_fd_sc_hd__dfxtp_2
X_5363_ _7653_/A VGND VGND VPWR VPWR _5363_/X sky130_fd_sc_hd__buf_1
XFILLER_114_643 VGND VGND VPWR VPWR sky130_fd_sc_hd__fill_1
XFILLER_114_654 VGND VGND VPWR VPWR sky130_fd_sc_hd__decap_3
XFILLER_99_332 VGND VGND VPWR VPWR sky130_fd_sc_hd__decap_3
XFILLER_99_343 VGND VGND VPWR VPWR sky130_fd_sc_hd__fill_2
X_7102_ _8206_/Q _8270_/Q _7102_/C VGND VGND VPWR VPWR _7102_/X sky130_fd_sc_hd__or3_2
X_4314_ _7898_/B _4314_/B VGND VGND VPWR VPWR _4315_/A sky130_fd_sc_hd__and2_2
XFILLER_59_207 VGND VGND VPWR VPWR sky130_fd_sc_hd__decap_3
XFILLER_87_505 VGND VGND VPWR VPWR sky130_fd_sc_hd__decap_3
XFILLER_99_376 VGND VGND VPWR VPWR sky130_fd_sc_hd__decap_3
X_8082_ _8359_/CLK _8082_/D VGND VGND VPWR VPWR _8082_/Q sky130_fd_sc_hd__dfxtp_2
X_5294_ _7783_/A _5292_/X _5293_/Y VGND VGND VPWR VPWR _5294_/X sky130_fd_sc_hd__a21o_2
XFILLER_87_538 VGND VGND VPWR VPWR sky130_fd_sc_hd__decap_3
X_7033_ _5732_/X _6494_/A _7005_/Y _7006_/X _8204_/Q _7044_/B VGND VGND VPWR VPWR
+ _7033_/X sky130_fd_sc_hd__mux4_2
X_4245_ _4245_/A VGND VGND VPWR VPWR _8060_/D sky130_fd_sc_hd__buf_1
XFILLER_67_240 VGND VGND VPWR VPWR sky130_fd_sc_hd__decap_3
XFILLER_83_700 VGND VGND VPWR VPWR sky130_fd_sc_hd__decap_3
X_4176_ _7898_/B input6/X VGND VGND VPWR VPWR _4177_/A sky130_fd_sc_hd__and2_2
XFILLER_28_627 VGND VGND VPWR VPWR sky130_fd_sc_hd__decap_3
XFILLER_55_402 VGND VGND VPWR VPWR sky130_fd_sc_hd__decap_3
XFILLER_95_593 VGND VGND VPWR VPWR sky130_fd_sc_hd__decap_3
XFILLER_27_148 VGND VGND VPWR VPWR sky130_fd_sc_hd__decap_3
XFILLER_82_221 VGND VGND VPWR VPWR sky130_fd_sc_hd__decap_3
XFILLER_35_27 VGND VGND VPWR VPWR sky130_fd_sc_hd__decap_3
XFILLER_35_38 VGND VGND VPWR VPWR sky130_fd_sc_hd__decap_3
XFILLER_36_671 VGND VGND VPWR VPWR sky130_fd_sc_hd__decap_3
XFILLER_42_107 VGND VGND VPWR VPWR sky130_fd_sc_hd__decap_3
XFILLER_70_416 VGND VGND VPWR VPWR sky130_fd_sc_hd__decap_3
X_7935_ _8352_/CLK _7935_/D VGND VGND VPWR VPWR _7935_/Q sky130_fd_sc_hd__dfxtp_2
XFILLER_23_332 VGND VGND VPWR VPWR sky130_fd_sc_hd__decap_3
XFILLER_82_298 VGND VGND VPWR VPWR sky130_fd_sc_hd__decap_3
X_7866_ _8303_/Q _7930_/B VGND VGND VPWR VPWR _7867_/A sky130_fd_sc_hd__and2_2
XFILLER_11_505 VGND VGND VPWR VPWR sky130_fd_sc_hd__fill_1
XFILLER_23_343 VGND VGND VPWR VPWR sky130_fd_sc_hd__decap_3
XFILLER_23_365 VGND VGND VPWR VPWR sky130_fd_sc_hd__decap_3
X_6817_ _6816_/X _6741_/X _6676_/X _6616_/X _7812_/A _7670_/A VGND VGND VPWR VPWR
+ _6817_/X sky130_fd_sc_hd__mux4_2
XFILLER_50_162 VGND VGND VPWR VPWR sky130_fd_sc_hd__decap_3
XFILLER_51_26 VGND VGND VPWR VPWR sky130_fd_sc_hd__fill_1
X_7797_ _7797_/A1 _8198_/Q _5121_/A _7670_/A VGND VGND VPWR VPWR _7797_/Y sky130_fd_sc_hd__a211oi_2
XFILLER_109_415 VGND VGND VPWR VPWR sky130_fd_sc_hd__decap_3
XFILLER_50_195 VGND VGND VPWR VPWR sky130_fd_sc_hd__fill_1
XFILLER_51_48 VGND VGND VPWR VPWR sky130_fd_sc_hd__decap_3
X_6748_ _8196_/Q _5600_/A _5718_/A _8260_/Q VGND VGND VPWR VPWR _6748_/X sky130_fd_sc_hd__a2bb2o_2
XTAP_TAPCELL_ROW_21_533 VGND VPWR sky130_fd_sc_hd__tapvpwrvgnd_1
XFILLER_109_437 VGND VGND VPWR VPWR sky130_fd_sc_hd__decap_3
X_6679_ _6011_/X _6678_/X _5372_/X VGND VGND VPWR VPWR _6679_/X sky130_fd_sc_hd__a21o_2
XFILLER_109_459 VGND VGND VPWR VPWR sky130_fd_sc_hd__decap_3
X_8349_ _8349_/CLK _8349_/D VGND VGND VPWR VPWR _8349_/Q sky130_fd_sc_hd__dfxtp_2
XFILLER_105_632 VGND VGND VPWR VPWR sky130_fd_sc_hd__decap_3
XFILLER_104_153 VGND VGND VPWR VPWR sky130_fd_sc_hd__fill_2
XFILLER_105_676 VGND VGND VPWR VPWR sky130_fd_sc_hd__decap_3
XFILLER_105_687 VGND VGND VPWR VPWR sky130_fd_sc_hd__decap_3
XFILLER_78_505 VGND VGND VPWR VPWR sky130_fd_sc_hd__decap_3
XFILLER_104_197 VGND VGND VPWR VPWR sky130_fd_sc_hd__decap_3
XFILLER_116_63 VGND VGND VPWR VPWR sky130_fd_sc_hd__decap_3
XFILLER_76_12 VGND VGND VPWR VPWR sky130_fd_sc_hd__decap_3
XFILLER_76_56 VGND VGND VPWR VPWR sky130_fd_sc_hd__decap_3
XFILLER_86_560 VGND VGND VPWR VPWR sky130_fd_sc_hd__decap_3
XFILLER_93_508 VGND VGND VPWR VPWR sky130_fd_sc_hd__decap_3
XFILLER_46_402 VGND VGND VPWR VPWR sky130_fd_sc_hd__decap_3
XFILLER_46_424 VGND VGND VPWR VPWR sky130_fd_sc_hd__decap_3
XFILLER_58_262 VGND VGND VPWR VPWR sky130_fd_sc_hd__decap_3
XFILLER_73_210 VGND VGND VPWR VPWR sky130_fd_sc_hd__decap_3
XFILLER_100_392 VGND VGND VPWR VPWR sky130_fd_sc_hd__decap_3
XFILLER_18_126 VGND VGND VPWR VPWR sky130_fd_sc_hd__fill_1
XFILLER_46_457 VGND VGND VPWR VPWR sky130_fd_sc_hd__decap_3
XFILLER_58_295 VGND VGND VPWR VPWR sky130_fd_sc_hd__decap_3
XTAP_TAPCELL_ROW_29_633 VGND VPWR sky130_fd_sc_hd__tapvpwrvgnd_1
XFILLER_27_671 VGND VGND VPWR VPWR sky130_fd_sc_hd__fill_1
XFILLER_61_405 VGND VGND VPWR VPWR sky130_fd_sc_hd__decap_3
XFILLER_73_254 VGND VGND VPWR VPWR sky130_fd_sc_hd__decap_3
XFILLER_73_276 VGND VGND VPWR VPWR sky130_fd_sc_hd__decap_3
XTAP_TAPCELL_ROW_57_997 VGND VPWR sky130_fd_sc_hd__tapvpwrvgnd_1
XFILLER_42_630 VGND VGND VPWR VPWR sky130_fd_sc_hd__decap_3
XFILLER_61_438 VGND VGND VPWR VPWR sky130_fd_sc_hd__decap_3
XFILLER_61_449 VGND VGND VPWR VPWR sky130_fd_sc_hd__decap_3
XFILLER_14_343 VGND VGND VPWR VPWR sky130_fd_sc_hd__decap_3
XFILLER_14_365 VGND VGND VPWR VPWR sky130_fd_sc_hd__decap_3
XFILLER_25_82 VGND VGND VPWR VPWR sky130_fd_sc_hd__decap_3
XFILLER_41_184 VGND VGND VPWR VPWR sky130_fd_sc_hd__decap_3
XFILLER_10_560 VGND VGND VPWR VPWR sky130_fd_sc_hd__decap_3
XFILLER_115_407 VGND VGND VPWR VPWR sky130_fd_sc_hd__decap_3
XFILLER_6_531 VGND VGND VPWR VPWR sky130_fd_sc_hd__fill_1
XFILLER_6_542 VGND VGND VPWR VPWR sky130_fd_sc_hd__decap_3
XFILLER_108_470 VGND VGND VPWR VPWR sky130_fd_sc_hd__decap_3
XFILLER_6_586 VGND VGND VPWR VPWR sky130_fd_sc_hd__fill_2
XTAP_TAPCELL_ROW_75_1240 VGND VPWR sky130_fd_sc_hd__tapvpwrvgnd_1
XFILLER_69_505 VGND VGND VPWR VPWR sky130_fd_sc_hd__decap_3
XFILLER_96_302 VGND VGND VPWR VPWR sky130_fd_sc_hd__decap_3
XFILLER_110_101 VGND VGND VPWR VPWR sky130_fd_sc_hd__decap_3
XFILLER_69_538 VGND VGND VPWR VPWR sky130_fd_sc_hd__decap_3
XTAP_TAPCELL_ROW_9_380 VGND VPWR sky130_fd_sc_hd__tapvpwrvgnd_1
XFILLER_110_156 VGND VGND VPWR VPWR sky130_fd_sc_hd__decap_3
XFILLER_49_251 VGND VGND VPWR VPWR sky130_fd_sc_hd__decap_3
XFILLER_96_357 VGND VGND VPWR VPWR sky130_fd_sc_hd__fill_1
XFILLER_96_368 VGND VGND VPWR VPWR sky130_fd_sc_hd__decap_3
XPHY_EDGE_ROW_10_Right_10 VGND VGND VPWR VPWR sky130_fd_sc_hd__decap_3
X_4030_ _8297_/Q _8296_/Q _8299_/Q _8298_/Q VGND VGND VPWR VPWR _4031_/D sky130_fd_sc_hd__or4_2
XFILLER_37_402 VGND VGND VPWR VPWR sky130_fd_sc_hd__decap_3
XFILLER_37_424 VGND VGND VPWR VPWR sky130_fd_sc_hd__decap_3
XFILLER_49_284 VGND VGND VPWR VPWR sky130_fd_sc_hd__decap_3
XFILLER_77_571 VGND VGND VPWR VPWR sky130_fd_sc_hd__decap_3
XFILLER_2_97 VGND VGND VPWR VPWR sky130_fd_sc_hd__decap_3
XFILLER_64_221 VGND VGND VPWR VPWR sky130_fd_sc_hd__decap_3
XFILLER_64_276 VGND VGND VPWR VPWR sky130_fd_sc_hd__decap_3
XFILLER_92_574 VGND VGND VPWR VPWR sky130_fd_sc_hd__decap_3
X_5981_ _5477_/X _6571_/B _6130_/A _8223_/Q VGND VGND VPWR VPWR _5981_/X sky130_fd_sc_hd__o211a_2
XFILLER_17_181 VGND VGND VPWR VPWR sky130_fd_sc_hd__decap_3
XFILLER_18_693 VGND VGND VPWR VPWR sky130_fd_sc_hd__decap_3
XFILLER_52_427 VGND VGND VPWR VPWR sky130_fd_sc_hd__decap_3
X_7720_ _8211_/Q _7680_/B _7672_/X VGND VGND VPWR VPWR _7721_/B sky130_fd_sc_hd__o21ai_2
Xclkbuf_leaf_44_clk clkload0/A VGND VGND VPWR VPWR _8224_/CLK sky130_fd_sc_hd__clkbuf_8
X_4932_ _6039_/C _4931_/X VGND VGND VPWR VPWR _5965_/A sky130_fd_sc_hd__or2b_2
XTAP_TAPCELL_ROW_86_1380 VGND VPWR sky130_fd_sc_hd__tapvpwrvgnd_1
X_7651_ _8229_/Q _7651_/B VGND VGND VPWR VPWR _7652_/B sky130_fd_sc_hd__xnor2_2
XANTENNA_14 _5615_/A VGND VGND VPWR VPWR sky130_fd_sc_hd__diode_2
XFILLER_20_324 VGND VGND VPWR VPWR sky130_fd_sc_hd__decap_3
X_6602_ _6610_/A _6603_/B VGND VGND VPWR VPWR _6602_/X sky130_fd_sc_hd__and2_2
X_4863_ _8188_/Q _4863_/B VGND VGND VPWR VPWR _6561_/C sky130_fd_sc_hd__nor2_2
XANTENNA_25 _8173_/Q VGND VGND VPWR VPWR sky130_fd_sc_hd__diode_2
XFILLER_119_713 VGND VGND VPWR VPWR sky130_fd_sc_hd__decap_3
XFILLER_20_357 VGND VGND VPWR VPWR sky130_fd_sc_hd__decap_3
X_7582_ _8221_/Q _7582_/B _7583_/C _7583_/D VGND VGND VPWR VPWR _7587_/B sky130_fd_sc_hd__and4_2
X_4794_ _7044_/B _8269_/Q VGND VGND VPWR VPWR _4795_/B sky130_fd_sc_hd__or2_2
XFILLER_20_368 VGND VGND VPWR VPWR sky130_fd_sc_hd__decap_3
X_6533_ _6533_/A _6533_/B VGND VGND VPWR VPWR _6533_/Y sky130_fd_sc_hd__nand2_2
XFILLER_21_29 VGND VGND VPWR VPWR sky130_fd_sc_hd__decap_3
XFILLER_9_391 VGND VGND VPWR VPWR sky130_fd_sc_hd__fill_1
X_6464_ _8188_/Q _8252_/Q VGND VGND VPWR VPWR _6464_/Y sky130_fd_sc_hd__nand2_2
XFILLER_106_407 VGND VGND VPWR VPWR sky130_fd_sc_hd__decap_3
XFILLER_106_418 VGND VGND VPWR VPWR sky130_fd_sc_hd__fill_2
X_8203_ _8207_/CLK _8203_/D VGND VGND VPWR VPWR _8203_/Q sky130_fd_sc_hd__dfxtp_2
X_5415_ _5415_/A _5700_/B VGND VGND VPWR VPWR _7231_/A sky130_fd_sc_hd__or2_2
Xoutput143 _7971_/Q VGND VGND VPWR VPWR result[13] sky130_fd_sc_hd__clkdlybuf4s25_1
X_6395_ _6395_/A _6395_/B VGND VGND VPWR VPWR _6395_/X sky130_fd_sc_hd__or2_4
XFILLER_0_729 VGND VGND VPWR VPWR sky130_fd_sc_hd__decap_3
XFILLER_114_462 VGND VGND VPWR VPWR sky130_fd_sc_hd__decap_3
XFILLER_87_302 VGND VGND VPWR VPWR sky130_fd_sc_hd__fill_1
XFILLER_99_140 VGND VGND VPWR VPWR sky130_fd_sc_hd__decap_3
X_8134_ _8398_/CLK _8134_/D VGND VGND VPWR VPWR _8134_/Q sky130_fd_sc_hd__dfxtp_2
Xoutput176 _8001_/Q VGND VGND VPWR VPWR result[43] sky130_fd_sc_hd__clkdlybuf4s25_1
Xoutput165 _7991_/Q VGND VGND VPWR VPWR result[33] sky130_fd_sc_hd__clkdlybuf4s25_1
Xoutput154 _7981_/Q VGND VGND VPWR VPWR result[23] sky130_fd_sc_hd__clkdlybuf4s25_1
X_5346_ _5346_/A _5491_/C VGND VGND VPWR VPWR _5346_/Y sky130_fd_sc_hd__nand2_2
XFILLER_102_624 VGND VGND VPWR VPWR sky130_fd_sc_hd__decap_3
X_8065_ _8199_/CLK _8065_/D VGND VGND VPWR VPWR _8065_/Q sky130_fd_sc_hd__dfxtp_2
Xoutput198 _8403_/X VGND VGND VPWR VPWR result[63] sky130_fd_sc_hd__clkdlybuf4s25_1
Xoutput187 _8011_/Q VGND VGND VPWR VPWR result[53] sky130_fd_sc_hd__clkdlybuf4s25_1
X_5277_ _6767_/A VGND VGND VPWR VPWR _6086_/A sky130_fd_sc_hd__buf_1
XFILLER_101_156 VGND VGND VPWR VPWR sky130_fd_sc_hd__decap_3
XFILLER_75_508 VGND VGND VPWR VPWR sky130_fd_sc_hd__fill_1
XFILLER_87_368 VGND VGND VPWR VPWR sky130_fd_sc_hd__fill_1
X_7016_ _7017_/A _7017_/B VGND VGND VPWR VPWR _7016_/Y sky130_fd_sc_hd__nand2_2
X_4228_ _7898_/B _4228_/B VGND VGND VPWR VPWR _4229_/A sky130_fd_sc_hd__and2_2
XFILLER_28_424 VGND VGND VPWR VPWR sky130_fd_sc_hd__decap_3
XFILLER_68_560 VGND VGND VPWR VPWR sky130_fd_sc_hd__decap_3
XFILLER_110_690 VGND VGND VPWR VPWR sky130_fd_sc_hd__decap_3
XFILLER_28_446 VGND VGND VPWR VPWR sky130_fd_sc_hd__decap_3
XFILLER_46_26 VGND VGND VPWR VPWR sky130_fd_sc_hd__fill_2
XPHY_EDGE_ROW_106_Right_106 VGND VGND VPWR VPWR sky130_fd_sc_hd__decap_3
X_4159_ _4159_/A VGND VGND VPWR VPWR _8017_/D sky130_fd_sc_hd__buf_1
XFILLER_43_405 VGND VGND VPWR VPWR sky130_fd_sc_hd__decap_3
XTAP_TAPCELL_ROW_26_603 VGND VPWR sky130_fd_sc_hd__tapvpwrvgnd_1
XFILLER_102_32 VGND VGND VPWR VPWR sky130_fd_sc_hd__decap_3
XFILLER_55_287 VGND VGND VPWR VPWR sky130_fd_sc_hd__decap_3
XFILLER_70_224 VGND VGND VPWR VPWR sky130_fd_sc_hd__decap_3
X_7918_ _8329_/Q _7930_/B VGND VGND VPWR VPWR _7919_/A sky130_fd_sc_hd__and2_2
XTAP_TAPCELL_ROW_54_956 VGND VPWR sky130_fd_sc_hd__tapvpwrvgnd_1
XFILLER_24_641 VGND VGND VPWR VPWR sky130_fd_sc_hd__decap_3
XFILLER_70_268 VGND VGND VPWR VPWR sky130_fd_sc_hd__decap_3
Xclkbuf_leaf_35_clk clkbuf_2_2__f_clk/X VGND VGND VPWR VPWR _8380_/CLK sky130_fd_sc_hd__clkbuf_8
XTAP_TAPCELL_ROW_54_967 VGND VPWR sky130_fd_sc_hd__tapvpwrvgnd_1
XFILLER_11_302 VGND VGND VPWR VPWR sky130_fd_sc_hd__decap_3
XFILLER_23_162 VGND VGND VPWR VPWR sky130_fd_sc_hd__decap_3
XFILLER_24_685 VGND VGND VPWR VPWR sky130_fd_sc_hd__decap_3
XFILLER_51_482 VGND VGND VPWR VPWR sky130_fd_sc_hd__decap_3
XFILLER_62_47 VGND VGND VPWR VPWR sky130_fd_sc_hd__decap_3
XFILLER_62_69 VGND VGND VPWR VPWR sky130_fd_sc_hd__decap_3
X_7849_ _7849_/A VGND VGND VPWR VPWR _8361_/D sky130_fd_sc_hd__buf_1
XFILLER_11_335 VGND VGND VPWR VPWR sky130_fd_sc_hd__fill_1
XFILLER_11_357 VGND VGND VPWR VPWR sky130_fd_sc_hd__decap_3
XFILLER_7_306 VGND VGND VPWR VPWR sky130_fd_sc_hd__decap_3
XFILLER_109_223 VGND VGND VPWR VPWR sky130_fd_sc_hd__fill_1
XFILLER_7_317 VGND VGND VPWR VPWR sky130_fd_sc_hd__decap_3
XPHY_EDGE_ROW_12_Left_132 VGND VGND VPWR VPWR sky130_fd_sc_hd__decap_3
XFILLER_109_234 VGND VGND VPWR VPWR sky130_fd_sc_hd__decap_3
XFILLER_109_267 VGND VGND VPWR VPWR sky130_fd_sc_hd__decap_3
XFILLER_109_289 VGND VGND VPWR VPWR sky130_fd_sc_hd__decap_3
XFILLER_11_40 VGND VGND VPWR VPWR sky130_fd_sc_hd__fill_1
XFILLER_3_501 VGND VGND VPWR VPWR sky130_fd_sc_hd__decap_3
XFILLER_105_462 VGND VGND VPWR VPWR sky130_fd_sc_hd__decap_3
XFILLER_78_302 VGND VGND VPWR VPWR sky130_fd_sc_hd__decap_3
XTAP_TAPCELL_ROW_111_1705 VGND VPWR sky130_fd_sc_hd__tapvpwrvgnd_1
XFILLER_3_589 VGND VGND VPWR VPWR sky130_fd_sc_hd__decap_3
XFILLER_78_324 VGND VGND VPWR VPWR sky130_fd_sc_hd__decap_3
XFILLER_78_357 VGND VGND VPWR VPWR sky130_fd_sc_hd__decap_3
XFILLER_78_368 VGND VGND VPWR VPWR sky130_fd_sc_hd__decap_3
XFILLER_87_99 VGND VGND VPWR VPWR sky130_fd_sc_hd__decap_3
XFILLER_19_402 VGND VGND VPWR VPWR sky130_fd_sc_hd__fill_1
XFILLER_59_571 VGND VGND VPWR VPWR sky130_fd_sc_hd__fill_2
XFILLER_93_316 VGND VGND VPWR VPWR sky130_fd_sc_hd__decap_3
XPHY_EDGE_ROW_21_Left_141 VGND VGND VPWR VPWR sky130_fd_sc_hd__decap_3
XTAP_TAPCELL_ROW_70_1170 VGND VPWR sky130_fd_sc_hd__tapvpwrvgnd_1
XFILLER_19_446 VGND VGND VPWR VPWR sky130_fd_sc_hd__fill_2
XFILLER_46_221 VGND VGND VPWR VPWR sky130_fd_sc_hd__decap_3
XFILLER_93_349 VGND VGND VPWR VPWR sky130_fd_sc_hd__decap_3
XFILLER_34_416 VGND VGND VPWR VPWR sky130_fd_sc_hd__decap_3
XFILLER_46_276 VGND VGND VPWR VPWR sky130_fd_sc_hd__decap_3
XFILLER_62_714 VGND VGND VPWR VPWR sky130_fd_sc_hd__fill_2
XFILLER_74_574 VGND VGND VPWR VPWR sky130_fd_sc_hd__decap_3
XTAP_TAPCELL_ROW_109_1678 VGND VPWR sky130_fd_sc_hd__tapvpwrvgnd_1
XFILLER_27_490 VGND VGND VPWR VPWR sky130_fd_sc_hd__fill_1
XFILLER_34_427 VGND VGND VPWR VPWR sky130_fd_sc_hd__decap_3
XFILLER_36_70 VGND VGND VPWR VPWR sky130_fd_sc_hd__fill_2
XFILLER_36_81 VGND VGND VPWR VPWR sky130_fd_sc_hd__decap_3
XFILLER_61_235 VGND VGND VPWR VPWR sky130_fd_sc_hd__decap_3
XFILLER_15_663 VGND VGND VPWR VPWR sky130_fd_sc_hd__decap_3
XFILLER_61_268 VGND VGND VPWR VPWR sky130_fd_sc_hd__decap_3
Xclkbuf_leaf_26_clk clkbuf_2_2__f_clk/X VGND VGND VPWR VPWR _8387_/CLK sky130_fd_sc_hd__clkbuf_8
XFILLER_14_162 VGND VGND VPWR VPWR sky130_fd_sc_hd__decap_3
XFILLER_30_600 VGND VGND VPWR VPWR sky130_fd_sc_hd__decap_3
XFILLER_61_279 VGND VGND VPWR VPWR sky130_fd_sc_hd__fill_1
XPHY_EDGE_ROW_30_Left_150 VGND VGND VPWR VPWR sky130_fd_sc_hd__decap_3
XFILLER_30_666 VGND VGND VPWR VPWR sky130_fd_sc_hd__decap_3
XFILLER_52_91 VGND VGND VPWR VPWR sky130_fd_sc_hd__decap_3
Xinput12 operand_a[15] VGND VGND VPWR VPWR _4206_/B sky130_fd_sc_hd__clkdlybuf4s25_1
Xinput45 operand_a[45] VGND VGND VPWR VPWR _4266_/B sky130_fd_sc_hd__clkdlybuf4s25_1
Xinput34 operand_a[35] VGND VGND VPWR VPWR _4246_/B sky130_fd_sc_hd__clkdlybuf4s25_1
Xinput23 operand_a[25] VGND VGND VPWR VPWR _4226_/B sky130_fd_sc_hd__clkdlybuf4s25_1
XFILLER_6_350 VGND VGND VPWR VPWR sky130_fd_sc_hd__decap_3
Xinput89 operand_b[27] VGND VGND VPWR VPWR _4358_/B sky130_fd_sc_hd__clkdlybuf4s25_1
Xinput78 operand_b[17] VGND VGND VPWR VPWR _4338_/B sky130_fd_sc_hd__clkdlybuf4s25_1
Xinput67 operand_a[7] VGND VGND VPWR VPWR _4190_/B sky130_fd_sc_hd__clkdlybuf4s25_1
Xinput56 operand_a[55] VGND VGND VPWR VPWR _4286_/B sky130_fd_sc_hd__clkdlybuf4s25_1
XFILLER_115_237 VGND VGND VPWR VPWR sky130_fd_sc_hd__decap_3
XFILLER_6_383 VGND VGND VPWR VPWR sky130_fd_sc_hd__decap_3
XFILLER_42_3 VGND VGND VPWR VPWR sky130_fd_sc_hd__decap_3
XFILLER_69_302 VGND VGND VPWR VPWR sky130_fd_sc_hd__decap_3
X_6180_ _6140_/Y _8243_/Q _8179_/Q VGND VGND VPWR VPWR _6180_/X sky130_fd_sc_hd__a21bo_2
X_5200_ _6380_/S _8222_/Q VGND VGND VPWR VPWR _5200_/Y sky130_fd_sc_hd__nand2_2
XFILLER_97_644 VGND VGND VPWR VPWR sky130_fd_sc_hd__decap_3
X_5131_ _5125_/X _5126_/X _7653_/A VGND VGND VPWR VPWR _5131_/X sky130_fd_sc_hd__mux2_2
XFILLER_69_346 VGND VGND VPWR VPWR sky130_fd_sc_hd__decap_3
X_5062_ _8201_/Q _8265_/Q VGND VGND VPWR VPWR _7078_/A sky130_fd_sc_hd__nand2b_2
XTAP_TAPCELL_ROW_4_309 VGND VPWR sky130_fd_sc_hd__tapvpwrvgnd_1
XFILLER_84_327 VGND VGND VPWR VPWR sky130_fd_sc_hd__decap_3
XFILLER_96_165 VGND VGND VPWR VPWR sky130_fd_sc_hd__decap_3
X_4013_ _8355_/Q _8354_/Q VGND VGND VPWR VPWR _4017_/A sky130_fd_sc_hd__or2_2
XFILLER_37_210 VGND VGND VPWR VPWR sky130_fd_sc_hd__decap_3
XFILLER_77_390 VGND VGND VPWR VPWR sky130_fd_sc_hd__fill_2
XFILLER_25_416 VGND VGND VPWR VPWR sky130_fd_sc_hd__decap_3
XFILLER_37_243 VGND VGND VPWR VPWR sky130_fd_sc_hd__decap_3
XFILLER_65_552 VGND VGND VPWR VPWR sky130_fd_sc_hd__decap_3
XFILLER_16_29 VGND VGND VPWR VPWR sky130_fd_sc_hd__fill_2
XFILLER_25_449 VGND VGND VPWR VPWR sky130_fd_sc_hd__decap_3
XFILLER_37_287 VGND VGND VPWR VPWR sky130_fd_sc_hd__decap_3
XFILLER_52_235 VGND VGND VPWR VPWR sky130_fd_sc_hd__decap_3
XFILLER_80_533 VGND VGND VPWR VPWR sky130_fd_sc_hd__decap_3
XFILLER_92_371 VGND VGND VPWR VPWR sky130_fd_sc_hd__decap_3
XFILLER_80_566 VGND VGND VPWR VPWR sky130_fd_sc_hd__decap_3
X_7703_ _7812_/A _8185_/Q _7812_/C VGND VGND VPWR VPWR _7703_/X sky130_fd_sc_hd__and3_2
Xclkbuf_leaf_17_clk clkload2/A VGND VGND VPWR VPWR _8398_/CLK sky130_fd_sc_hd__clkbuf_8
X_5964_ _6589_/B2 _6042_/A1 _5933_/Y _5967_/A VGND VGND VPWR VPWR _5965_/B sky130_fd_sc_hd__o2bb2a_2
XFILLER_33_482 VGND VGND VPWR VPWR sky130_fd_sc_hd__decap_3
X_5895_ _8169_/Q _8170_/Q _8171_/Q _8172_/Q VGND VGND VPWR VPWR _6095_/D sky130_fd_sc_hd__or4_4
X_4915_ _6394_/B _4915_/B VGND VGND VPWR VPWR _6299_/B sky130_fd_sc_hd__and2b_2
XTAP_TAPCELL_ROW_51_926 VGND VPWR sky130_fd_sc_hd__tapvpwrvgnd_1
XFILLER_20_132 VGND VGND VPWR VPWR sky130_fd_sc_hd__decap_3
X_7634_ _8286_/Q _7632_/X _7633_/X _7522_/B _5951_/A VGND VGND VPWR VPWR _7634_/X
+ sky130_fd_sc_hd__a221o_2
X_4846_ _6636_/A VGND VGND VPWR VPWR _6792_/B sky130_fd_sc_hd__inv_2
XFILLER_20_165 VGND VGND VPWR VPWR sky130_fd_sc_hd__decap_3
XFILLER_21_688 VGND VGND VPWR VPWR sky130_fd_sc_hd__decap_3
X_7565_ _7565_/A VGND VGND VPWR VPWR _7565_/Y sky130_fd_sc_hd__inv_2
XTAP_TAPCELL_ROW_31_661 VGND VPWR sky130_fd_sc_hd__tapvpwrvgnd_1
Xrebuffer948 _6481_/X VGND VGND VPWR VPWR rebuffer948/X sky130_fd_sc_hd__buf_6
X_6516_ _8188_/Q _6498_/Y _6515_/X VGND VGND VPWR VPWR _6516_/Y sky130_fd_sc_hd__a21oi_2
X_4777_ _8209_/Q VGND VGND VPWR VPWR _7195_/A sky130_fd_sc_hd__inv_2
XFILLER_106_215 VGND VGND VPWR VPWR sky130_fd_sc_hd__decap_3
XFILLER_113_9 VGND VGND VPWR VPWR sky130_fd_sc_hd__decap_3
XFILLER_119_587 VGND VGND VPWR VPWR sky130_fd_sc_hd__fill_1
XFILLER_4_309 VGND VGND VPWR VPWR sky130_fd_sc_hd__decap_3
X_7496_ _8282_/Q _7463_/B _7495_/X VGND VGND VPWR VPWR _7497_/B sky130_fd_sc_hd__o21a_2
X_6447_ _6430_/X _6437_/X _6446_/X _7930_/B VGND VGND VPWR VPWR _8321_/D sky130_fd_sc_hd__o31a_2
XFILLER_106_259 VGND VGND VPWR VPWR sky130_fd_sc_hd__decap_3
X_6378_ _6494_/A _6433_/C _6378_/S VGND VGND VPWR VPWR _6379_/B sky130_fd_sc_hd__mux2_2
XFILLER_102_410 VGND VGND VPWR VPWR sky130_fd_sc_hd__decap_3
XFILLER_102_421 VGND VGND VPWR VPWR sky130_fd_sc_hd__decap_3
X_8117_ _8387_/CLK _8117_/D VGND VGND VPWR VPWR _8117_/Q sky130_fd_sc_hd__dfxtp_2
X_5329_ _5320_/X _5322_/X _5328_/X VGND VGND VPWR VPWR _5329_/X sky130_fd_sc_hd__a21o_2
XFILLER_0_559 VGND VGND VPWR VPWR sky130_fd_sc_hd__fill_1
XFILLER_48_508 VGND VGND VPWR VPWR sky130_fd_sc_hd__decap_3
XFILLER_88_655 VGND VGND VPWR VPWR sky130_fd_sc_hd__decap_3
XFILLER_102_465 VGND VGND VPWR VPWR sky130_fd_sc_hd__decap_3
XFILLER_57_36 VGND VGND VPWR VPWR sky130_fd_sc_hd__decap_3
XFILLER_75_305 VGND VGND VPWR VPWR sky130_fd_sc_hd__decap_3
XFILLER_88_699 VGND VGND VPWR VPWR sky130_fd_sc_hd__fill_1
X_8048_ _8187_/CLK _8048_/D VGND VGND VPWR VPWR _8048_/Q sky130_fd_sc_hd__dfxtp_2
XFILLER_102_498 VGND VGND VPWR VPWR sky130_fd_sc_hd__decap_3
XFILLER_56_530 VGND VGND VPWR VPWR sky130_fd_sc_hd__fill_2
XFILLER_28_243 VGND VGND VPWR VPWR sky130_fd_sc_hd__decap_3
XFILLER_56_552 VGND VGND VPWR VPWR sky130_fd_sc_hd__decap_3
XFILLER_71_500 VGND VGND VPWR VPWR sky130_fd_sc_hd__decap_3
XTAP_TAPCELL_ROW_39_761 VGND VPWR sky130_fd_sc_hd__tapvpwrvgnd_1
XFILLER_16_427 VGND VGND VPWR VPWR sky130_fd_sc_hd__decap_3
XFILLER_71_511 VGND VGND VPWR VPWR sky130_fd_sc_hd__decap_3
XFILLER_83_393 VGND VGND VPWR VPWR sky130_fd_sc_hd__decap_3
XTAP_TAPCELL_ROW_39_772 VGND VPWR sky130_fd_sc_hd__tapvpwrvgnd_1
XFILLER_43_268 VGND VGND VPWR VPWR sky130_fd_sc_hd__decap_3
XFILLER_73_57 VGND VGND VPWR VPWR sky130_fd_sc_hd__decap_3
XFILLER_12_600 VGND VGND VPWR VPWR sky130_fd_sc_hd__fill_2
XFILLER_51_290 VGND VGND VPWR VPWR sky130_fd_sc_hd__fill_1
XFILLER_11_154 VGND VGND VPWR VPWR sky130_fd_sc_hd__decap_3
XFILLER_8_626 VGND VGND VPWR VPWR sky130_fd_sc_hd__fill_1
XFILLER_12_699 VGND VGND VPWR VPWR sky130_fd_sc_hd__fill_1
XFILLER_7_125 VGND VGND VPWR VPWR sky130_fd_sc_hd__fill_1
XFILLER_8_648 VGND VGND VPWR VPWR sky130_fd_sc_hd__decap_3
XFILLER_22_94 VGND VGND VPWR VPWR sky130_fd_sc_hd__decap_3
XFILLER_7_169 VGND VGND VPWR VPWR sky130_fd_sc_hd__decap_3
XTAP_TAPCELL_ROW_59_1032 VGND VPWR sky130_fd_sc_hd__tapvpwrvgnd_1
XTAP_TAPCELL_ROW_59_1021 VGND VPWR sky130_fd_sc_hd__tapvpwrvgnd_1
XFILLER_98_408 VGND VGND VPWR VPWR sky130_fd_sc_hd__decap_3
XFILLER_112_229 VGND VGND VPWR VPWR sky130_fd_sc_hd__decap_3
XFILLER_79_611 VGND VGND VPWR VPWR sky130_fd_sc_hd__decap_3
XFILLER_105_281 VGND VGND VPWR VPWR sky130_fd_sc_hd__decap_3
XFILLER_39_508 VGND VGND VPWR VPWR sky130_fd_sc_hd__decap_3
XFILLER_94_603 VGND VGND VPWR VPWR sky130_fd_sc_hd__decap_3
XFILLER_39_519 VGND VGND VPWR VPWR sky130_fd_sc_hd__decap_3
XFILLER_66_327 VGND VGND VPWR VPWR sky130_fd_sc_hd__fill_2
XFILLER_78_154 VGND VGND VPWR VPWR sky130_fd_sc_hd__decap_3
XFILLER_79_688 VGND VGND VPWR VPWR sky130_fd_sc_hd__decap_3
XFILLER_93_113 VGND VGND VPWR VPWR sky130_fd_sc_hd__decap_3
XFILLER_94_636 VGND VGND VPWR VPWR sky130_fd_sc_hd__decap_3
XFILLER_19_221 VGND VGND VPWR VPWR sky130_fd_sc_hd__decap_3
XFILLER_66_349 VGND VGND VPWR VPWR sky130_fd_sc_hd__decap_3
XFILLER_19_243 VGND VGND VPWR VPWR sky130_fd_sc_hd__decap_3
XFILLER_19_254 VGND VGND VPWR VPWR sky130_fd_sc_hd__decap_3
XFILLER_74_360 VGND VGND VPWR VPWR sky130_fd_sc_hd__decap_3
XFILLER_81_319 VGND VGND VPWR VPWR sky130_fd_sc_hd__decap_3
XFILLER_19_287 VGND VGND VPWR VPWR sky130_fd_sc_hd__fill_1
XFILLER_19_298 VGND VGND VPWR VPWR sky130_fd_sc_hd__decap_3
XFILLER_47_585 VGND VGND VPWR VPWR sky130_fd_sc_hd__decap_3
XFILLER_62_522 VGND VGND VPWR VPWR sky130_fd_sc_hd__decap_3
XFILLER_74_371 VGND VGND VPWR VPWR sky130_fd_sc_hd__decap_3
XFILLER_34_246 VGND VGND VPWR VPWR sky130_fd_sc_hd__decap_3
XFILLER_62_566 VGND VGND VPWR VPWR sky130_fd_sc_hd__decap_3
XFILLER_15_460 VGND VGND VPWR VPWR sky130_fd_sc_hd__decap_3
XFILLER_22_419 VGND VGND VPWR VPWR sky130_fd_sc_hd__fill_1
XTAP_TAPCELL_ROW_17_477 VGND VPWR sky130_fd_sc_hd__tapvpwrvgnd_1
XFILLER_30_430 VGND VGND VPWR VPWR sky130_fd_sc_hd__fill_2
X_5680_ _5680_/A VGND VGND VPWR VPWR _5680_/Y sky130_fd_sc_hd__inv_2
X_4700_ _7898_/B _8154_/Q VGND VGND VPWR VPWR _4701_/A sky130_fd_sc_hd__and2_2
XFILLER_30_474 VGND VGND VPWR VPWR sky130_fd_sc_hd__fill_2
XFILLER_8_41 VGND VGND VPWR VPWR sky130_fd_sc_hd__fill_1
X_4631_ _4631_/A VGND VGND VPWR VPWR _8253_/D sky130_fd_sc_hd__buf_1
XFILLER_116_502 VGND VGND VPWR VPWR sky130_fd_sc_hd__decap_3
X_7350_ _6817_/X _7349_/X _6531_/X _7060_/X _5182_/A _7745_/A VGND VGND VPWR VPWR
+ _7350_/X sky130_fd_sc_hd__mux4_2
X_4562_ _7898_/B _8085_/Q VGND VGND VPWR VPWR _4563_/A sky130_fd_sc_hd__and2_2
X_7281_ _8210_/Q _8211_/Q _7281_/C VGND VGND VPWR VPWR _7306_/B sky130_fd_sc_hd__or3_4
X_6301_ _6293_/X _6295_/X _6300_/Y _6264_/X VGND VGND VPWR VPWR _6303_/A sky130_fd_sc_hd__a211o_2
X_4493_ _4493_/A VGND VGND VPWR VPWR _8184_/D sky130_fd_sc_hd__buf_1
XFILLER_89_419 VGND VGND VPWR VPWR sky130_fd_sc_hd__decap_3
Xclkbuf_leaf_6_clk clkload1/A VGND VGND VPWR VPWR _8228_/CLK sky130_fd_sc_hd__clkbuf_8
X_6232_ _8181_/Q _6232_/B VGND VGND VPWR VPWR _6232_/X sky130_fd_sc_hd__and2b_2
XFILLER_97_452 VGND VGND VPWR VPWR sky130_fd_sc_hd__decap_3
X_6163_ _8289_/Q _6158_/X _6162_/X _6769_/B VGND VGND VPWR VPWR _6163_/X sky130_fd_sc_hd__o2bb2a_2
XFILLER_111_240 VGND VGND VPWR VPWR sky130_fd_sc_hd__decap_3
XFILLER_57_305 VGND VGND VPWR VPWR sky130_fd_sc_hd__decap_3
XFILLER_57_316 VGND VGND VPWR VPWR sky130_fd_sc_hd__decap_3
XFILLER_69_165 VGND VGND VPWR VPWR sky130_fd_sc_hd__decap_3
XFILLER_85_603 VGND VGND VPWR VPWR sky130_fd_sc_hd__decap_3
XFILLER_85_625 VGND VGND VPWR VPWR sky130_fd_sc_hd__decap_3
XFILLER_97_485 VGND VGND VPWR VPWR sky130_fd_sc_hd__decap_3
X_6094_ _8174_/Q _8175_/Q _8176_/Q _8177_/Q VGND VGND VPWR VPWR _6095_/C sky130_fd_sc_hd__or4_4
X_5114_ _6769_/B _5087_/X _5096_/X _5113_/Y VGND VGND VPWR VPWR _5114_/X sky130_fd_sc_hd__o211a_2
XFILLER_111_284 VGND VGND VPWR VPWR sky130_fd_sc_hd__decap_3
XFILLER_27_17 VGND VGND VPWR VPWR sky130_fd_sc_hd__decap_3
XFILLER_38_530 VGND VGND VPWR VPWR sky130_fd_sc_hd__fill_2
XFILLER_57_349 VGND VGND VPWR VPWR sky130_fd_sc_hd__decap_3
XFILLER_69_187 VGND VGND VPWR VPWR sky130_fd_sc_hd__decap_3
X_5045_ _4917_/B _5040_/X _5044_/X _6400_/C VGND VGND VPWR VPWR _5045_/X sky130_fd_sc_hd__o211a_2
XFILLER_25_202 VGND VGND VPWR VPWR sky130_fd_sc_hd__decap_3
XFILLER_53_511 VGND VGND VPWR VPWR sky130_fd_sc_hd__decap_3
XFILLER_65_393 VGND VGND VPWR VPWR sky130_fd_sc_hd__decap_3
XFILLER_25_257 VGND VGND VPWR VPWR sky130_fd_sc_hd__decap_3
XFILLER_53_555 VGND VGND VPWR VPWR sky130_fd_sc_hd__decap_3
X_6996_ _7017_/A _7027_/B VGND VGND VPWR VPWR _6996_/Y sky130_fd_sc_hd__nor2_2
XTAP_TAPCELL_ROW_36_731 VGND VPWR sky130_fd_sc_hd__tapvpwrvgnd_1
XFILLER_40_216 VGND VGND VPWR VPWR sky130_fd_sc_hd__fill_2
XFILLER_53_588 VGND VGND VPWR VPWR sky130_fd_sc_hd__decap_3
XFILLER_80_363 VGND VGND VPWR VPWR sky130_fd_sc_hd__fill_1
X_5947_ _7613_/B _6022_/C _6825_/A _7610_/B VGND VGND VPWR VPWR _5977_/B sky130_fd_sc_hd__a22oi_2
X_7617_ _7617_/A _8290_/Q _8287_/Q VGND VGND VPWR VPWR _7617_/X sky130_fd_sc_hd__or3b_2
X_5878_ _5805_/X _5841_/Y _5877_/X VGND VGND VPWR VPWR _5879_/B sky130_fd_sc_hd__o21a_2
XFILLER_21_474 VGND VGND VPWR VPWR sky130_fd_sc_hd__decap_3
X_4829_ _8199_/Q _8263_/Q VGND VGND VPWR VPWR _6956_/D sky130_fd_sc_hd__and2b_2
XTAP_TAPCELL_ROW_97_1519 VGND VPWR sky130_fd_sc_hd__tapvpwrvgnd_1
XFILLER_107_502 VGND VGND VPWR VPWR sky130_fd_sc_hd__fill_2
XFILLER_119_340 VGND VGND VPWR VPWR sky130_fd_sc_hd__fill_1
XFILLER_4_106 VGND VGND VPWR VPWR sky130_fd_sc_hd__decap_3
X_7548_ _8285_/Q _5292_/A _5293_/Y VGND VGND VPWR VPWR _7548_/X sky130_fd_sc_hd__a21o_2
Xrebuffer734 _5992_/X VGND VGND VPWR VPWR _5993_/B sky130_fd_sc_hd__buf_2
XFILLER_4_128 VGND VGND VPWR VPWR sky130_fd_sc_hd__decap_3
XFILLER_4_139 VGND VGND VPWR VPWR sky130_fd_sc_hd__fill_1
X_7479_ _7478_/X _7418_/X _7348_/X _7296_/X _7812_/A _7670_/A VGND VGND VPWR VPWR
+ _7479_/X sky130_fd_sc_hd__mux4_2
Xrebuffer789 _5929_/X VGND VGND VPWR VPWR _6042_/A1 sky130_fd_sc_hd__buf_2
XFILLER_0_312 VGND VGND VPWR VPWR sky130_fd_sc_hd__fill_1
XFILLER_0_334 VGND VGND VPWR VPWR sky130_fd_sc_hd__fill_2
XFILLER_0_389 VGND VGND VPWR VPWR sky130_fd_sc_hd__decap_3
XFILLER_75_102 VGND VGND VPWR VPWR sky130_fd_sc_hd__fill_1
XFILLER_76_614 VGND VGND VPWR VPWR sky130_fd_sc_hd__decap_3
XFILLER_102_284 VGND VGND VPWR VPWR sky130_fd_sc_hd__decap_3
XFILLER_84_23 VGND VGND VPWR VPWR sky130_fd_sc_hd__decap_3
XFILLER_29_541 VGND VGND VPWR VPWR sky130_fd_sc_hd__decap_3
XFILLER_16_224 VGND VGND VPWR VPWR sky130_fd_sc_hd__decap_3
XFILLER_56_371 VGND VGND VPWR VPWR sky130_fd_sc_hd__decap_3
XFILLER_71_352 VGND VGND VPWR VPWR sky130_fd_sc_hd__decap_3
XTAP_TAPCELL_ROW_106_1637 VGND VPWR sky130_fd_sc_hd__tapvpwrvgnd_1
XFILLER_31_216 VGND VGND VPWR VPWR sky130_fd_sc_hd__decap_3
XFILLER_71_385 VGND VGND VPWR VPWR sky130_fd_sc_hd__decap_3
XFILLER_12_430 VGND VGND VPWR VPWR sky130_fd_sc_hd__decap_3
XFILLER_24_290 VGND VGND VPWR VPWR sky130_fd_sc_hd__decap_3
XFILLER_31_249 VGND VGND VPWR VPWR sky130_fd_sc_hd__fill_1
XFILLER_71_396 VGND VGND VPWR VPWR sky130_fd_sc_hd__decap_3
XTAP_TAPCELL_ROW_14_436 VGND VPWR sky130_fd_sc_hd__tapvpwrvgnd_1
XTAP_TAPCELL_ROW_14_447 VGND VPWR sky130_fd_sc_hd__tapvpwrvgnd_1
XFILLER_12_463 VGND VGND VPWR VPWR sky130_fd_sc_hd__decap_3
XFILLER_8_412 VGND VGND VPWR VPWR sky130_fd_sc_hd__decap_3
XFILLER_33_82 VGND VGND VPWR VPWR sky130_fd_sc_hd__fill_1
XFILLER_76_9 VGND VGND VPWR VPWR sky130_fd_sc_hd__decap_3
XFILLER_8_445 VGND VGND VPWR VPWR sky130_fd_sc_hd__decap_3
XFILLER_8_456 VGND VGND VPWR VPWR sky130_fd_sc_hd__decap_3
XFILLER_8_489 VGND VGND VPWR VPWR sky130_fd_sc_hd__decap_3
XFILLER_113_505 VGND VGND VPWR VPWR sky130_fd_sc_hd__decap_3
XFILLER_4_651 VGND VGND VPWR VPWR sky130_fd_sc_hd__decap_3
XFILLER_99_706 VGND VGND VPWR VPWR sky130_fd_sc_hd__decap_3
XTAP_TAPCELL_ROW_117_1777 VGND VPWR sky130_fd_sc_hd__tapvpwrvgnd_1
XFILLER_4_684 VGND VGND VPWR VPWR sky130_fd_sc_hd__decap_3
XFILLER_79_452 VGND VGND VPWR VPWR sky130_fd_sc_hd__decap_3
XFILLER_39_305 VGND VGND VPWR VPWR sky130_fd_sc_hd__decap_3
XFILLER_79_474 VGND VGND VPWR VPWR sky130_fd_sc_hd__decap_3
XFILLER_39_327 VGND VGND VPWR VPWR sky130_fd_sc_hd__decap_3
XFILLER_94_433 VGND VGND VPWR VPWR sky130_fd_sc_hd__decap_3
XFILLER_66_146 VGND VGND VPWR VPWR sky130_fd_sc_hd__decap_3
XFILLER_82_606 VGND VGND VPWR VPWR sky130_fd_sc_hd__decap_3
XFILLER_94_477 VGND VGND VPWR VPWR sky130_fd_sc_hd__decap_3
XFILLER_35_511 VGND VGND VPWR VPWR sky130_fd_sc_hd__fill_1
XFILLER_47_360 VGND VGND VPWR VPWR sky130_fd_sc_hd__decap_3
XFILLER_81_116 VGND VGND VPWR VPWR sky130_fd_sc_hd__decap_3
XFILLER_35_533 VGND VGND VPWR VPWR sky130_fd_sc_hd__decap_3
XFILLER_35_555 VGND VGND VPWR VPWR sky130_fd_sc_hd__decap_3
XFILLER_47_393 VGND VGND VPWR VPWR sky130_fd_sc_hd__decap_3
XFILLER_62_330 VGND VGND VPWR VPWR sky130_fd_sc_hd__decap_3
X_6850_ _4834_/B _6815_/B _8198_/Q VGND VGND VPWR VPWR _6850_/X sky130_fd_sc_hd__o21a_2
XFILLER_22_216 VGND VGND VPWR VPWR sky130_fd_sc_hd__decap_3
XFILLER_35_588 VGND VGND VPWR VPWR sky130_fd_sc_hd__decap_3
XFILLER_50_514 VGND VGND VPWR VPWR sky130_fd_sc_hd__fill_2
XFILLER_50_525 VGND VGND VPWR VPWR sky130_fd_sc_hd__decap_3
XFILLER_62_385 VGND VGND VPWR VPWR sky130_fd_sc_hd__decap_3
XFILLER_90_683 VGND VGND VPWR VPWR sky130_fd_sc_hd__fill_1
XPHY_EDGE_ROW_8_Right_8 VGND VGND VPWR VPWR sky130_fd_sc_hd__decap_3
X_6781_ _8197_/Q _8196_/Q _8195_/Q _8194_/Q _7796_/A _7812_/A VGND VGND VPWR VPWR
+ _6781_/X sky130_fd_sc_hd__mux4_2
X_5801_ _5867_/B _5801_/B VGND VGND VPWR VPWR _5801_/Y sky130_fd_sc_hd__xnor2_2
XTAP_TAPCELL_ROW_81_1309 VGND VPWR sky130_fd_sc_hd__tapvpwrvgnd_1
XFILLER_50_536 VGND VGND VPWR VPWR sky130_fd_sc_hd__decap_3
XFILLER_50_558 VGND VGND VPWR VPWR sky130_fd_sc_hd__decap_3
X_5732_ _6368_/B VGND VGND VPWR VPWR _5732_/X sky130_fd_sc_hd__buf_1
X_3993_ _3993_/A VGND VGND VPWR VPWR _7945_/D sky130_fd_sc_hd__buf_1
XFILLER_15_290 VGND VGND VPWR VPWR sky130_fd_sc_hd__decap_3
XFILLER_30_271 VGND VGND VPWR VPWR sky130_fd_sc_hd__decap_3
XFILLER_30_282 VGND VGND VPWR VPWR sky130_fd_sc_hd__decap_3
X_5663_ _8230_/Q _5561_/A _5561_/B _8166_/Q VGND VGND VPWR VPWR _5663_/X sky130_fd_sc_hd__a31o_2
X_7402_ _8215_/Q _8279_/Q _7401_/X VGND VGND VPWR VPWR _7402_/X sky130_fd_sc_hd__o21a_2
X_8382_ _8382_/CLK _8382_/D VGND VGND VPWR VPWR _8382_/Q sky130_fd_sc_hd__dfxtp_2
X_5594_ _8166_/Q _8165_/Q _5678_/S VGND VGND VPWR VPWR _5594_/X sky130_fd_sc_hd__mux2_2
X_4614_ _7898_/B _8111_/Q VGND VGND VPWR VPWR _4615_/A sky130_fd_sc_hd__and2_2
XFILLER_116_321 VGND VGND VPWR VPWR sky130_fd_sc_hd__fill_2
X_7333_ _7182_/B _7319_/Y _7332_/X VGND VGND VPWR VPWR _7333_/X sky130_fd_sc_hd__a21o_2
X_4545_ _4545_/A VGND VGND VPWR VPWR _8210_/D sky130_fd_sc_hd__buf_1
XFILLER_116_354 VGND VGND VPWR VPWR sky130_fd_sc_hd__decap_3
XFILLER_116_365 VGND VGND VPWR VPWR sky130_fd_sc_hd__decap_3
XFILLER_89_205 VGND VGND VPWR VPWR sky130_fd_sc_hd__decap_3
X_7264_ _7264_/A _7283_/A VGND VGND VPWR VPWR _7264_/Y sky130_fd_sc_hd__nor2_2
X_4476_ _7898_/B _8042_/Q VGND VGND VPWR VPWR _4477_/A sky130_fd_sc_hd__and2_2
XTAP_TAPCELL_ROW_92_1449 VGND VPWR sky130_fd_sc_hd__tapvpwrvgnd_1
XPHY_EDGE_ROW_39_Right_39 VGND VGND VPWR VPWR sky130_fd_sc_hd__decap_3
X_7195_ _7195_/A _7195_/B VGND VGND VPWR VPWR _7195_/Y sky130_fd_sc_hd__nor2_2
X_6215_ _6198_/X _6208_/X _6214_/X _7898_/B VGND VGND VPWR VPWR _8315_/D sky130_fd_sc_hd__o31a_2
XFILLER_112_560 VGND VGND VPWR VPWR sky130_fd_sc_hd__decap_3
XFILLER_57_102 VGND VGND VPWR VPWR sky130_fd_sc_hd__fill_2
X_6146_ _6126_/X _6136_/Y _6145_/X _7898_/B VGND VGND VPWR VPWR _8313_/D sky130_fd_sc_hd__o31a_2
XFILLER_38_38 VGND VGND VPWR VPWR sky130_fd_sc_hd__decap_3
XFILLER_57_113 VGND VGND VPWR VPWR sky130_fd_sc_hd__decap_3
XFILLER_45_308 VGND VGND VPWR VPWR sky130_fd_sc_hd__fill_1
XFILLER_57_157 VGND VGND VPWR VPWR sky130_fd_sc_hd__decap_3
XFILLER_73_606 VGND VGND VPWR VPWR sky130_fd_sc_hd__decap_3
XFILLER_85_455 VGND VGND VPWR VPWR sky130_fd_sc_hd__decap_3
XFILLER_85_466 VGND VGND VPWR VPWR sky130_fd_sc_hd__fill_1
X_6077_ _8241_/Q _6077_/B VGND VGND VPWR VPWR _6079_/A sky130_fd_sc_hd__or2_4
XFILLER_38_360 VGND VGND VPWR VPWR sky130_fd_sc_hd__decap_3
XFILLER_38_371 VGND VGND VPWR VPWR sky130_fd_sc_hd__decap_3
XFILLER_66_680 VGND VGND VPWR VPWR sky130_fd_sc_hd__decap_3
XFILLER_72_127 VGND VGND VPWR VPWR sky130_fd_sc_hd__decap_3
XFILLER_73_639 VGND VGND VPWR VPWR sky130_fd_sc_hd__decap_3
X_5028_ _5886_/B _5027_/Y _4939_/B VGND VGND VPWR VPWR _5028_/Y sky130_fd_sc_hd__a21oi_2
XFILLER_26_533 VGND VGND VPWR VPWR sky130_fd_sc_hd__decap_3
XFILLER_26_555 VGND VGND VPWR VPWR sky130_fd_sc_hd__decap_3
XFILLER_54_15 VGND VGND VPWR VPWR sky130_fd_sc_hd__decap_3
XFILLER_65_190 VGND VGND VPWR VPWR sky130_fd_sc_hd__decap_3
XFILLER_26_577 VGND VGND VPWR VPWR sky130_fd_sc_hd__decap_3
XFILLER_26_599 VGND VGND VPWR VPWR sky130_fd_sc_hd__decap_3
XFILLER_41_514 VGND VGND VPWR VPWR sky130_fd_sc_hd__decap_3
XFILLER_53_363 VGND VGND VPWR VPWR sky130_fd_sc_hd__decap_3
XFILLER_54_59 VGND VGND VPWR VPWR sky130_fd_sc_hd__decap_3
XFILLER_53_396 VGND VGND VPWR VPWR sky130_fd_sc_hd__fill_1
XPHY_EDGE_ROW_48_Right_48 VGND VGND VPWR VPWR sky130_fd_sc_hd__decap_3
X_6979_ _6420_/X _6978_/X _6128_/X _6706_/X _5462_/X _6353_/B VGND VGND VPWR VPWR
+ _6979_/X sky130_fd_sc_hd__mux4_2
XFILLER_110_65 VGND VGND VPWR VPWR sky130_fd_sc_hd__decap_3
XFILLER_70_14 VGND VGND VPWR VPWR sky130_fd_sc_hd__decap_3
XFILLER_110_98 VGND VGND VPWR VPWR sky130_fd_sc_hd__decap_3
XFILLER_70_47 VGND VGND VPWR VPWR sky130_fd_sc_hd__decap_3
XTAP_TAPCELL_ROW_101_1567 VGND VPWR sky130_fd_sc_hd__tapvpwrvgnd_1
XTAP_TAPCELL_ROW_101_1578 VGND VPWR sky130_fd_sc_hd__tapvpwrvgnd_1
XTAP_TAPCELL_ROW_11_406 VGND VPWR sky130_fd_sc_hd__tapvpwrvgnd_1
XFILLER_21_293 VGND VGND VPWR VPWR sky130_fd_sc_hd__decap_3
XFILLER_107_321 VGND VGND VPWR VPWR sky130_fd_sc_hd__decap_3
XFILLER_119_41 VGND VGND VPWR VPWR sky130_fd_sc_hd__decap_3
XFILLER_119_63 VGND VGND VPWR VPWR sky130_fd_sc_hd__fill_2
XFILLER_119_85 VGND VGND VPWR VPWR sky130_fd_sc_hd__decap_3
XFILLER_107_387 VGND VGND VPWR VPWR sky130_fd_sc_hd__decap_3
XPHY_EDGE_ROW_57_Right_57 VGND VGND VPWR VPWR sky130_fd_sc_hd__decap_3
XFILLER_1_676 VGND VGND VPWR VPWR sky130_fd_sc_hd__fill_1
XFILLER_95_11 VGND VGND VPWR VPWR sky130_fd_sc_hd__fill_1
XFILLER_95_219 VGND VGND VPWR VPWR sky130_fd_sc_hd__decap_3
XFILLER_0_197 VGND VGND VPWR VPWR sky130_fd_sc_hd__fill_1
XFILLER_48_135 VGND VGND VPWR VPWR sky130_fd_sc_hd__decap_3
XFILLER_49_658 VGND VGND VPWR VPWR sky130_fd_sc_hd__decap_3
XFILLER_76_433 VGND VGND VPWR VPWR sky130_fd_sc_hd__decap_3
XFILLER_88_271 VGND VGND VPWR VPWR sky130_fd_sc_hd__decap_3
XFILLER_88_293 VGND VGND VPWR VPWR sky130_fd_sc_hd__decap_3
XFILLER_95_33 VGND VGND VPWR VPWR sky130_fd_sc_hd__decap_3
XFILLER_48_157 VGND VGND VPWR VPWR sky130_fd_sc_hd__decap_3
XFILLER_76_477 VGND VGND VPWR VPWR sky130_fd_sc_hd__decap_3
XFILLER_95_99 VGND VGND VPWR VPWR sky130_fd_sc_hd__decap_3
XFILLER_17_522 VGND VGND VPWR VPWR sky130_fd_sc_hd__fill_2
XFILLER_28_71 VGND VGND VPWR VPWR sky130_fd_sc_hd__decap_3
XFILLER_63_116 VGND VGND VPWR VPWR sky130_fd_sc_hd__decap_3
XFILLER_64_639 VGND VGND VPWR VPWR sky130_fd_sc_hd__decap_3
XFILLER_91_414 VGND VGND VPWR VPWR sky130_fd_sc_hd__decap_3
XFILLER_91_436 VGND VGND VPWR VPWR sky130_fd_sc_hd__decap_3
XTAP_TAPCELL_ROW_19_506 VGND VPWR sky130_fd_sc_hd__tapvpwrvgnd_1
XFILLER_17_544 VGND VGND VPWR VPWR sky130_fd_sc_hd__fill_1
XFILLER_29_393 VGND VGND VPWR VPWR sky130_fd_sc_hd__decap_3
XFILLER_63_149 VGND VGND VPWR VPWR sky130_fd_sc_hd__decap_3
XFILLER_72_650 VGND VGND VPWR VPWR sky130_fd_sc_hd__decap_3
XFILLER_91_458 VGND VGND VPWR VPWR sky130_fd_sc_hd__decap_3
XTAP_TAPCELL_ROW_67_1131 VGND VPWR sky130_fd_sc_hd__tapvpwrvgnd_1
XFILLER_44_374 VGND VGND VPWR VPWR sky130_fd_sc_hd__decap_3
XFILLER_72_683 VGND VGND VPWR VPWR sky130_fd_sc_hd__decap_3
XPHY_EDGE_ROW_66_Right_66 VGND VGND VPWR VPWR sky130_fd_sc_hd__decap_3
XFILLER_32_558 VGND VGND VPWR VPWR sky130_fd_sc_hd__fill_2
XFILLER_72_694 VGND VGND VPWR VPWR sky130_fd_sc_hd__fill_1
XPHY_EDGE_ROW_4_Left_124 VGND VGND VPWR VPWR sky130_fd_sc_hd__decap_3
XFILLER_12_271 VGND VGND VPWR VPWR sky130_fd_sc_hd__fill_1
XFILLER_9_732 VGND VGND VPWR VPWR sky130_fd_sc_hd__fill_1
XTAP_TAPCELL_ROW_119_1806 VGND VPWR sky130_fd_sc_hd__tapvpwrvgnd_1
XTAP_TAPCELL_ROW_119_1817 VGND VPWR sky130_fd_sc_hd__tapvpwrvgnd_1
XFILLER_12_293 VGND VGND VPWR VPWR sky130_fd_sc_hd__decap_3
XFILLER_8_253 VGND VGND VPWR VPWR sky130_fd_sc_hd__decap_3
XFILLER_60_80 VGND VGND VPWR VPWR sky130_fd_sc_hd__decap_3
XFILLER_60_91 VGND VGND VPWR VPWR sky130_fd_sc_hd__decap_3
XFILLER_8_275 VGND VGND VPWR VPWR sky130_fd_sc_hd__decap_3
XFILLER_99_503 VGND VGND VPWR VPWR sky130_fd_sc_hd__fill_1
XPHY_EDGE_ROW_75_Right_75 VGND VGND VPWR VPWR sky130_fd_sc_hd__decap_3
XTAP_TAPCELL_ROW_78_1271 VGND VPWR sky130_fd_sc_hd__tapvpwrvgnd_1
XFILLER_99_514 VGND VGND VPWR VPWR sky130_fd_sc_hd__decap_3
X_4330_ _7898_/B _4330_/B VGND VGND VPWR VPWR _4331_/A sky130_fd_sc_hd__and2_2
XFILLER_113_324 VGND VGND VPWR VPWR sky130_fd_sc_hd__fill_2
XFILLER_113_346 VGND VGND VPWR VPWR sky130_fd_sc_hd__decap_3
XFILLER_99_558 VGND VGND VPWR VPWR sky130_fd_sc_hd__fill_2
X_4261_ _4261_/A VGND VGND VPWR VPWR _8068_/D sky130_fd_sc_hd__buf_1
XFILLER_101_508 VGND VGND VPWR VPWR sky130_fd_sc_hd__decap_3
X_6000_ _6007_/A VGND VGND VPWR VPWR _6003_/A sky130_fd_sc_hd__inv_2
XFILLER_39_102 VGND VGND VPWR VPWR sky130_fd_sc_hd__decap_3
XFILLER_39_113 VGND VGND VPWR VPWR sky130_fd_sc_hd__decap_3
XFILLER_67_411 VGND VGND VPWR VPWR sky130_fd_sc_hd__decap_3
XFILLER_79_271 VGND VGND VPWR VPWR sky130_fd_sc_hd__fill_2
XFILLER_79_293 VGND VGND VPWR VPWR sky130_fd_sc_hd__decap_3
X_4192_ _7898_/B _4192_/B VGND VGND VPWR VPWR _4193_/A sky130_fd_sc_hd__and2_2
XFILLER_27_308 VGND VGND VPWR VPWR sky130_fd_sc_hd__decap_3
XFILLER_67_444 VGND VGND VPWR VPWR sky130_fd_sc_hd__decap_3
XFILLER_67_455 VGND VGND VPWR VPWR sky130_fd_sc_hd__decap_3
XFILLER_94_241 VGND VGND VPWR VPWR sky130_fd_sc_hd__decap_3
XFILLER_54_127 VGND VGND VPWR VPWR sky130_fd_sc_hd__decap_3
XFILLER_82_436 VGND VGND VPWR VPWR sky130_fd_sc_hd__decap_3
XFILLER_94_274 VGND VGND VPWR VPWR sky130_fd_sc_hd__decap_3
XPHY_EDGE_ROW_84_Right_84 VGND VGND VPWR VPWR sky130_fd_sc_hd__decap_3
X_7951_ _8355_/CLK _7951_/D VGND VGND VPWR VPWR _7951_/Q sky130_fd_sc_hd__dfxtp_2
X_7882_ _8311_/Q _7898_/B VGND VGND VPWR VPWR _7883_/A sky130_fd_sc_hd__and2_2
X_6902_ _6944_/A _6926_/B _6975_/D _5732_/X VGND VGND VPWR VPWR _6902_/X sky130_fd_sc_hd__a2bb2o_2
XFILLER_35_352 VGND VGND VPWR VPWR sky130_fd_sc_hd__decap_3
X_6833_ _8262_/Q _5337_/A _5093_/X VGND VGND VPWR VPWR _6833_/Y sky130_fd_sc_hd__o21ai_2
XFILLER_23_536 VGND VGND VPWR VPWR sky130_fd_sc_hd__fill_2
XFILLER_35_396 VGND VGND VPWR VPWR sky130_fd_sc_hd__decap_3
XFILLER_50_333 VGND VGND VPWR VPWR sky130_fd_sc_hd__decap_3
XFILLER_62_182 VGND VGND VPWR VPWR sky130_fd_sc_hd__decap_3
XFILLER_90_480 VGND VGND VPWR VPWR sky130_fd_sc_hd__decap_3
XPHY_EDGE_ROW_59_Left_179 VGND VGND VPWR VPWR sky130_fd_sc_hd__decap_3
X_6764_ _6764_/A VGND VGND VPWR VPWR _7551_/B sky130_fd_sc_hd__buf_1
X_3976_ _8341_/Q _7930_/B VGND VGND VPWR VPWR _3977_/A sky130_fd_sc_hd__and2_2
XFILLER_10_219 VGND VGND VPWR VPWR sky130_fd_sc_hd__decap_3
X_6695_ _6731_/A _6695_/B VGND VGND VPWR VPWR _6695_/X sky130_fd_sc_hd__or2_4
X_5715_ _5867_/A _5715_/B VGND VGND VPWR VPWR _5715_/Y sky130_fd_sc_hd__nand2_2
XFILLER_40_17 VGND VGND VPWR VPWR sky130_fd_sc_hd__decap_3
X_5646_ _5452_/X _5443_/X _7555_/S VGND VGND VPWR VPWR _5646_/X sky130_fd_sc_hd__mux2_2
XFILLER_40_39 VGND VGND VPWR VPWR sky130_fd_sc_hd__decap_3
XPHY_EDGE_ROW_93_Right_93 VGND VGND VPWR VPWR sky130_fd_sc_hd__decap_3
X_8365_ _8365_/CLK _8365_/D VGND VGND VPWR VPWR _8365_/Q sky130_fd_sc_hd__dfxtp_2
X_5577_ _6353_/B _5574_/Y _5576_/X VGND VGND VPWR VPWR _6248_/A sky130_fd_sc_hd__a21o_2
XFILLER_2_418 VGND VGND VPWR VPWR sky130_fd_sc_hd__fill_2
X_8296_ _8322_/CLK _8296_/D VGND VGND VPWR VPWR _8296_/Q sky130_fd_sc_hd__dfxtp_2
X_7316_ _5714_/A _7312_/Y _7338_/B _5966_/A _7398_/A VGND VGND VPWR VPWR _7316_/Y
+ sky130_fd_sc_hd__o221ai_2
X_4528_ _7843_/A _8068_/Q VGND VGND VPWR VPWR _4529_/A sky130_fd_sc_hd__and2_2
XFILLER_116_184 VGND VGND VPWR VPWR sky130_fd_sc_hd__fill_2
XFILLER_116_195 VGND VGND VPWR VPWR sky130_fd_sc_hd__fill_1
XPHY_EDGE_ROW_68_Left_188 VGND VGND VPWR VPWR sky130_fd_sc_hd__decap_3
X_7247_ _7209_/A _7226_/X _7233_/X _7246_/X VGND VGND VPWR VPWR _7247_/X sky130_fd_sc_hd__a211o_2
X_4459_ _4459_/A VGND VGND VPWR VPWR _8167_/D sky130_fd_sc_hd__buf_1
XFILLER_104_368 VGND VGND VPWR VPWR sky130_fd_sc_hd__decap_3
XFILLER_58_433 VGND VGND VPWR VPWR sky130_fd_sc_hd__decap_3
X_7178_ _7171_/X _7172_/X _7167_/X _6879_/X _7177_/X VGND VGND VPWR VPWR _7178_/X
+ sky130_fd_sc_hd__a221o_2
XFILLER_100_541 VGND VGND VPWR VPWR sky130_fd_sc_hd__decap_3
XFILLER_100_552 VGND VGND VPWR VPWR sky130_fd_sc_hd__fill_1
XFILLER_105_43 VGND VGND VPWR VPWR sky130_fd_sc_hd__decap_3
XFILLER_105_54 VGND VGND VPWR VPWR sky130_fd_sc_hd__fill_2
XFILLER_46_606 VGND VGND VPWR VPWR sky130_fd_sc_hd__decap_3
XFILLER_58_466 VGND VGND VPWR VPWR sky130_fd_sc_hd__decap_3
XFILLER_85_252 VGND VGND VPWR VPWR sky130_fd_sc_hd__decap_3
X_6129_ _6128_/X _5830_/A _6707_/S VGND VGND VPWR VPWR _6708_/B sky130_fd_sc_hd__mux2_2
XFILLER_100_585 VGND VGND VPWR VPWR sky130_fd_sc_hd__decap_3
XFILLER_45_116 VGND VGND VPWR VPWR sky130_fd_sc_hd__decap_3
XFILLER_58_477 VGND VGND VPWR VPWR sky130_fd_sc_hd__decap_3
XFILLER_65_47 VGND VGND VPWR VPWR sky130_fd_sc_hd__decap_3
XFILLER_73_403 VGND VGND VPWR VPWR sky130_fd_sc_hd__decap_3
XFILLER_73_436 VGND VGND VPWR VPWR sky130_fd_sc_hd__fill_2
XFILLER_85_263 VGND VGND VPWR VPWR sky130_fd_sc_hd__decap_3
XFILLER_38_190 VGND VGND VPWR VPWR sky130_fd_sc_hd__decap_3
XFILLER_39_691 VGND VGND VPWR VPWR sky130_fd_sc_hd__decap_3
XFILLER_65_69 VGND VGND VPWR VPWR sky130_fd_sc_hd__decap_3
XFILLER_73_447 VGND VGND VPWR VPWR sky130_fd_sc_hd__fill_1
XFILLER_73_458 VGND VGND VPWR VPWR sky130_fd_sc_hd__decap_3
XFILLER_60_119 VGND VGND VPWR VPWR sky130_fd_sc_hd__decap_3
XPHY_EDGE_ROW_77_Left_197 VGND VGND VPWR VPWR sky130_fd_sc_hd__decap_3
XTAP_TAPCELL_ROW_44_829 VGND VPWR sky130_fd_sc_hd__tapvpwrvgnd_1
XFILLER_14_536 VGND VGND VPWR VPWR sky130_fd_sc_hd__decap_3
XFILLER_41_322 VGND VGND VPWR VPWR sky130_fd_sc_hd__decap_3
XFILLER_41_333 VGND VGND VPWR VPWR sky130_fd_sc_hd__decap_3
XFILLER_53_160 VGND VGND VPWR VPWR sky130_fd_sc_hd__decap_3
XFILLER_81_46 VGND VGND VPWR VPWR sky130_fd_sc_hd__fill_1
XFILLER_81_57 VGND VGND VPWR VPWR sky130_fd_sc_hd__decap_3
XFILLER_22_580 VGND VGND VPWR VPWR sky130_fd_sc_hd__fill_1
XFILLER_41_377 VGND VGND VPWR VPWR sky130_fd_sc_hd__decap_3
XTAP_TAPCELL_ROW_62_1061 VGND VPWR sky130_fd_sc_hd__tapvpwrvgnd_1
XTAP_TAPCELL_ROW_24_575 VGND VPWR sky130_fd_sc_hd__tapvpwrvgnd_1
XFILLER_5_212 VGND VGND VPWR VPWR sky130_fd_sc_hd__decap_3
XFILLER_6_724 VGND VGND VPWR VPWR sky130_fd_sc_hd__decap_3
XFILLER_108_641 VGND VGND VPWR VPWR sky130_fd_sc_hd__decap_3
XFILLER_108_663 VGND VGND VPWR VPWR sky130_fd_sc_hd__decap_3
XFILLER_5_245 VGND VGND VPWR VPWR sky130_fd_sc_hd__fill_1
XFILLER_108_696 VGND VGND VPWR VPWR sky130_fd_sc_hd__decap_3
XFILLER_5_278 VGND VGND VPWR VPWR sky130_fd_sc_hd__fill_2
XTAP_TAPCELL_ROW_114_1736 VGND VPWR sky130_fd_sc_hd__tapvpwrvgnd_1
XTAP_TAPCELL_ROW_114_1747 VGND VPWR sky130_fd_sc_hd__tapvpwrvgnd_1
XFILLER_107_184 VGND VGND VPWR VPWR sky130_fd_sc_hd__decap_3
XFILLER_96_506 VGND VGND VPWR VPWR sky130_fd_sc_hd__decap_3
XFILLER_96_539 VGND VGND VPWR VPWR sky130_fd_sc_hd__decap_3
XFILLER_49_444 VGND VGND VPWR VPWR sky130_fd_sc_hd__decap_3
XFILLER_49_455 VGND VGND VPWR VPWR sky130_fd_sc_hd__decap_3
XFILLER_76_230 VGND VGND VPWR VPWR sky130_fd_sc_hd__decap_3
XFILLER_92_701 VGND VGND VPWR VPWR sky130_fd_sc_hd__fill_2
XFILLER_36_105 VGND VGND VPWR VPWR sky130_fd_sc_hd__decap_3
XFILLER_64_414 VGND VGND VPWR VPWR sky130_fd_sc_hd__decap_3
XFILLER_91_211 VGND VGND VPWR VPWR sky130_fd_sc_hd__decap_3
XFILLER_92_712 VGND VGND VPWR VPWR sky130_fd_sc_hd__decap_3
XFILLER_76_296 VGND VGND VPWR VPWR sky130_fd_sc_hd__decap_3
XFILLER_17_352 VGND VGND VPWR VPWR sky130_fd_sc_hd__decap_3
XFILLER_51_119 VGND VGND VPWR VPWR sky130_fd_sc_hd__decap_3
XFILLER_91_266 VGND VGND VPWR VPWR sky130_fd_sc_hd__fill_1
XFILLER_91_277 VGND VGND VPWR VPWR sky130_fd_sc_hd__decap_3
XFILLER_17_396 VGND VGND VPWR VPWR sky130_fd_sc_hd__fill_1
XFILLER_45_683 VGND VGND VPWR VPWR sky130_fd_sc_hd__decap_3
XFILLER_55_91 VGND VGND VPWR VPWR sky130_fd_sc_hd__decap_3
XFILLER_72_480 VGND VGND VPWR VPWR sky130_fd_sc_hd__decap_3
XFILLER_32_355 VGND VGND VPWR VPWR sky130_fd_sc_hd__decap_3
XFILLER_44_193 VGND VGND VPWR VPWR sky130_fd_sc_hd__decap_3
XFILLER_20_528 VGND VGND VPWR VPWR sky130_fd_sc_hd__decap_3
XFILLER_32_399 VGND VGND VPWR VPWR sky130_fd_sc_hd__decap_3
X_5500_ _6769_/B _5499_/X _5296_/X _7825_/A VGND VGND VPWR VPWR _5500_/X sky130_fd_sc_hd__a2bb2o_2
XFILLER_118_449 VGND VGND VPWR VPWR sky130_fd_sc_hd__fill_1
XFILLER_72_3 VGND VGND VPWR VPWR sky130_fd_sc_hd__decap_3
XFILLER_9_595 VGND VGND VPWR VPWR sky130_fd_sc_hd__fill_1
X_6480_ _4863_/B _4876_/B _8188_/Q VGND VGND VPWR VPWR _6480_/Y sky130_fd_sc_hd__o21ai_2
X_5431_ _5288_/A _5288_/B _6706_/S _5314_/X VGND VGND VPWR VPWR _5431_/X sky130_fd_sc_hd__o211a_2
X_8150_ _8285_/CLK _8150_/D VGND VGND VPWR VPWR _8150_/Q sky130_fd_sc_hd__dfxtp_2
X_5362_ _5360_/X _5361_/X _7555_/S VGND VGND VPWR VPWR _5362_/X sky130_fd_sc_hd__mux2_2
X_8081_ _8228_/CLK _8081_/D VGND VGND VPWR VPWR _8081_/Q sky130_fd_sc_hd__dfxtp_2
X_7101_ _7074_/B _7560_/A _7228_/B VGND VGND VPWR VPWR _7101_/X sky130_fd_sc_hd__mux2_2
X_4313_ _4313_/A VGND VGND VPWR VPWR _8094_/D sky130_fd_sc_hd__buf_1
XFILLER_101_305 VGND VGND VPWR VPWR sky130_fd_sc_hd__decap_3
XFILLER_113_143 VGND VGND VPWR VPWR sky130_fd_sc_hd__decap_3
XFILLER_59_219 VGND VGND VPWR VPWR sky130_fd_sc_hd__decap_3
XFILLER_87_517 VGND VGND VPWR VPWR sky130_fd_sc_hd__decap_3
XFILLER_99_388 VGND VGND VPWR VPWR sky130_fd_sc_hd__decap_3
X_7032_ _7166_/A _7032_/B VGND VGND VPWR VPWR _7032_/Y sky130_fd_sc_hd__xnor2_2
X_5293_ _5858_/B _5415_/A VGND VGND VPWR VPWR _5293_/Y sky130_fd_sc_hd__nor2_2
XFILLER_99_399 VGND VGND VPWR VPWR sky130_fd_sc_hd__decap_3
X_4244_ _7930_/B _4244_/B VGND VGND VPWR VPWR _4245_/A sky130_fd_sc_hd__and2_2
XFILLER_67_252 VGND VGND VPWR VPWR sky130_fd_sc_hd__decap_3
XFILLER_95_561 VGND VGND VPWR VPWR sky130_fd_sc_hd__decap_3
X_4175_ _4175_/A VGND VGND VPWR VPWR _8025_/D sky130_fd_sc_hd__buf_1
XFILLER_27_116 VGND VGND VPWR VPWR sky130_fd_sc_hd__fill_1
XFILLER_55_414 VGND VGND VPWR VPWR sky130_fd_sc_hd__decap_3
XFILLER_82_200 VGND VGND VPWR VPWR sky130_fd_sc_hd__decap_3
XFILLER_55_458 VGND VGND VPWR VPWR sky130_fd_sc_hd__decap_3
XFILLER_82_233 VGND VGND VPWR VPWR sky130_fd_sc_hd__decap_3
XFILLER_43_609 VGND VGND VPWR VPWR sky130_fd_sc_hd__decap_3
XFILLER_82_266 VGND VGND VPWR VPWR sky130_fd_sc_hd__decap_3
X_7934_ _8398_/CLK _7934_/D VGND VGND VPWR VPWR _7934_/Q sky130_fd_sc_hd__dfxtp_2
XFILLER_23_311 VGND VGND VPWR VPWR sky130_fd_sc_hd__decap_3
XFILLER_42_119 VGND VGND VPWR VPWR sky130_fd_sc_hd__decap_3
X_7865_ _7865_/A VGND VGND VPWR VPWR _8369_/D sky130_fd_sc_hd__buf_1
XFILLER_50_141 VGND VGND VPWR VPWR sky130_fd_sc_hd__decap_3
X_7796_ _7796_/A _8198_/Q VGND VGND VPWR VPWR _7796_/Y sky130_fd_sc_hd__nand2_2
X_6816_ _8198_/Q _8197_/Q _7796_/A VGND VGND VPWR VPWR _6816_/X sky130_fd_sc_hd__mux2_2
XFILLER_11_517 VGND VGND VPWR VPWR sky130_fd_sc_hd__decap_3
XFILLER_23_377 VGND VGND VPWR VPWR sky130_fd_sc_hd__decap_3
XFILLER_23_388 VGND VGND VPWR VPWR sky130_fd_sc_hd__decap_3
XFILLER_50_174 VGND VGND VPWR VPWR sky130_fd_sc_hd__decap_3
X_6747_ _6721_/A _5469_/B _6740_/X _6746_/X _6787_/A VGND VGND VPWR VPWR _6747_/X
+ sky130_fd_sc_hd__a32o_2
XTAP_TAPCELL_ROW_21_534 VGND VPWR sky130_fd_sc_hd__tapvpwrvgnd_1
X_6678_ _6105_/X _6677_/X _5782_/A _6381_/X _7298_/S0 _7745_/A VGND VGND VPWR VPWR
+ _6678_/X sky130_fd_sc_hd__mux4_2
X_5629_ _7809_/A1 _5616_/X _5617_/X _5628_/X VGND VGND VPWR VPWR _5629_/X sky130_fd_sc_hd__a211o_2
XFILLER_105_600 VGND VGND VPWR VPWR sky130_fd_sc_hd__decap_3
XFILLER_117_471 VGND VGND VPWR VPWR sky130_fd_sc_hd__fill_2
X_8348_ _8349_/CLK _8348_/D VGND VGND VPWR VPWR _8348_/Q sky130_fd_sc_hd__dfxtp_2
XFILLER_104_121 VGND VGND VPWR VPWR sky130_fd_sc_hd__decap_3
XFILLER_105_644 VGND VGND VPWR VPWR sky130_fd_sc_hd__fill_2
XFILLER_117_493 VGND VGND VPWR VPWR sky130_fd_sc_hd__decap_3
XFILLER_105_666 VGND VGND VPWR VPWR sky130_fd_sc_hd__decap_3
XFILLER_78_517 VGND VGND VPWR VPWR sky130_fd_sc_hd__decap_3
X_8279_ _8280_/CLK _8279_/D VGND VGND VPWR VPWR _8279_/Q sky130_fd_sc_hd__dfxtp_2
XFILLER_116_75 VGND VGND VPWR VPWR sky130_fd_sc_hd__decap_3
XFILLER_76_24 VGND VGND VPWR VPWR sky130_fd_sc_hd__decap_3
XFILLER_78_539 VGND VGND VPWR VPWR sky130_fd_sc_hd__decap_3
XFILLER_100_371 VGND VGND VPWR VPWR sky130_fd_sc_hd__decap_3
XFILLER_18_105 VGND VGND VPWR VPWR sky130_fd_sc_hd__decap_3
XFILLER_19_617 VGND VGND VPWR VPWR sky130_fd_sc_hd__decap_3
XFILLER_46_414 VGND VGND VPWR VPWR sky130_fd_sc_hd__decap_3
XFILLER_58_274 VGND VGND VPWR VPWR sky130_fd_sc_hd__fill_1
XFILLER_74_701 VGND VGND VPWR VPWR sky130_fd_sc_hd__decap_3
XFILLER_86_572 VGND VGND VPWR VPWR sky130_fd_sc_hd__decap_3
XFILLER_18_138 VGND VGND VPWR VPWR sky130_fd_sc_hd__fill_2
XFILLER_73_222 VGND VGND VPWR VPWR sky130_fd_sc_hd__fill_2
XFILLER_73_233 VGND VGND VPWR VPWR sky130_fd_sc_hd__decap_3
XPHY_EDGE_ROW_85_Left_205 VGND VGND VPWR VPWR sky130_fd_sc_hd__decap_3
XTAP_TAPCELL_ROW_29_634 VGND VPWR sky130_fd_sc_hd__tapvpwrvgnd_1
XFILLER_27_650 VGND VGND VPWR VPWR sky130_fd_sc_hd__fill_2
XFILLER_34_609 VGND VGND VPWR VPWR sky130_fd_sc_hd__decap_3
XFILLER_46_469 VGND VGND VPWR VPWR sky130_fd_sc_hd__decap_3
XFILLER_61_417 VGND VGND VPWR VPWR sky130_fd_sc_hd__decap_3
XTAP_TAPCELL_ROW_1_270 VGND VPWR sky130_fd_sc_hd__tapvpwrvgnd_1
XFILLER_26_171 VGND VGND VPWR VPWR sky130_fd_sc_hd__decap_3
XFILLER_27_683 VGND VGND VPWR VPWR sky130_fd_sc_hd__decap_3
XFILLER_33_119 VGND VGND VPWR VPWR sky130_fd_sc_hd__decap_3
XFILLER_54_480 VGND VGND VPWR VPWR sky130_fd_sc_hd__decap_3
XTAP_TAPCELL_ROW_57_998 VGND VPWR sky130_fd_sc_hd__tapvpwrvgnd_1
XFILLER_14_355 VGND VGND VPWR VPWR sky130_fd_sc_hd__decap_3
XFILLER_41_141 VGND VGND VPWR VPWR sky130_fd_sc_hd__decap_3
XFILLER_41_196 VGND VGND VPWR VPWR sky130_fd_sc_hd__decap_3
XFILLER_10_550 VGND VGND VPWR VPWR sky130_fd_sc_hd__decap_3
XFILLER_10_572 VGND VGND VPWR VPWR sky130_fd_sc_hd__decap_3
XFILLER_6_510 VGND VGND VPWR VPWR sky130_fd_sc_hd__fill_1
XPHY_EDGE_ROW_94_Left_214 VGND VGND VPWR VPWR sky130_fd_sc_hd__decap_3
XFILLER_115_419 VGND VGND VPWR VPWR sky130_fd_sc_hd__decap_3
XFILLER_6_598 VGND VGND VPWR VPWR sky130_fd_sc_hd__decap_3
XTAP_TAPCELL_ROW_75_1230 VGND VPWR sky130_fd_sc_hd__tapvpwrvgnd_1
XFILLER_69_517 VGND VGND VPWR VPWR sky130_fd_sc_hd__decap_3
XTAP_TAPCELL_ROW_9_370 VGND VPWR sky130_fd_sc_hd__tapvpwrvgnd_1
XFILLER_37_6 VGND VGND VPWR VPWR sky130_fd_sc_hd__decap_3
XFILLER_96_325 VGND VGND VPWR VPWR sky130_fd_sc_hd__decap_3
XTAP_TAPCELL_ROW_9_381 VGND VPWR sky130_fd_sc_hd__tapvpwrvgnd_1
XFILLER_84_509 VGND VGND VPWR VPWR sky130_fd_sc_hd__decap_3
XFILLER_2_65 VGND VGND VPWR VPWR sky130_fd_sc_hd__decap_3
XFILLER_37_414 VGND VGND VPWR VPWR sky130_fd_sc_hd__fill_1
XFILLER_64_200 VGND VGND VPWR VPWR sky130_fd_sc_hd__decap_3
XFILLER_65_701 VGND VGND VPWR VPWR sky130_fd_sc_hd__decap_3
XFILLER_77_561 VGND VGND VPWR VPWR sky130_fd_sc_hd__decap_3
XFILLER_37_436 VGND VGND VPWR VPWR sky130_fd_sc_hd__decap_3
XFILLER_37_458 VGND VGND VPWR VPWR sky130_fd_sc_hd__decap_3
XFILLER_49_296 VGND VGND VPWR VPWR sky130_fd_sc_hd__decap_3
XFILLER_92_564 VGND VGND VPWR VPWR sky130_fd_sc_hd__decap_3
XFILLER_92_586 VGND VGND VPWR VPWR sky130_fd_sc_hd__fill_2
X_5980_ _5646_/X _5641_/X _6321_/B VGND VGND VPWR VPWR _5980_/X sky130_fd_sc_hd__mux2_2
XFILLER_17_160 VGND VGND VPWR VPWR sky130_fd_sc_hd__decap_3
XFILLER_33_620 VGND VGND VPWR VPWR sky130_fd_sc_hd__fill_1
XFILLER_33_631 VGND VGND VPWR VPWR sky130_fd_sc_hd__decap_3
XFILLER_52_439 VGND VGND VPWR VPWR sky130_fd_sc_hd__decap_3
XFILLER_64_288 VGND VGND VPWR VPWR sky130_fd_sc_hd__decap_3
X_4931_ _8238_/Q _6024_/A VGND VGND VPWR VPWR _4931_/X sky130_fd_sc_hd__or2b_2
XTAP_TAPCELL_ROW_86_1381 VGND VPWR sky130_fd_sc_hd__tapvpwrvgnd_1
XFILLER_32_141 VGND VGND VPWR VPWR sky130_fd_sc_hd__fill_1
XFILLER_33_653 VGND VGND VPWR VPWR sky130_fd_sc_hd__decap_3
XFILLER_60_450 VGND VGND VPWR VPWR sky130_fd_sc_hd__decap_3
X_7650_ _7648_/Y _4972_/B _7649_/Y _5071_/A _7843_/C VGND VGND VPWR VPWR _7831_/B
+ sky130_fd_sc_hd__o221a_2
X_4862_ _8252_/Q VGND VGND VPWR VPWR _4863_/B sky130_fd_sc_hd__inv_2
XFILLER_60_483 VGND VGND VPWR VPWR sky130_fd_sc_hd__decap_3
X_6601_ _6303_/A _6303_/B _6599_/X _6600_/X VGND VGND VPWR VPWR _6601_/X sky130_fd_sc_hd__o31a_4
XANTENNA_15 _7843_/C VGND VGND VPWR VPWR sky130_fd_sc_hd__diode_2
XANTENNA_26 _8180_/Q VGND VGND VPWR VPWR sky130_fd_sc_hd__diode_2
XFILLER_20_336 VGND VGND VPWR VPWR sky130_fd_sc_hd__decap_3
X_7581_ _8220_/Q _7582_/B _7585_/B _7583_/C _7583_/D VGND VGND VPWR VPWR _7587_/A
+ sky130_fd_sc_hd__o2111a_2
X_4793_ _7044_/B _8269_/Q VGND VGND VPWR VPWR _7159_/A sky130_fd_sc_hd__nand2_2
XFILLER_119_725 VGND VGND VPWR VPWR sky130_fd_sc_hd__decap_3
XFILLER_9_370 VGND VGND VPWR VPWR sky130_fd_sc_hd__decap_3
X_6532_ _5957_/X _6531_/X _5596_/X _6240_/X _5182_/A _6818_/S VGND VGND VPWR VPWR
+ _6533_/B sky130_fd_sc_hd__mux4_2
XFILLER_118_246 VGND VGND VPWR VPWR sky130_fd_sc_hd__fill_1
X_6463_ _5415_/A _6460_/X _6462_/X VGND VGND VPWR VPWR _6463_/Y sky130_fd_sc_hd__o21ai_2
X_8202_ _8359_/CLK _8202_/D VGND VGND VPWR VPWR _8202_/Q sky130_fd_sc_hd__dfxtp_2
X_5414_ _7264_/A VGND VGND VPWR VPWR _7474_/A sky130_fd_sc_hd__buf_1
X_8133_ _8269_/CLK _8133_/D VGND VGND VPWR VPWR _8133_/Q sky130_fd_sc_hd__dfxtp_2
X_6394_ _6394_/A _6394_/B _6394_/C _6140_/A VGND VGND VPWR VPWR _6395_/B sky130_fd_sc_hd__or4b_4
XFILLER_99_152 VGND VGND VPWR VPWR sky130_fd_sc_hd__decap_3
Xoutput177 _8002_/Q VGND VGND VPWR VPWR result[44] sky130_fd_sc_hd__clkdlybuf4s25_1
Xoutput166 _7992_/Q VGND VGND VPWR VPWR result[34] sky130_fd_sc_hd__clkdlybuf4s25_1
Xoutput155 _7982_/Q VGND VGND VPWR VPWR result[24] sky130_fd_sc_hd__clkdlybuf4s25_1
Xoutput144 _7972_/Q VGND VGND VPWR VPWR result[14] sky130_fd_sc_hd__clkdlybuf4s25_1
X_5345_ _6706_/S _5318_/B _6121_/B _5344_/X VGND VGND VPWR VPWR _5345_/X sky130_fd_sc_hd__a31o_2
XFILLER_101_113 VGND VGND VPWR VPWR sky130_fd_sc_hd__decap_3
X_8064_ _8199_/CLK _8064_/D VGND VGND VPWR VPWR _8064_/Q sky130_fd_sc_hd__dfxtp_2
Xoutput199 _7964_/Q VGND VGND VPWR VPWR result[6] sky130_fd_sc_hd__clkdlybuf4s25_1
Xoutput188 _8012_/Q VGND VGND VPWR VPWR result[54] sky130_fd_sc_hd__clkdlybuf4s25_1
X_5276_ _5276_/A VGND VGND VPWR VPWR _5276_/Y sky130_fd_sc_hd__inv_2
X_7015_ _8267_/Q _6970_/X _7014_/X VGND VGND VPWR VPWR _7017_/B sky130_fd_sc_hd__a21o_4
X_4227_ _4227_/A VGND VGND VPWR VPWR _8051_/D sky130_fd_sc_hd__buf_1
XFILLER_56_701 VGND VGND VPWR VPWR sky130_fd_sc_hd__decap_3
XFILLER_68_572 VGND VGND VPWR VPWR sky130_fd_sc_hd__decap_3
XFILLER_28_458 VGND VGND VPWR VPWR sky130_fd_sc_hd__decap_3
XFILLER_46_38 VGND VGND VPWR VPWR sky130_fd_sc_hd__decap_3
XFILLER_83_520 VGND VGND VPWR VPWR sky130_fd_sc_hd__decap_3
XFILLER_95_391 VGND VGND VPWR VPWR sky130_fd_sc_hd__fill_1
X_4158_ _7930_/B _7949_/Q VGND VGND VPWR VPWR _4159_/A sky130_fd_sc_hd__and2_2
XFILLER_43_417 VGND VGND VPWR VPWR sky130_fd_sc_hd__decap_3
XFILLER_55_266 VGND VGND VPWR VPWR sky130_fd_sc_hd__decap_3
XFILLER_83_564 VGND VGND VPWR VPWR sky130_fd_sc_hd__decap_3
X_4089_ _4089_/A VGND VGND VPWR VPWR _7982_/D sky130_fd_sc_hd__buf_1
XFILLER_102_44 VGND VGND VPWR VPWR sky130_fd_sc_hd__decap_3
XFILLER_36_480 VGND VGND VPWR VPWR sky130_fd_sc_hd__fill_1
XFILLER_55_299 VGND VGND VPWR VPWR sky130_fd_sc_hd__decap_3
XFILLER_70_203 VGND VGND VPWR VPWR sky130_fd_sc_hd__decap_3
XFILLER_70_236 VGND VGND VPWR VPWR sky130_fd_sc_hd__decap_3
X_7917_ _7917_/A VGND VGND VPWR VPWR _8395_/D sky130_fd_sc_hd__buf_1
XFILLER_24_653 VGND VGND VPWR VPWR sky130_fd_sc_hd__decap_3
XFILLER_62_26 VGND VGND VPWR VPWR sky130_fd_sc_hd__fill_2
XTAP_TAPCELL_ROW_54_957 VGND VPWR sky130_fd_sc_hd__tapvpwrvgnd_1
XFILLER_102_99 VGND VGND VPWR VPWR sky130_fd_sc_hd__decap_3
XFILLER_11_314 VGND VGND VPWR VPWR sky130_fd_sc_hd__decap_3
XFILLER_24_697 VGND VGND VPWR VPWR sky130_fd_sc_hd__decap_3
XFILLER_51_461 VGND VGND VPWR VPWR sky130_fd_sc_hd__decap_3
XFILLER_62_59 VGND VGND VPWR VPWR sky130_fd_sc_hd__fill_1
X_7848_ _8294_/Q _7930_/B VGND VGND VPWR VPWR _7849_/A sky130_fd_sc_hd__and2_2
XFILLER_51_494 VGND VGND VPWR VPWR sky130_fd_sc_hd__decap_3
X_7779_ _5897_/A _7680_/B _7672_/A VGND VGND VPWR VPWR _7779_/Y sky130_fd_sc_hd__o21ai_2
XFILLER_109_202 VGND VGND VPWR VPWR sky130_fd_sc_hd__decap_3
XFILLER_11_369 VGND VGND VPWR VPWR sky130_fd_sc_hd__decap_3
XFILLER_7_329 VGND VGND VPWR VPWR sky130_fd_sc_hd__decap_3
XFILLER_109_246 VGND VGND VPWR VPWR sky130_fd_sc_hd__decap_3
XFILLER_11_30 VGND VGND VPWR VPWR sky130_fd_sc_hd__decap_3
XFILLER_3_524 VGND VGND VPWR VPWR sky130_fd_sc_hd__decap_3
XFILLER_2_3 VGND VGND VPWR VPWR sky130_fd_sc_hd__fill_2
XFILLER_3_557 VGND VGND VPWR VPWR sky130_fd_sc_hd__decap_3
XTAP_TAPCELL_ROW_111_1706 VGND VPWR sky130_fd_sc_hd__tapvpwrvgnd_1
XFILLER_105_474 VGND VGND VPWR VPWR sky130_fd_sc_hd__decap_3
XFILLER_105_485 VGND VGND VPWR VPWR sky130_fd_sc_hd__decap_3
XFILLER_78_336 VGND VGND VPWR VPWR sky130_fd_sc_hd__decap_3
XFILLER_87_45 VGND VGND VPWR VPWR sky130_fd_sc_hd__decap_3
XFILLER_59_550 VGND VGND VPWR VPWR sky130_fd_sc_hd__fill_1
XFILLER_66_509 VGND VGND VPWR VPWR sky130_fd_sc_hd__fill_1
XFILLER_87_78 VGND VGND VPWR VPWR sky130_fd_sc_hd__decap_3
XTAP_TAPCELL_ROW_6_340 VGND VPWR sky130_fd_sc_hd__tapvpwrvgnd_1
XFILLER_46_200 VGND VGND VPWR VPWR sky130_fd_sc_hd__decap_3
XTAP_TAPCELL_ROW_70_1171 VGND VPWR sky130_fd_sc_hd__tapvpwrvgnd_1
XFILLER_86_380 VGND VGND VPWR VPWR sky130_fd_sc_hd__decap_3
XFILLER_19_469 VGND VGND VPWR VPWR sky130_fd_sc_hd__decap_3
XFILLER_34_406 VGND VGND VPWR VPWR sky130_fd_sc_hd__fill_2
XFILLER_62_704 VGND VGND VPWR VPWR sky130_fd_sc_hd__decap_3
XFILLER_74_553 VGND VGND VPWR VPWR sky130_fd_sc_hd__decap_3
XTAP_TAPCELL_ROW_109_1679 VGND VPWR sky130_fd_sc_hd__tapvpwrvgnd_1
XFILLER_34_439 VGND VGND VPWR VPWR sky130_fd_sc_hd__decap_3
XFILLER_36_60 VGND VGND VPWR VPWR sky130_fd_sc_hd__fill_1
XFILLER_61_225 VGND VGND VPWR VPWR sky130_fd_sc_hd__decap_3
XFILLER_74_586 VGND VGND VPWR VPWR sky130_fd_sc_hd__fill_2
XFILLER_15_631 VGND VGND VPWR VPWR sky130_fd_sc_hd__fill_1
XFILLER_61_247 VGND VGND VPWR VPWR sky130_fd_sc_hd__decap_3
XFILLER_14_141 VGND VGND VPWR VPWR sky130_fd_sc_hd__decap_3
XFILLER_14_185 VGND VGND VPWR VPWR sky130_fd_sc_hd__fill_2
XFILLER_30_645 VGND VGND VPWR VPWR sky130_fd_sc_hd__decap_3
Xinput13 operand_a[16] VGND VGND VPWR VPWR _4208_/B sky130_fd_sc_hd__clkdlybuf4s25_1
Xinput46 operand_a[46] VGND VGND VPWR VPWR _4268_/B sky130_fd_sc_hd__clkdlybuf4s25_1
Xinput35 operand_a[36] VGND VGND VPWR VPWR _4248_/B sky130_fd_sc_hd__clkdlybuf4s25_1
Xinput24 operand_a[26] VGND VGND VPWR VPWR _4228_/B sky130_fd_sc_hd__clkdlybuf4s25_1
XFILLER_115_205 VGND VGND VPWR VPWR sky130_fd_sc_hd__fill_2
XFILLER_6_362 VGND VGND VPWR VPWR sky130_fd_sc_hd__fill_2
Xinput79 operand_b[18] VGND VGND VPWR VPWR _4340_/B sky130_fd_sc_hd__clkdlybuf4s25_1
Xinput68 operand_a[8] VGND VGND VPWR VPWR _4192_/B sky130_fd_sc_hd__clkdlybuf4s25_1
Xinput57 operand_a[56] VGND VGND VPWR VPWR _4288_/B sky130_fd_sc_hd__clkdlybuf4s25_1
XFILLER_108_290 VGND VGND VPWR VPWR sky130_fd_sc_hd__decap_3
XFILLER_35_3 VGND VGND VPWR VPWR sky130_fd_sc_hd__fill_1
XFILLER_69_314 VGND VGND VPWR VPWR sky130_fd_sc_hd__decap_3
XFILLER_69_325 VGND VGND VPWR VPWR sky130_fd_sc_hd__decap_3
XFILLER_96_100 VGND VGND VPWR VPWR sky130_fd_sc_hd__decap_3
XFILLER_97_623 VGND VGND VPWR VPWR sky130_fd_sc_hd__decap_3
X_5130_ _5451_/S VGND VGND VPWR VPWR _7653_/A sky130_fd_sc_hd__buf_1
XFILLER_111_455 VGND VGND VPWR VPWR sky130_fd_sc_hd__fill_2
XFILLER_69_369 VGND VGND VPWR VPWR sky130_fd_sc_hd__decap_3
XFILLER_96_122 VGND VGND VPWR VPWR sky130_fd_sc_hd__fill_2
XFILLER_97_656 VGND VGND VPWR VPWR sky130_fd_sc_hd__decap_3
X_5061_ _5061_/A _5061_/B VGND VGND VPWR VPWR _5061_/Y sky130_fd_sc_hd__nor2_2
XFILLER_38_701 VGND VGND VPWR VPWR sky130_fd_sc_hd__decap_3
XFILLER_38_712 VGND VGND VPWR VPWR sky130_fd_sc_hd__decap_3
X_4012_ _8345_/Q _8346_/Q _8349_/Q _8348_/Q VGND VGND VPWR VPWR _4033_/B sky130_fd_sc_hd__or4_2
XFILLER_37_222 VGND VGND VPWR VPWR sky130_fd_sc_hd__fill_2
XFILLER_65_531 VGND VGND VPWR VPWR sky130_fd_sc_hd__decap_3
XFILLER_84_339 VGND VGND VPWR VPWR sky130_fd_sc_hd__decap_3
XFILLER_65_564 VGND VGND VPWR VPWR sky130_fd_sc_hd__decap_3
XFILLER_92_361 VGND VGND VPWR VPWR sky130_fd_sc_hd__decap_3
XFILLER_92_383 VGND VGND VPWR VPWR sky130_fd_sc_hd__decap_3
X_5963_ _5963_/A _5963_/B _5963_/C VGND VGND VPWR VPWR _5967_/A sky130_fd_sc_hd__and3_2
XFILLER_18_491 VGND VGND VPWR VPWR sky130_fd_sc_hd__decap_3
XFILLER_40_409 VGND VGND VPWR VPWR sky130_fd_sc_hd__decap_3
XFILLER_52_247 VGND VGND VPWR VPWR sky130_fd_sc_hd__decap_3
X_7702_ _7812_/A _7698_/X _7701_/X VGND VGND VPWR VPWR _7702_/Y sky130_fd_sc_hd__a21oi_2
X_4914_ _8243_/Q _8179_/Q VGND VGND VPWR VPWR _4915_/B sky130_fd_sc_hd__or2b_2
XFILLER_33_461 VGND VGND VPWR VPWR sky130_fd_sc_hd__decap_3
XFILLER_52_269 VGND VGND VPWR VPWR sky130_fd_sc_hd__decap_3
XFILLER_80_578 VGND VGND VPWR VPWR sky130_fd_sc_hd__decap_3
XFILLER_80_589 VGND VGND VPWR VPWR sky130_fd_sc_hd__decap_3
X_5894_ _5894_/A _5894_/B VGND VGND VPWR VPWR _5894_/Y sky130_fd_sc_hd__xnor2_2
XTAP_TAPCELL_ROW_51_927 VGND VPWR sky130_fd_sc_hd__tapvpwrvgnd_1
XTAP_TAPCELL_ROW_51_916 VGND VPWR sky130_fd_sc_hd__tapvpwrvgnd_1
XFILLER_32_29 VGND VGND VPWR VPWR sky130_fd_sc_hd__decap_3
XFILLER_33_494 VGND VGND VPWR VPWR sky130_fd_sc_hd__decap_3
XFILLER_60_280 VGND VGND VPWR VPWR sky130_fd_sc_hd__decap_3
X_7633_ _8286_/Q _7633_/B _7633_/C VGND VGND VPWR VPWR _7633_/X sky130_fd_sc_hd__and3_2
X_4845_ _4998_/A _4845_/B VGND VGND VPWR VPWR _6636_/A sky130_fd_sc_hd__nand2_2
XFILLER_20_144 VGND VGND VPWR VPWR sky130_fd_sc_hd__decap_3
X_7564_ _7264_/A _7562_/B _7231_/A _7559_/Y VGND VGND VPWR VPWR _7565_/A sky130_fd_sc_hd__o22a_2
X_4776_ _4776_/A _4776_/B VGND VGND VPWR VPWR _7180_/A sky130_fd_sc_hd__nand2_2
XTAP_TAPCELL_ROW_31_662 VGND VPWR sky130_fd_sc_hd__tapvpwrvgnd_1
XFILLER_20_177 VGND VGND VPWR VPWR sky130_fd_sc_hd__decap_3
Xrebuffer949 _6610_/B VGND VGND VPWR VPWR _6635_/A2 sky130_fd_sc_hd__buf_2
X_6515_ _8290_/Q _6502_/X _6504_/X _5627_/A _6514_/X VGND VGND VPWR VPWR _6515_/X
+ sky130_fd_sc_hd__a221o_2
XTAP_TAPCELL_ROW_99_1550 VGND VPWR sky130_fd_sc_hd__tapvpwrvgnd_1
X_7495_ _8282_/Q _7463_/B _4749_/A VGND VGND VPWR VPWR _7495_/X sky130_fd_sc_hd__a21o_2
XFILLER_106_227 VGND VGND VPWR VPWR sky130_fd_sc_hd__decap_3
X_6446_ _4877_/B _6444_/X _6445_/X VGND VGND VPWR VPWR _6446_/X sky130_fd_sc_hd__o21ba_2
X_6377_ _6378_/S _6338_/B _6369_/X _8185_/Q _6376_/X VGND VGND VPWR VPWR _6390_/A
+ sky130_fd_sc_hd__o221a_2
XFILLER_0_505 VGND VGND VPWR VPWR sky130_fd_sc_hd__decap_3
XFILLER_114_271 VGND VGND VPWR VPWR sky130_fd_sc_hd__decap_3
XFILLER_88_634 VGND VGND VPWR VPWR sky130_fd_sc_hd__fill_1
X_8116_ _8388_/CLK _8116_/D VGND VGND VPWR VPWR _8116_/Q sky130_fd_sc_hd__dfxtp_2
X_5328_ _5323_/Y _5325_/Y _5326_/X _5327_/X _5411_/B VGND VGND VPWR VPWR _5328_/X
+ sky130_fd_sc_hd__a32o_2
XFILLER_102_433 VGND VGND VPWR VPWR sky130_fd_sc_hd__decap_3
XFILLER_114_293 VGND VGND VPWR VPWR sky130_fd_sc_hd__decap_3
XFILLER_87_122 VGND VGND VPWR VPWR sky130_fd_sc_hd__fill_2
X_8047_ _8360_/CLK _8047_/D VGND VGND VPWR VPWR _8047_/Q sky130_fd_sc_hd__dfxtp_2
XFILLER_102_477 VGND VGND VPWR VPWR sky130_fd_sc_hd__decap_3
XFILLER_75_317 VGND VGND VPWR VPWR sky130_fd_sc_hd__decap_3
XFILLER_87_155 VGND VGND VPWR VPWR sky130_fd_sc_hd__fill_2
XFILLER_87_166 VGND VGND VPWR VPWR sky130_fd_sc_hd__fill_2
X_5259_ _8191_/Q _8192_/Q _5678_/S VGND VGND VPWR VPWR _5259_/X sky130_fd_sc_hd__mux2_2
XFILLER_113_21 VGND VGND VPWR VPWR sky130_fd_sc_hd__decap_3
XFILLER_28_200 VGND VGND VPWR VPWR sky130_fd_sc_hd__decap_3
XFILLER_68_391 VGND VGND VPWR VPWR sky130_fd_sc_hd__decap_3
XFILLER_87_199 VGND VGND VPWR VPWR sky130_fd_sc_hd__decap_3
XFILLER_113_54 VGND VGND VPWR VPWR sky130_fd_sc_hd__fill_2
XFILLER_90_309 VGND VGND VPWR VPWR sky130_fd_sc_hd__decap_3
Xclkbuf_2_2__f_clk clkbuf_0_clk/X VGND VGND VPWR VPWR clkbuf_2_2__f_clk/X sky130_fd_sc_hd__clkbuf_16
XTAP_TAPCELL_ROW_39_762 VGND VPWR sky130_fd_sc_hd__tapvpwrvgnd_1
XFILLER_16_439 VGND VGND VPWR VPWR sky130_fd_sc_hd__decap_3
XFILLER_43_225 VGND VGND VPWR VPWR sky130_fd_sc_hd__decap_3
XFILLER_43_258 VGND VGND VPWR VPWR sky130_fd_sc_hd__decap_3
XFILLER_71_567 VGND VGND VPWR VPWR sky130_fd_sc_hd__fill_2
XFILLER_24_450 VGND VGND VPWR VPWR sky130_fd_sc_hd__decap_3
XFILLER_24_472 VGND VGND VPWR VPWR sky130_fd_sc_hd__decap_3
XFILLER_12_623 VGND VGND VPWR VPWR sky130_fd_sc_hd__decap_3
XFILLER_12_634 VGND VGND VPWR VPWR sky130_fd_sc_hd__decap_3
XFILLER_12_645 VGND VGND VPWR VPWR sky130_fd_sc_hd__decap_3
XFILLER_11_133 VGND VGND VPWR VPWR sky130_fd_sc_hd__decap_3
XFILLER_7_104 VGND VGND VPWR VPWR sky130_fd_sc_hd__decap_3
XFILLER_11_166 VGND VGND VPWR VPWR sky130_fd_sc_hd__fill_2
XFILLER_11_199 VGND VGND VPWR VPWR sky130_fd_sc_hd__fill_1
XTAP_TAPCELL_ROW_59_1022 VGND VPWR sky130_fd_sc_hd__tapvpwrvgnd_1
XFILLER_98_44 VGND VGND VPWR VPWR sky130_fd_sc_hd__decap_3
XFILLER_3_343 VGND VGND VPWR VPWR sky130_fd_sc_hd__decap_3
XFILLER_98_77 VGND VGND VPWR VPWR sky130_fd_sc_hd__decap_3
XTAP_TAPCELL_ROW_72_1200 VGND VPWR sky130_fd_sc_hd__tapvpwrvgnd_1
XFILLER_105_260 VGND VGND VPWR VPWR sky130_fd_sc_hd__decap_3
XFILLER_112_208 VGND VGND VPWR VPWR sky130_fd_sc_hd__fill_2
XFILLER_3_387 VGND VGND VPWR VPWR sky130_fd_sc_hd__decap_3
XFILLER_78_100 VGND VGND VPWR VPWR sky130_fd_sc_hd__decap_3
XFILLER_98_88 VGND VGND VPWR VPWR sky130_fd_sc_hd__decap_3
XFILLER_105_293 VGND VGND VPWR VPWR sky130_fd_sc_hd__decap_3
XFILLER_78_133 VGND VGND VPWR VPWR sky130_fd_sc_hd__decap_3
XFILLER_78_144 VGND VGND VPWR VPWR sky130_fd_sc_hd__fill_1
XFILLER_79_656 VGND VGND VPWR VPWR sky130_fd_sc_hd__decap_3
XFILLER_66_306 VGND VGND VPWR VPWR sky130_fd_sc_hd__fill_2
XFILLER_59_391 VGND VGND VPWR VPWR sky130_fd_sc_hd__fill_1
XFILLER_94_659 VGND VGND VPWR VPWR sky130_fd_sc_hd__decap_3
XFILLER_47_81 VGND VGND VPWR VPWR sky130_fd_sc_hd__decap_3
XFILLER_93_147 VGND VGND VPWR VPWR sky130_fd_sc_hd__decap_3
XFILLER_93_169 VGND VGND VPWR VPWR sky130_fd_sc_hd__decap_3
XFILLER_19_266 VGND VGND VPWR VPWR sky130_fd_sc_hd__decap_3
XFILLER_19_277 VGND VGND VPWR VPWR sky130_fd_sc_hd__decap_3
XFILLER_34_203 VGND VGND VPWR VPWR sky130_fd_sc_hd__decap_3
XFILLER_34_214 VGND VGND VPWR VPWR sky130_fd_sc_hd__fill_1
XFILLER_47_597 VGND VGND VPWR VPWR sky130_fd_sc_hd__decap_3
XFILLER_62_512 VGND VGND VPWR VPWR sky130_fd_sc_hd__fill_2
XFILLER_74_383 VGND VGND VPWR VPWR sky130_fd_sc_hd__decap_3
XFILLER_62_556 VGND VGND VPWR VPWR sky130_fd_sc_hd__decap_3
XFILLER_62_578 VGND VGND VPWR VPWR sky130_fd_sc_hd__decap_3
XFILLER_62_589 VGND VGND VPWR VPWR sky130_fd_sc_hd__decap_3
XTAP_TAPCELL_ROW_83_1340 VGND VPWR sky130_fd_sc_hd__tapvpwrvgnd_1
XTAP_TAPCELL_ROW_17_478 VGND VPWR sky130_fd_sc_hd__tapvpwrvgnd_1
XFILLER_15_494 VGND VGND VPWR VPWR sky130_fd_sc_hd__decap_3
XFILLER_42_291 VGND VGND VPWR VPWR sky130_fd_sc_hd__decap_3
XFILLER_30_453 VGND VGND VPWR VPWR sky130_fd_sc_hd__decap_3
X_4630_ _7930_/B _8119_/Q VGND VGND VPWR VPWR _4631_/A sky130_fd_sc_hd__and2_2
X_6300_ _6300_/A _6300_/B VGND VGND VPWR VPWR _6300_/Y sky130_fd_sc_hd__nor2_2
X_4561_ _4561_/A VGND VGND VPWR VPWR _8218_/D sky130_fd_sc_hd__buf_1
XFILLER_116_525 VGND VGND VPWR VPWR sky130_fd_sc_hd__decap_3
XFILLER_7_671 VGND VGND VPWR VPWR sky130_fd_sc_hd__fill_1
X_7280_ _7398_/B _7280_/B VGND VGND VPWR VPWR _7280_/X sky130_fd_sc_hd__xor2_2
X_4492_ _7898_/B _8050_/Q VGND VGND VPWR VPWR _4493_/A sky130_fd_sc_hd__and2_2
XFILLER_116_558 VGND VGND VPWR VPWR sky130_fd_sc_hd__decap_3
XFILLER_6_192 VGND VGND VPWR VPWR sky130_fd_sc_hd__decap_3
X_6231_ _6769_/B _6227_/X _6230_/X _8289_/Q VGND VGND VPWR VPWR _6251_/A sky130_fd_sc_hd__a2bb2o_2
XFILLER_103_208 VGND VGND VPWR VPWR sky130_fd_sc_hd__decap_3
X_6162_ _8180_/Q _5701_/X _6161_/Y _6999_/A1 VGND VGND VPWR VPWR _6162_/X sky130_fd_sc_hd__o22a_2
XTAP_TAPCELL_ROW_94_1480 VGND VPWR sky130_fd_sc_hd__tapvpwrvgnd_1
XFILLER_69_122 VGND VGND VPWR VPWR sky130_fd_sc_hd__fill_1
X_5113_ split/X _5113_/B VGND VGND VPWR VPWR _5113_/Y sky130_fd_sc_hd__nand2_2
XFILLER_85_615 VGND VGND VPWR VPWR sky130_fd_sc_hd__fill_1
XFILLER_97_464 VGND VGND VPWR VPWR sky130_fd_sc_hd__decap_3
X_6093_ _7195_/B VGND VGND VPWR VPWR _6334_/A sky130_fd_sc_hd__buf_1
XFILLER_111_274 VGND VGND VPWR VPWR sky130_fd_sc_hd__decap_3
XFILLER_69_199 VGND VGND VPWR VPWR sky130_fd_sc_hd__decap_3
XFILLER_85_637 VGND VGND VPWR VPWR sky130_fd_sc_hd__decap_3
XFILLER_85_659 VGND VGND VPWR VPWR sky130_fd_sc_hd__decap_3
X_5044_ _5041_/Y _8247_/Q _5042_/X _8246_/Q _5043_/X VGND VGND VPWR VPWR _5044_/X
+ sky130_fd_sc_hd__a221o_2
XFILLER_26_704 VGND VGND VPWR VPWR sky130_fd_sc_hd__decap_3
XFILLER_38_542 VGND VGND VPWR VPWR sky130_fd_sc_hd__decap_3
XFILLER_72_309 VGND VGND VPWR VPWR sky130_fd_sc_hd__decap_3
XFILLER_84_158 VGND VGND VPWR VPWR sky130_fd_sc_hd__decap_3
XFILLER_25_214 VGND VGND VPWR VPWR sky130_fd_sc_hd__decap_3
XFILLER_53_501 VGND VGND VPWR VPWR sky130_fd_sc_hd__decap_3
XFILLER_65_361 VGND VGND VPWR VPWR sky130_fd_sc_hd__decap_3
XTAP_TAPCELL_ROW_36_721 VGND VPWR sky130_fd_sc_hd__tapvpwrvgnd_1
XFILLER_25_225 VGND VGND VPWR VPWR sky130_fd_sc_hd__fill_2
XFILLER_53_534 VGND VGND VPWR VPWR sky130_fd_sc_hd__decap_3
XFILLER_80_331 VGND VGND VPWR VPWR sky130_fd_sc_hd__decap_3
X_6995_ _7017_/A _7027_/B VGND VGND VPWR VPWR _6995_/X sky130_fd_sc_hd__and2_2
XTAP_TAPCELL_ROW_36_732 VGND VPWR sky130_fd_sc_hd__tapvpwrvgnd_1
XFILLER_25_269 VGND VGND VPWR VPWR sky130_fd_sc_hd__decap_3
XFILLER_41_729 VGND VGND VPWR VPWR sky130_fd_sc_hd__decap_3
XFILLER_53_578 VGND VGND VPWR VPWR sky130_fd_sc_hd__decap_3
XFILLER_80_386 VGND VGND VPWR VPWR sky130_fd_sc_hd__decap_3
X_5946_ _7767_/B _5946_/B VGND VGND VPWR VPWR _5946_/X sky130_fd_sc_hd__or2_2
XFILLER_21_431 VGND VGND VPWR VPWR sky130_fd_sc_hd__decap_3
XFILLER_40_228 VGND VGND VPWR VPWR sky130_fd_sc_hd__decap_3
XFILLER_43_39 VGND VGND VPWR VPWR sky130_fd_sc_hd__decap_3
X_5877_ _5849_/X _5852_/X _5866_/X _5876_/Y _6910_/A VGND VGND VPWR VPWR _5877_/X
+ sky130_fd_sc_hd__a32o_2
XFILLER_21_442 VGND VGND VPWR VPWR sky130_fd_sc_hd__decap_3
XFILLER_33_291 VGND VGND VPWR VPWR sky130_fd_sc_hd__decap_3
X_7616_ _5076_/Y _6767_/Y _7646_/A VGND VGND VPWR VPWR _7616_/X sky130_fd_sc_hd__mux2_2
X_4828_ _4828_/A _5004_/A VGND VGND VPWR VPWR _6874_/A sky130_fd_sc_hd__or2_2
XFILLER_21_486 VGND VGND VPWR VPWR sky130_fd_sc_hd__decap_3
XFILLER_119_352 VGND VGND VPWR VPWR sky130_fd_sc_hd__decap_3
XFILLER_5_608 VGND VGND VPWR VPWR sky130_fd_sc_hd__decap_3
X_7547_ _7551_/A _7547_/B VGND VGND VPWR VPWR _7547_/Y sky130_fd_sc_hd__xnor2_2
Xrebuffer735 _5310_/B VGND VGND VPWR VPWR _5127_/A sky130_fd_sc_hd__buf_2
X_4759_ _7319_/A _8277_/Q VGND VGND VPWR VPWR _4980_/A sky130_fd_sc_hd__nor2_2
XFILLER_119_385 VGND VGND VPWR VPWR sky130_fd_sc_hd__decap_3
XFILLER_119_396 VGND VGND VPWR VPWR sky130_fd_sc_hd__decap_3
XFILLER_4_118 VGND VGND VPWR VPWR sky130_fd_sc_hd__fill_1
X_7478_ _8218_/Q _8217_/Q _7796_/A VGND VGND VPWR VPWR _7478_/X sky130_fd_sc_hd__mux2_2
X_6429_ _6423_/X _6425_/Y _6428_/X _5528_/A VGND VGND VPWR VPWR _6429_/Y sky130_fd_sc_hd__a22oi_2
XFILLER_108_65 VGND VGND VPWR VPWR sky130_fd_sc_hd__fill_2
XFILLER_68_14 VGND VGND VPWR VPWR sky130_fd_sc_hd__decap_3
XFILLER_102_230 VGND VGND VPWR VPWR sky130_fd_sc_hd__decap_3
XFILLER_0_357 VGND VGND VPWR VPWR sky130_fd_sc_hd__decap_3
XFILLER_102_241 VGND VGND VPWR VPWR sky130_fd_sc_hd__decap_3
XFILLER_102_263 VGND VGND VPWR VPWR sky130_fd_sc_hd__decap_3
XFILLER_76_626 VGND VGND VPWR VPWR sky130_fd_sc_hd__decap_3
XFILLER_88_475 VGND VGND VPWR VPWR sky130_fd_sc_hd__fill_1
XFILLER_88_486 VGND VGND VPWR VPWR sky130_fd_sc_hd__decap_3
XFILLER_102_296 VGND VGND VPWR VPWR sky130_fd_sc_hd__decap_3
XFILLER_29_520 VGND VGND VPWR VPWR sky130_fd_sc_hd__decap_3
XFILLER_75_125 VGND VGND VPWR VPWR sky130_fd_sc_hd__decap_3
XFILLER_75_169 VGND VGND VPWR VPWR sky130_fd_sc_hd__decap_3
XFILLER_84_35 VGND VGND VPWR VPWR sky130_fd_sc_hd__fill_2
XFILLER_91_607 VGND VGND VPWR VPWR sky130_fd_sc_hd__fill_2
XFILLER_29_575 VGND VGND VPWR VPWR sky130_fd_sc_hd__decap_3
XFILLER_44_501 VGND VGND VPWR VPWR sky130_fd_sc_hd__decap_3
XFILLER_56_361 VGND VGND VPWR VPWR sky130_fd_sc_hd__decap_3
XFILLER_56_383 VGND VGND VPWR VPWR sky130_fd_sc_hd__decap_3
XFILLER_84_681 VGND VGND VPWR VPWR sky130_fd_sc_hd__decap_3
XFILLER_17_51 VGND VGND VPWR VPWR sky130_fd_sc_hd__decap_3
XFILLER_32_707 VGND VGND VPWR VPWR sky130_fd_sc_hd__fill_2
XFILLER_71_331 VGND VGND VPWR VPWR sky130_fd_sc_hd__decap_3
XTAP_TAPCELL_ROW_106_1638 VGND VPWR sky130_fd_sc_hd__tapvpwrvgnd_1
XFILLER_32_729 VGND VGND VPWR VPWR sky130_fd_sc_hd__decap_3
XFILLER_44_589 VGND VGND VPWR VPWR sky130_fd_sc_hd__fill_1
XFILLER_71_364 VGND VGND VPWR VPWR sky130_fd_sc_hd__decap_3
XFILLER_31_228 VGND VGND VPWR VPWR sky130_fd_sc_hd__decap_3
XTAP_TAPCELL_ROW_14_437 VGND VPWR sky130_fd_sc_hd__tapvpwrvgnd_1
XFILLER_12_442 VGND VGND VPWR VPWR sky130_fd_sc_hd__decap_3
XFILLER_8_402 VGND VGND VPWR VPWR sky130_fd_sc_hd__fill_2
XFILLER_12_475 VGND VGND VPWR VPWR sky130_fd_sc_hd__fill_1
XFILLER_33_94 VGND VGND VPWR VPWR sky130_fd_sc_hd__decap_3
XFILLER_4_641 VGND VGND VPWR VPWR sky130_fd_sc_hd__decap_3
XTAP_TAPCELL_ROW_117_1778 VGND VPWR sky130_fd_sc_hd__tapvpwrvgnd_1
XFILLER_113_528 VGND VGND VPWR VPWR sky130_fd_sc_hd__decap_3
XFILLER_3_162 VGND VGND VPWR VPWR sky130_fd_sc_hd__decap_3
XFILLER_4_663 VGND VGND VPWR VPWR sky130_fd_sc_hd__fill_1
XFILLER_98_206 VGND VGND VPWR VPWR sky130_fd_sc_hd__decap_3
XFILLER_98_217 VGND VGND VPWR VPWR sky130_fd_sc_hd__decap_3
XFILLER_99_729 VGND VGND VPWR VPWR sky130_fd_sc_hd__decap_3
XFILLER_4_696 VGND VGND VPWR VPWR sky130_fd_sc_hd__decap_3
XFILLER_79_431 VGND VGND VPWR VPWR sky130_fd_sc_hd__decap_3
XFILLER_67_626 VGND VGND VPWR VPWR sky130_fd_sc_hd__decap_3
XFILLER_94_401 VGND VGND VPWR VPWR sky130_fd_sc_hd__decap_3
XFILLER_58_80 VGND VGND VPWR VPWR sky130_fd_sc_hd__decap_3
XFILLER_58_91 VGND VGND VPWR VPWR sky130_fd_sc_hd__decap_3
XFILLER_94_445 VGND VGND VPWR VPWR sky130_fd_sc_hd__fill_2
XFILLER_54_309 VGND VGND VPWR VPWR sky130_fd_sc_hd__decap_3
XFILLER_82_618 VGND VGND VPWR VPWR sky130_fd_sc_hd__decap_3
XFILLER_81_128 VGND VGND VPWR VPWR sky130_fd_sc_hd__decap_3
XFILLER_94_489 VGND VGND VPWR VPWR sky130_fd_sc_hd__decap_3
XFILLER_35_545 VGND VGND VPWR VPWR sky130_fd_sc_hd__decap_3
XFILLER_74_180 VGND VGND VPWR VPWR sky130_fd_sc_hd__decap_3
XFILLER_22_206 VGND VGND VPWR VPWR sky130_fd_sc_hd__fill_1
XFILLER_23_729 VGND VGND VPWR VPWR sky130_fd_sc_hd__decap_3
XFILLER_35_567 VGND VGND VPWR VPWR sky130_fd_sc_hd__decap_3
XFILLER_62_353 VGND VGND VPWR VPWR sky130_fd_sc_hd__decap_3
X_6780_ _6774_/X _6779_/Y _8197_/Q VGND VGND VPWR VPWR _6780_/X sky130_fd_sc_hd__mux2_2
X_5800_ _8234_/Q _5791_/Y _5799_/X VGND VGND VPWR VPWR _5801_/B sky130_fd_sc_hd__a21o_2
X_3992_ _8349_/Q _7930_/B VGND VGND VPWR VPWR _3993_/A sky130_fd_sc_hd__and2_2
XFILLER_22_239 VGND VGND VPWR VPWR sky130_fd_sc_hd__decap_3
XFILLER_50_548 VGND VGND VPWR VPWR sky130_fd_sc_hd__fill_2
XFILLER_62_397 VGND VGND VPWR VPWR sky130_fd_sc_hd__decap_3
X_5731_ _7562_/A VGND VGND VPWR VPWR _6368_/B sky130_fd_sc_hd__buf_1
X_5662_ _5655_/X _5656_/X _5661_/X VGND VGND VPWR VPWR _5662_/X sky130_fd_sc_hd__o21a_2
XFILLER_30_294 VGND VGND VPWR VPWR sky130_fd_sc_hd__fill_1
X_7401_ _8215_/Q _8279_/Q _7399_/X _8278_/Q _7400_/X VGND VGND VPWR VPWR _7401_/X
+ sky130_fd_sc_hd__a221o_2
X_8381_ _8386_/CLK _8381_/D VGND VGND VPWR VPWR _8381_/Q sky130_fd_sc_hd__dfxtp_2
X_5593_ _8166_/Q _5593_/B _5593_/C VGND VGND VPWR VPWR _5593_/X sky130_fd_sc_hd__or3_2
X_4613_ _4613_/A VGND VGND VPWR VPWR _8244_/D sky130_fd_sc_hd__buf_1
XTAP_TAPCELL_ROW_41_790 VGND VPWR sky130_fd_sc_hd__tapvpwrvgnd_1
X_7332_ _8213_/Q _5293_/Y _7324_/X _7325_/X _7331_/Y VGND VGND VPWR VPWR _7332_/X
+ sky130_fd_sc_hd__a2111o_2
X_4544_ _7843_/A _8076_/Q VGND VGND VPWR VPWR _4545_/A sky130_fd_sc_hd__and2_2
XFILLER_7_490 VGND VGND VPWR VPWR sky130_fd_sc_hd__fill_2
X_7263_ _8275_/Q _5296_/X _7453_/A _7262_/X VGND VGND VPWR VPWR _7274_/B sky130_fd_sc_hd__a211o_2
XFILLER_116_377 VGND VGND VPWR VPWR sky130_fd_sc_hd__decap_3
XFILLER_89_217 VGND VGND VPWR VPWR sky130_fd_sc_hd__decap_3
XFILLER_89_228 VGND VGND VPWR VPWR sky130_fd_sc_hd__decap_3
X_6214_ _6297_/B _6212_/X _6213_/X VGND VGND VPWR VPWR _6214_/X sky130_fd_sc_hd__o21ba_2
X_4475_ _4475_/A VGND VGND VPWR VPWR _8175_/D sky130_fd_sc_hd__buf_1
X_7194_ _6072_/B _7193_/Y _6064_/X VGND VGND VPWR VPWR _7204_/B sky130_fd_sc_hd__a21o_2
XFILLER_100_701 VGND VGND VPWR VPWR sky130_fd_sc_hd__fill_2
X_6145_ _6143_/X _6144_/X _6299_/B VGND VGND VPWR VPWR _6145_/X sky130_fd_sc_hd__mux2_2
XFILLER_112_583 VGND VGND VPWR VPWR sky130_fd_sc_hd__decap_3
XFILLER_57_125 VGND VGND VPWR VPWR sky130_fd_sc_hd__decap_3
XFILLER_58_626 VGND VGND VPWR VPWR sky130_fd_sc_hd__decap_3
XFILLER_58_659 VGND VGND VPWR VPWR sky130_fd_sc_hd__decap_3
X_6076_ _6076_/A _6076_/B VGND VGND VPWR VPWR _8311_/D sky130_fd_sc_hd__nor2_2
XFILLER_57_169 VGND VGND VPWR VPWR sky130_fd_sc_hd__decap_3
X_5027_ _5027_/A _5027_/B VGND VGND VPWR VPWR _5027_/Y sky130_fd_sc_hd__nor2_2
XFILLER_73_629 VGND VGND VPWR VPWR sky130_fd_sc_hd__fill_1
XFILLER_38_383 VGND VGND VPWR VPWR sky130_fd_sc_hd__decap_3
XFILLER_53_320 VGND VGND VPWR VPWR sky130_fd_sc_hd__decap_3
XFILLER_54_27 VGND VGND VPWR VPWR sky130_fd_sc_hd__fill_1
XFILLER_54_38 VGND VGND VPWR VPWR sky130_fd_sc_hd__decap_3
XFILLER_72_139 VGND VGND VPWR VPWR sky130_fd_sc_hd__fill_1
XTAP_TAPCELL_ROW_49_890 VGND VPWR sky130_fd_sc_hd__tapvpwrvgnd_1
XFILLER_13_206 VGND VGND VPWR VPWR sky130_fd_sc_hd__decap_3
XFILLER_14_707 VGND VGND VPWR VPWR sky130_fd_sc_hd__fill_1
XFILLER_14_718 VGND VGND VPWR VPWR sky130_fd_sc_hd__decap_3
XFILLER_26_567 VGND VGND VPWR VPWR sky130_fd_sc_hd__decap_3
XFILLER_53_375 VGND VGND VPWR VPWR sky130_fd_sc_hd__decap_3
XFILLER_81_673 VGND VGND VPWR VPWR sky130_fd_sc_hd__decap_3
XFILLER_13_228 VGND VGND VPWR VPWR sky130_fd_sc_hd__decap_3
XFILLER_41_548 VGND VGND VPWR VPWR sky130_fd_sc_hd__decap_3
XFILLER_53_386 VGND VGND VPWR VPWR sky130_fd_sc_hd__decap_3
XFILLER_80_183 VGND VGND VPWR VPWR sky130_fd_sc_hd__decap_3
XFILLER_81_695 VGND VGND VPWR VPWR sky130_fd_sc_hd__decap_3
X_6978_ _6977_/X _6865_/X _7555_/S VGND VGND VPWR VPWR _6978_/X sky130_fd_sc_hd__mux2_2
XFILLER_110_55 VGND VGND VPWR VPWR sky130_fd_sc_hd__fill_1
XFILLER_70_26 VGND VGND VPWR VPWR sky130_fd_sc_hd__fill_2
X_5929_ _5929_/A _5929_/B VGND VGND VPWR VPWR _5929_/X sky130_fd_sc_hd__or2_4
XFILLER_110_88 VGND VGND VPWR VPWR sky130_fd_sc_hd__fill_1
XFILLER_70_59 VGND VGND VPWR VPWR sky130_fd_sc_hd__decap_3
XTAP_TAPCELL_ROW_101_1568 VGND VPWR sky130_fd_sc_hd__tapvpwrvgnd_1
XTAP_TAPCELL_ROW_11_407 VGND VPWR sky130_fd_sc_hd__tapvpwrvgnd_1
XFILLER_107_300 VGND VGND VPWR VPWR sky130_fd_sc_hd__decap_3
XFILLER_119_53 VGND VGND VPWR VPWR sky130_fd_sc_hd__decap_3
XFILLER_107_333 VGND VGND VPWR VPWR sky130_fd_sc_hd__decap_3
XFILLER_107_355 VGND VGND VPWR VPWR sky130_fd_sc_hd__decap_3
XFILLER_5_449 VGND VGND VPWR VPWR sky130_fd_sc_hd__decap_3
XFILLER_102_3 VGND VGND VPWR VPWR sky130_fd_sc_hd__fill_2
XFILLER_79_57 VGND VGND VPWR VPWR sky130_fd_sc_hd__decap_3
XFILLER_107_399 VGND VGND VPWR VPWR sky130_fd_sc_hd__decap_3
XFILLER_103_561 VGND VGND VPWR VPWR sky130_fd_sc_hd__decap_3
XFILLER_110_509 VGND VGND VPWR VPWR sky130_fd_sc_hd__decap_3
XFILLER_76_401 VGND VGND VPWR VPWR sky130_fd_sc_hd__decap_3
XFILLER_49_637 VGND VGND VPWR VPWR sky130_fd_sc_hd__decap_3
XFILLER_28_50 VGND VGND VPWR VPWR sky130_fd_sc_hd__decap_3
XFILLER_36_309 VGND VGND VPWR VPWR sky130_fd_sc_hd__decap_3
XFILLER_64_607 VGND VGND VPWR VPWR sky130_fd_sc_hd__decap_3
XFILLER_64_618 VGND VGND VPWR VPWR sky130_fd_sc_hd__decap_3
XFILLER_76_456 VGND VGND VPWR VPWR sky130_fd_sc_hd__decap_3
XFILLER_95_78 VGND VGND VPWR VPWR sky130_fd_sc_hd__decap_3
XFILLER_28_83 VGND VGND VPWR VPWR sky130_fd_sc_hd__fill_1
XFILLER_29_350 VGND VGND VPWR VPWR sky130_fd_sc_hd__decap_3
XFILLER_29_372 VGND VGND VPWR VPWR sky130_fd_sc_hd__decap_3
XFILLER_57_681 VGND VGND VPWR VPWR sky130_fd_sc_hd__fill_2
XFILLER_63_128 VGND VGND VPWR VPWR sky130_fd_sc_hd__decap_3
XFILLER_91_426 VGND VGND VPWR VPWR sky130_fd_sc_hd__fill_1
XTAP_TAPCELL_ROW_19_507 VGND VPWR sky130_fd_sc_hd__tapvpwrvgnd_1
XFILLER_28_94 VGND VGND VPWR VPWR sky130_fd_sc_hd__decap_3
XFILLER_56_180 VGND VGND VPWR VPWR sky130_fd_sc_hd__decap_3
XFILLER_57_692 VGND VGND VPWR VPWR sky130_fd_sc_hd__decap_3
XTAP_TAPCELL_ROW_67_1132 VGND VPWR sky130_fd_sc_hd__tapvpwrvgnd_1
XFILLER_17_578 VGND VGND VPWR VPWR sky130_fd_sc_hd__decap_3
XFILLER_44_353 VGND VGND VPWR VPWR sky130_fd_sc_hd__fill_2
XFILLER_72_662 VGND VGND VPWR VPWR sky130_fd_sc_hd__decap_3
XFILLER_32_526 VGND VGND VPWR VPWR sky130_fd_sc_hd__decap_3
XFILLER_32_548 VGND VGND VPWR VPWR sky130_fd_sc_hd__fill_1
XFILLER_44_386 VGND VGND VPWR VPWR sky130_fd_sc_hd__decap_3
XFILLER_71_161 VGND VGND VPWR VPWR sky130_fd_sc_hd__decap_3
XFILLER_71_172 VGND VGND VPWR VPWR sky130_fd_sc_hd__fill_2
XFILLER_71_183 VGND VGND VPWR VPWR sky130_fd_sc_hd__decap_3
XFILLER_44_82 VGND VGND VPWR VPWR sky130_fd_sc_hd__fill_2
XFILLER_8_221 VGND VGND VPWR VPWR sky130_fd_sc_hd__decap_3
XTAP_TAPCELL_ROW_119_1807 VGND VPWR sky130_fd_sc_hd__tapvpwrvgnd_1
XFILLER_40_592 VGND VGND VPWR VPWR sky130_fd_sc_hd__decap_3
XFILLER_8_243 VGND VGND VPWR VPWR sky130_fd_sc_hd__decap_3
XTAP_TAPCELL_ROW_119_1818 VGND VPWR sky130_fd_sc_hd__tapvpwrvgnd_1
XFILLER_117_119 VGND VGND VPWR VPWR sky130_fd_sc_hd__decap_3
XFILLER_67_6 VGND VGND VPWR VPWR sky130_fd_sc_hd__fill_2
XFILLER_8_265 VGND VGND VPWR VPWR sky130_fd_sc_hd__fill_1
XFILLER_8_287 VGND VGND VPWR VPWR sky130_fd_sc_hd__decap_3
XTAP_TAPCELL_ROW_78_1272 VGND VPWR sky130_fd_sc_hd__tapvpwrvgnd_1
XFILLER_113_303 VGND VGND VPWR VPWR sky130_fd_sc_hd__decap_3
XFILLER_99_537 VGND VGND VPWR VPWR sky130_fd_sc_hd__decap_3
XFILLER_5_76 VGND VGND VPWR VPWR sky130_fd_sc_hd__fill_1
X_4260_ _7843_/A _4260_/B VGND VGND VPWR VPWR _4261_/A sky130_fd_sc_hd__and2_2
XFILLER_113_358 VGND VGND VPWR VPWR sky130_fd_sc_hd__fill_1
XFILLER_86_209 VGND VGND VPWR VPWR sky130_fd_sc_hd__decap_3
X_4191_ _4191_/A VGND VGND VPWR VPWR _8033_/D sky130_fd_sc_hd__buf_1
XFILLER_95_732 VGND VGND VPWR VPWR sky130_fd_sc_hd__fill_1
XPHY_EDGE_ROW_105_Left_225 VGND VGND VPWR VPWR sky130_fd_sc_hd__decap_3
XFILLER_94_253 VGND VGND VPWR VPWR sky130_fd_sc_hd__fill_2
XFILLER_39_169 VGND VGND VPWR VPWR sky130_fd_sc_hd__decap_3
XFILLER_48_681 VGND VGND VPWR VPWR sky130_fd_sc_hd__decap_3
XFILLER_82_404 VGND VGND VPWR VPWR sky130_fd_sc_hd__decap_3
XFILLER_94_286 VGND VGND VPWR VPWR sky130_fd_sc_hd__decap_3
X_7950_ _8355_/CLK _7950_/D VGND VGND VPWR VPWR _7950_/Q sky130_fd_sc_hd__dfxtp_2
XFILLER_54_139 VGND VGND VPWR VPWR sky130_fd_sc_hd__fill_1
XFILLER_82_448 VGND VGND VPWR VPWR sky130_fd_sc_hd__decap_3
X_7881_ _7881_/A VGND VGND VPWR VPWR _8377_/D sky130_fd_sc_hd__buf_1
X_6901_ _6497_/B _6975_/D _6494_/A _6926_/B VGND VGND VPWR VPWR _6901_/X sky130_fd_sc_hd__a2bb2o_2
XFILLER_35_364 VGND VGND VPWR VPWR sky130_fd_sc_hd__decap_3
XFILLER_62_150 VGND VGND VPWR VPWR sky130_fd_sc_hd__decap_3
XFILLER_63_662 VGND VGND VPWR VPWR sky130_fd_sc_hd__decap_3
X_6832_ _8198_/Q _5337_/A _5618_/A _8262_/Q VGND VGND VPWR VPWR _6832_/X sky130_fd_sc_hd__a2bb2o_2
XTAP_TAPCELL_ROW_46_860 VGND VPWR sky130_fd_sc_hd__tapvpwrvgnd_1
XFILLER_50_312 VGND VGND VPWR VPWR sky130_fd_sc_hd__decap_3
XFILLER_23_559 VGND VGND VPWR VPWR sky130_fd_sc_hd__fill_1
XFILLER_50_345 VGND VGND VPWR VPWR sky130_fd_sc_hd__decap_3
XFILLER_62_194 VGND VGND VPWR VPWR sky130_fd_sc_hd__fill_2
XPHY_EDGE_ROW_114_Left_234 VGND VGND VPWR VPWR sky130_fd_sc_hd__decap_3
X_6763_ _6763_/A _6763_/B VGND VGND VPWR VPWR _6764_/A sky130_fd_sc_hd__or2_2
X_3975_ _3975_/A VGND VGND VPWR VPWR _7936_/D sky130_fd_sc_hd__buf_1
XFILLER_50_389 VGND VGND VPWR VPWR sky130_fd_sc_hd__fill_1
X_6694_ _6731_/A _6695_/B VGND VGND VPWR VPWR _6694_/Y sky130_fd_sc_hd__nand2_2
X_5714_ _5714_/A VGND VGND VPWR VPWR _5714_/X sky130_fd_sc_hd__clkbuf_1
X_5645_ _5449_/X _5451_/X _7555_/S VGND VGND VPWR VPWR _5645_/X sky130_fd_sc_hd__mux2_2
XFILLER_117_620 VGND VGND VPWR VPWR sky130_fd_sc_hd__decap_3
XFILLER_117_642 VGND VGND VPWR VPWR sky130_fd_sc_hd__fill_2
XFILLER_117_653 VGND VGND VPWR VPWR sky130_fd_sc_hd__fill_1
X_8364_ _8365_/CLK _8364_/D VGND VGND VPWR VPWR _8364_/Q sky130_fd_sc_hd__dfxtp_2
X_5576_ _6321_/B _5576_/B VGND VGND VPWR VPWR _5576_/X sky130_fd_sc_hd__and2b_2
XFILLER_104_303 VGND VGND VPWR VPWR sky130_fd_sc_hd__decap_3
XFILLER_116_141 VGND VGND VPWR VPWR sky130_fd_sc_hd__decap_3
X_8295_ _8385_/CLK _8295_/D VGND VGND VPWR VPWR _8295_/Q sky130_fd_sc_hd__dfxtp_2
X_7315_ _5313_/A _7312_/Y _7338_/B _6624_/A _7398_/A VGND VGND VPWR VPWR _7315_/X
+ sky130_fd_sc_hd__a221o_2
X_4527_ _4527_/A VGND VGND VPWR VPWR _8201_/D sky130_fd_sc_hd__buf_1
XFILLER_116_174 VGND VGND VPWR VPWR sky130_fd_sc_hd__fill_1
X_7246_ _8290_/Q _7237_/Y _7238_/Y _7243_/Y _7245_/X VGND VGND VPWR VPWR _7246_/X
+ sky130_fd_sc_hd__a221o_2
X_4458_ _7898_/B _8033_/Q VGND VGND VPWR VPWR _4459_/A sky130_fd_sc_hd__and2_2
XFILLER_77_209 VGND VGND VPWR VPWR sky130_fd_sc_hd__decap_3
X_7177_ _8203_/Q _8267_/Q _7167_/D _7176_/X VGND VGND VPWR VPWR _7177_/X sky130_fd_sc_hd__o211a_2
XFILLER_105_11 VGND VGND VPWR VPWR sky130_fd_sc_hd__decap_3
XFILLER_105_22 VGND VGND VPWR VPWR sky130_fd_sc_hd__fill_1
XFILLER_58_401 VGND VGND VPWR VPWR sky130_fd_sc_hd__decap_3
XFILLER_98_570 VGND VGND VPWR VPWR sky130_fd_sc_hd__decap_3
XFILLER_98_592 VGND VGND VPWR VPWR sky130_fd_sc_hd__decap_3
X_6128_ _6127_/X _5984_/X _6706_/S VGND VGND VPWR VPWR _6128_/X sky130_fd_sc_hd__mux2_2
X_4389_ _4389_/A VGND VGND VPWR VPWR _8132_/D sky130_fd_sc_hd__buf_1
XFILLER_100_531 VGND VGND VPWR VPWR sky130_fd_sc_hd__fill_1
XFILLER_58_445 VGND VGND VPWR VPWR sky130_fd_sc_hd__decap_3
XFILLER_85_231 VGND VGND VPWR VPWR sky130_fd_sc_hd__decap_3
XFILLER_100_564 VGND VGND VPWR VPWR sky130_fd_sc_hd__decap_3
XFILLER_18_309 VGND VGND VPWR VPWR sky130_fd_sc_hd__decap_3
XFILLER_46_629 VGND VGND VPWR VPWR sky130_fd_sc_hd__decap_3
XFILLER_58_489 VGND VGND VPWR VPWR sky130_fd_sc_hd__decap_3
XFILLER_65_26 VGND VGND VPWR VPWR sky130_fd_sc_hd__fill_2
XFILLER_73_415 VGND VGND VPWR VPWR sky130_fd_sc_hd__decap_3
X_6059_ _6058_/X _5916_/X _6706_/S VGND VGND VPWR VPWR _6059_/X sky130_fd_sc_hd__mux2_2
XFILLER_26_331 VGND VGND VPWR VPWR sky130_fd_sc_hd__decap_3
XFILLER_45_139 VGND VGND VPWR VPWR sky130_fd_sc_hd__decap_3
XFILLER_14_504 VGND VGND VPWR VPWR sky130_fd_sc_hd__decap_3
XFILLER_54_651 VGND VGND VPWR VPWR sky130_fd_sc_hd__fill_2
XFILLER_14_526 VGND VGND VPWR VPWR sky130_fd_sc_hd__decap_3
XFILLER_53_172 VGND VGND VPWR VPWR sky130_fd_sc_hd__decap_3
XFILLER_81_69 VGND VGND VPWR VPWR sky130_fd_sc_hd__decap_3
XFILLER_41_389 VGND VGND VPWR VPWR sky130_fd_sc_hd__decap_3
XTAP_TAPCELL_ROW_62_1062 VGND VPWR sky130_fd_sc_hd__tapvpwrvgnd_1
XTAP_TAPCELL_ROW_24_576 VGND VPWR sky130_fd_sc_hd__tapvpwrvgnd_1
XTAP_TAPCELL_ROW_24_565 VGND VPWR sky130_fd_sc_hd__tapvpwrvgnd_1
XFILLER_30_40 VGND VGND VPWR VPWR sky130_fd_sc_hd__fill_1
XFILLER_107_163 VGND VGND VPWR VPWR sky130_fd_sc_hd__decap_3
XFILLER_108_675 VGND VGND VPWR VPWR sky130_fd_sc_hd__decap_3
XTAP_TAPCELL_ROW_114_1737 VGND VPWR sky130_fd_sc_hd__tapvpwrvgnd_1
XFILLER_107_196 VGND VGND VPWR VPWR sky130_fd_sc_hd__decap_3
XFILLER_110_306 VGND VGND VPWR VPWR sky130_fd_sc_hd__fill_2
XFILLER_1_441 VGND VGND VPWR VPWR sky130_fd_sc_hd__decap_3
XFILLER_110_328 VGND VGND VPWR VPWR sky130_fd_sc_hd__decap_3
XFILLER_39_60 VGND VGND VPWR VPWR sky130_fd_sc_hd__decap_3
XFILLER_49_401 VGND VGND VPWR VPWR sky130_fd_sc_hd__decap_3
XFILLER_49_423 VGND VGND VPWR VPWR sky130_fd_sc_hd__decap_3
XFILLER_77_732 VGND VGND VPWR VPWR sky130_fd_sc_hd__fill_1
XFILLER_89_592 VGND VGND VPWR VPWR sky130_fd_sc_hd__decap_3
XFILLER_103_380 VGND VGND VPWR VPWR sky130_fd_sc_hd__decap_3
XFILLER_39_93 VGND VGND VPWR VPWR sky130_fd_sc_hd__decap_3
XFILLER_49_467 VGND VGND VPWR VPWR sky130_fd_sc_hd__decap_3
XFILLER_76_253 VGND VGND VPWR VPWR sky130_fd_sc_hd__decap_3
XFILLER_36_139 VGND VGND VPWR VPWR sky130_fd_sc_hd__fill_1
XFILLER_64_437 VGND VGND VPWR VPWR sky130_fd_sc_hd__decap_3
XFILLER_64_459 VGND VGND VPWR VPWR sky130_fd_sc_hd__decap_3
XFILLER_91_245 VGND VGND VPWR VPWR sky130_fd_sc_hd__decap_3
XFILLER_45_651 VGND VGND VPWR VPWR sky130_fd_sc_hd__decap_3
XFILLER_45_673 VGND VGND VPWR VPWR sky130_fd_sc_hd__fill_1
XFILLER_51_109 VGND VGND VPWR VPWR sky130_fd_sc_hd__decap_3
XFILLER_55_81 VGND VGND VPWR VPWR sky130_fd_sc_hd__decap_3
XFILLER_17_375 VGND VGND VPWR VPWR sky130_fd_sc_hd__decap_3
XFILLER_32_312 VGND VGND VPWR VPWR sky130_fd_sc_hd__decap_3
XFILLER_60_610 VGND VGND VPWR VPWR sky130_fd_sc_hd__decap_3
XFILLER_72_470 VGND VGND VPWR VPWR sky130_fd_sc_hd__decap_3
XFILLER_72_492 VGND VGND VPWR VPWR sky130_fd_sc_hd__decap_3
XFILLER_91_289 VGND VGND VPWR VPWR sky130_fd_sc_hd__decap_3
XFILLER_60_643 VGND VGND VPWR VPWR sky130_fd_sc_hd__fill_1
XFILLER_60_654 VGND VGND VPWR VPWR sky130_fd_sc_hd__decap_3
XFILLER_60_676 VGND VGND VPWR VPWR sky130_fd_sc_hd__decap_3
XFILLER_60_698 VGND VGND VPWR VPWR sky130_fd_sc_hd__fill_2
XFILLER_13_581 VGND VGND VPWR VPWR sky130_fd_sc_hd__decap_3
XFILLER_118_417 VGND VGND VPWR VPWR sky130_fd_sc_hd__decap_3
X_5430_ _5430_/A _5430_/B _6706_/S VGND VGND VPWR VPWR _5430_/X sky130_fd_sc_hd__and3_2
XFILLER_65_3 VGND VGND VPWR VPWR sky130_fd_sc_hd__decap_3
X_5361_ _5138_/X _5132_/X _5384_/S VGND VGND VPWR VPWR _5361_/X sky130_fd_sc_hd__mux2_2
XFILLER_113_111 VGND VGND VPWR VPWR sky130_fd_sc_hd__fill_1
XFILLER_113_122 VGND VGND VPWR VPWR sky130_fd_sc_hd__decap_3
XFILLER_114_634 VGND VGND VPWR VPWR sky130_fd_sc_hd__decap_3
XFILLER_114_645 VGND VGND VPWR VPWR sky130_fd_sc_hd__decap_3
XFILLER_99_323 VGND VGND VPWR VPWR sky130_fd_sc_hd__decap_3
X_8080_ _8218_/CLK _8080_/D VGND VGND VPWR VPWR _8080_/Q sky130_fd_sc_hd__dfxtp_2
X_7100_ _7166_/C _7100_/B VGND VGND VPWR VPWR _7100_/Y sky130_fd_sc_hd__xnor2_2
X_5292_ _5292_/A VGND VGND VPWR VPWR _5292_/X sky130_fd_sc_hd__buf_1
X_4312_ _7843_/A _4312_/B VGND VGND VPWR VPWR _4313_/A sky130_fd_sc_hd__and2_2
XFILLER_99_356 VGND VGND VPWR VPWR sky130_fd_sc_hd__decap_3
X_7031_ _7017_/B _7030_/Y _6992_/A VGND VGND VPWR VPWR _7031_/Y sky130_fd_sc_hd__a21oi_4
X_4243_ _4243_/A VGND VGND VPWR VPWR _8059_/D sky130_fd_sc_hd__buf_1
XFILLER_113_166 VGND VGND VPWR VPWR sky130_fd_sc_hd__fill_2
XFILLER_68_721 VGND VGND VPWR VPWR sky130_fd_sc_hd__fill_1
XFILLER_28_607 VGND VGND VPWR VPWR sky130_fd_sc_hd__fill_2
XFILLER_67_231 VGND VGND VPWR VPWR sky130_fd_sc_hd__decap_3
XFILLER_95_551 VGND VGND VPWR VPWR sky130_fd_sc_hd__decap_3
X_4174_ _7898_/B _7957_/Q VGND VGND VPWR VPWR _4175_/A sky130_fd_sc_hd__and2_2
XFILLER_28_618 VGND VGND VPWR VPWR sky130_fd_sc_hd__decap_3
XFILLER_67_264 VGND VGND VPWR VPWR sky130_fd_sc_hd__decap_3
XFILLER_95_584 VGND VGND VPWR VPWR sky130_fd_sc_hd__decap_3
XFILLER_27_139 VGND VGND VPWR VPWR sky130_fd_sc_hd__decap_3
XFILLER_82_212 VGND VGND VPWR VPWR sky130_fd_sc_hd__decap_3
X_7933_ _8401_/CLK _7933_/D VGND VGND VPWR VPWR _7933_/Q sky130_fd_sc_hd__dfxtp_2
XFILLER_36_640 VGND VGND VPWR VPWR sky130_fd_sc_hd__decap_3
XFILLER_36_651 VGND VGND VPWR VPWR sky130_fd_sc_hd__decap_3
XFILLER_70_407 VGND VGND VPWR VPWR sky130_fd_sc_hd__decap_3
XFILLER_82_256 VGND VGND VPWR VPWR sky130_fd_sc_hd__fill_2
XFILLER_23_323 VGND VGND VPWR VPWR sky130_fd_sc_hd__decap_3
XFILLER_35_172 VGND VGND VPWR VPWR sky130_fd_sc_hd__decap_3
XFILLER_82_289 VGND VGND VPWR VPWR sky130_fd_sc_hd__decap_3
X_7864_ _8302_/Q _7930_/B VGND VGND VPWR VPWR _7865_/A sky130_fd_sc_hd__and2_2
XFILLER_23_356 VGND VGND VPWR VPWR sky130_fd_sc_hd__decap_3
X_7795_ _7653_/X _8192_/Q _7655_/X _7793_/Y _7794_/X VGND VGND VPWR VPWR _7795_/X
+ sky130_fd_sc_hd__a311o_2
X_6815_ _6874_/C _6815_/B VGND VGND VPWR VPWR _6815_/Y sky130_fd_sc_hd__xnor2_2
XFILLER_51_17 VGND VGND VPWR VPWR sky130_fd_sc_hd__decap_3
XFILLER_51_676 VGND VGND VPWR VPWR sky130_fd_sc_hd__decap_3
X_6746_ _7193_/A _5487_/X _6354_/B _6745_/X VGND VGND VPWR VPWR _6746_/X sky130_fd_sc_hd__a31o_2
XFILLER_50_197 VGND VGND VPWR VPWR sky130_fd_sc_hd__decap_3
XFILLER_51_39 VGND VGND VPWR VPWR sky130_fd_sc_hd__decap_3
XTAP_TAPCELL_ROW_21_535 VGND VPWR sky130_fd_sc_hd__tapvpwrvgnd_1
X_6677_ _6676_/X _6616_/X _6530_/X _6451_/X _7812_/A _7670_/A VGND VGND VPWR VPWR
+ _6677_/X sky130_fd_sc_hd__mux4_2
X_5628_ _8290_/Q _5622_/X _5625_/X _5812_/A VGND VGND VPWR VPWR _5628_/X sky130_fd_sc_hd__a22o_2
X_8347_ _8352_/CLK _8347_/D VGND VGND VPWR VPWR _8347_/Q sky130_fd_sc_hd__dfxtp_2
X_5559_ _5559_/A VGND VGND VPWR VPWR _8299_/D sky130_fd_sc_hd__buf_1
XFILLER_104_100 VGND VGND VPWR VPWR sky130_fd_sc_hd__decap_3
XFILLER_104_144 VGND VGND VPWR VPWR sky130_fd_sc_hd__decap_3
XFILLER_116_21 VGND VGND VPWR VPWR sky130_fd_sc_hd__decap_3
XFILLER_116_32 VGND VGND VPWR VPWR sky130_fd_sc_hd__decap_3
X_8278_ _8280_/CLK _8278_/D VGND VGND VPWR VPWR _8278_/Q sky130_fd_sc_hd__dfxtp_2
XFILLER_59_732 VGND VGND VPWR VPWR sky130_fd_sc_hd__fill_1
XFILLER_78_529 VGND VGND VPWR VPWR sky130_fd_sc_hd__decap_3
X_7229_ _8208_/Q _8209_/Q _7229_/C VGND VGND VPWR VPWR _7283_/A sky130_fd_sc_hd__nand3_2
XFILLER_58_220 VGND VGND VPWR VPWR sky130_fd_sc_hd__decap_3
XFILLER_86_551 VGND VGND VPWR VPWR sky130_fd_sc_hd__decap_3
XFILLER_19_629 VGND VGND VPWR VPWR sky130_fd_sc_hd__fill_1
XFILLER_58_253 VGND VGND VPWR VPWR sky130_fd_sc_hd__decap_3
XFILLER_73_201 VGND VGND VPWR VPWR sky130_fd_sc_hd__decap_3
XFILLER_86_584 VGND VGND VPWR VPWR sky130_fd_sc_hd__decap_3
XFILLER_18_117 VGND VGND VPWR VPWR sky130_fd_sc_hd__decap_3
XFILLER_46_448 VGND VGND VPWR VPWR sky130_fd_sc_hd__decap_3
XFILLER_58_286 VGND VGND VPWR VPWR sky130_fd_sc_hd__decap_3
XTAP_TAPCELL_ROW_29_635 VGND VPWR sky130_fd_sc_hd__tapvpwrvgnd_1
XFILLER_73_245 VGND VGND VPWR VPWR sky130_fd_sc_hd__decap_3
XFILLER_73_267 VGND VGND VPWR VPWR sky130_fd_sc_hd__decap_3
XFILLER_14_312 VGND VGND VPWR VPWR sky130_fd_sc_hd__decap_3
XFILLER_27_673 VGND VGND VPWR VPWR sky130_fd_sc_hd__decap_3
XFILLER_54_470 VGND VGND VPWR VPWR sky130_fd_sc_hd__decap_3
XFILLER_61_429 VGND VGND VPWR VPWR sky130_fd_sc_hd__fill_1
XTAP_TAPCELL_ROW_57_999 VGND VPWR sky130_fd_sc_hd__tapvpwrvgnd_1
XTAP_TAPCELL_ROW_1_271 VGND VPWR sky130_fd_sc_hd__tapvpwrvgnd_1
XFILLER_14_334 VGND VGND VPWR VPWR sky130_fd_sc_hd__fill_2
XFILLER_42_654 VGND VGND VPWR VPWR sky130_fd_sc_hd__decap_3
XFILLER_54_492 VGND VGND VPWR VPWR sky130_fd_sc_hd__decap_3
XFILLER_25_73 VGND VGND VPWR VPWR sky130_fd_sc_hd__decap_3
XFILLER_41_164 VGND VGND VPWR VPWR sky130_fd_sc_hd__decap_3
XFILLER_108_461 VGND VGND VPWR VPWR sky130_fd_sc_hd__decap_3
XFILLER_108_483 VGND VGND VPWR VPWR sky130_fd_sc_hd__decap_3
XTAP_TAPCELL_ROW_75_1231 VGND VPWR sky130_fd_sc_hd__tapvpwrvgnd_1
XFILLER_111_626 VGND VGND VPWR VPWR sky130_fd_sc_hd__fill_2
XFILLER_96_337 VGND VGND VPWR VPWR sky130_fd_sc_hd__fill_1
XTAP_TAPCELL_ROW_9_382 VGND VPWR sky130_fd_sc_hd__tapvpwrvgnd_1
XTAP_TAPCELL_ROW_9_371 VGND VPWR sky130_fd_sc_hd__tapvpwrvgnd_1
XFILLER_110_136 VGND VGND VPWR VPWR sky130_fd_sc_hd__decap_3
XFILLER_49_242 VGND VGND VPWR VPWR sky130_fd_sc_hd__decap_3
XFILLER_77_540 VGND VGND VPWR VPWR sky130_fd_sc_hd__fill_2
XFILLER_2_77 VGND VGND VPWR VPWR sky130_fd_sc_hd__decap_3
XFILLER_2_88 VGND VGND VPWR VPWR sky130_fd_sc_hd__decap_3
XFILLER_52_407 VGND VGND VPWR VPWR sky130_fd_sc_hd__decap_3
XFILLER_64_267 VGND VGND VPWR VPWR sky130_fd_sc_hd__decap_3
XFILLER_66_91 VGND VGND VPWR VPWR sky130_fd_sc_hd__decap_3
XFILLER_17_172 VGND VGND VPWR VPWR sky130_fd_sc_hd__decap_3
XFILLER_45_481 VGND VGND VPWR VPWR sky130_fd_sc_hd__decap_3
XFILLER_80_727 VGND VGND VPWR VPWR sky130_fd_sc_hd__decap_3
X_4930_ _6024_/A _8238_/Q VGND VGND VPWR VPWR _6039_/C sky130_fd_sc_hd__and2b_2
XTAP_TAPCELL_ROW_86_1382 VGND VPWR sky130_fd_sc_hd__tapvpwrvgnd_1
XTAP_TAPCELL_ROW_86_1371 VGND VPWR sky130_fd_sc_hd__tapvpwrvgnd_1
XFILLER_33_665 VGND VGND VPWR VPWR sky130_fd_sc_hd__decap_3
XFILLER_60_440 VGND VGND VPWR VPWR sky130_fd_sc_hd__fill_2
X_4861_ _4861_/A _8252_/Q VGND VGND VPWR VPWR _4864_/A sky130_fd_sc_hd__nor2_2
XFILLER_20_315 VGND VGND VPWR VPWR sky130_fd_sc_hd__decap_3
XFILLER_33_676 VGND VGND VPWR VPWR sky130_fd_sc_hd__fill_2
X_6600_ _6371_/X _6409_/X _6593_/X _6599_/B VGND VGND VPWR VPWR _6600_/X sky130_fd_sc_hd__a31o_2
XANTENNA_16 _7631_/A VGND VGND VPWR VPWR sky130_fd_sc_hd__diode_2
XANTENNA_27 _8182_/Q VGND VGND VPWR VPWR sky130_fd_sc_hd__diode_2
XFILLER_119_704 VGND VGND VPWR VPWR sky130_fd_sc_hd__decap_3
XFILLER_32_197 VGND VGND VPWR VPWR sky130_fd_sc_hd__decap_3
X_7580_ _7588_/A _7836_/B VGND VGND VPWR VPWR _7580_/X sky130_fd_sc_hd__xor2_2
X_4792_ _8205_/Q VGND VGND VPWR VPWR _7044_/B sky130_fd_sc_hd__inv_2
X_6531_ _6530_/X _6451_/X _6380_/X _6322_/X _7812_/A _7670_/A VGND VGND VPWR VPWR
+ _6531_/X sky130_fd_sc_hd__mux4_2
XFILLER_9_382 VGND VGND VPWR VPWR sky130_fd_sc_hd__decap_3
XFILLER_9_393 VGND VGND VPWR VPWR sky130_fd_sc_hd__decap_3
X_6462_ _6462_/A _6462_/B _6462_/C VGND VGND VPWR VPWR _6462_/X sky130_fd_sc_hd__or3_2
X_8201_ _8207_/CLK _8201_/D VGND VGND VPWR VPWR _8201_/Q sky130_fd_sc_hd__dfxtp_2
X_6393_ _6393_/A _6393_/B VGND VGND VPWR VPWR _6394_/C sky130_fd_sc_hd__or2_2
X_5413_ _5407_/X _5412_/Y _5417_/A VGND VGND VPWR VPWR _5413_/X sky130_fd_sc_hd__mux2_2
X_8132_ _8269_/CLK _8132_/D VGND VGND VPWR VPWR _8132_/Q sky130_fd_sc_hd__dfxtp_2
X_5344_ _5396_/A _5411_/B _5339_/Y _5343_/Y VGND VGND VPWR VPWR _5344_/X sky130_fd_sc_hd__a31o_2
XFILLER_102_604 VGND VGND VPWR VPWR sky130_fd_sc_hd__decap_3
XFILLER_114_431 VGND VGND VPWR VPWR sky130_fd_sc_hd__decap_3
Xoutput167 _7993_/Q VGND VGND VPWR VPWR result[35] sky130_fd_sc_hd__clkdlybuf4s25_1
Xoutput156 _7983_/Q VGND VGND VPWR VPWR result[25] sky130_fd_sc_hd__clkdlybuf4s25_1
Xoutput145 _7973_/Q VGND VGND VPWR VPWR result[15] sky130_fd_sc_hd__clkdlybuf4s25_1
XFILLER_114_486 VGND VGND VPWR VPWR sky130_fd_sc_hd__decap_3
XFILLER_87_315 VGND VGND VPWR VPWR sky130_fd_sc_hd__decap_3
X_8063_ clkload4/A _8063_/D VGND VGND VPWR VPWR _8063_/Q sky130_fd_sc_hd__dfxtp_2
Xoutput189 _8013_/Q VGND VGND VPWR VPWR result[55] sky130_fd_sc_hd__clkdlybuf4s25_1
Xoutput178 _8003_/Q VGND VGND VPWR VPWR result[45] sky130_fd_sc_hd__clkdlybuf4s25_1
X_5275_ _6130_/B _5488_/B VGND VGND VPWR VPWR _5276_/A sky130_fd_sc_hd__nand2_2
XFILLER_101_125 VGND VGND VPWR VPWR sky130_fd_sc_hd__decap_3
XFILLER_101_147 VGND VGND VPWR VPWR sky130_fd_sc_hd__decap_3
XFILLER_102_648 VGND VGND VPWR VPWR sky130_fd_sc_hd__fill_1
XFILLER_99_197 VGND VGND VPWR VPWR sky130_fd_sc_hd__decap_3
X_7014_ _8267_/Q _6970_/X _8203_/Q VGND VGND VPWR VPWR _7014_/X sky130_fd_sc_hd__o21ba_4
X_4226_ _7898_/B _4226_/B VGND VGND VPWR VPWR _4227_/A sky130_fd_sc_hd__and2_2
XFILLER_101_169 VGND VGND VPWR VPWR sky130_fd_sc_hd__decap_3
XFILLER_28_404 VGND VGND VPWR VPWR sky130_fd_sc_hd__decap_3
XFILLER_56_713 VGND VGND VPWR VPWR sky130_fd_sc_hd__decap_3
XFILLER_68_551 VGND VGND VPWR VPWR sky130_fd_sc_hd__decap_3
X_4157_ _4157_/A VGND VGND VPWR VPWR _8016_/D sky130_fd_sc_hd__buf_1
XFILLER_46_17 VGND VGND VPWR VPWR sky130_fd_sc_hd__decap_3
XFILLER_95_370 VGND VGND VPWR VPWR sky130_fd_sc_hd__decap_3
XFILLER_71_716 VGND VGND VPWR VPWR sky130_fd_sc_hd__fill_1
XFILLER_83_554 VGND VGND VPWR VPWR sky130_fd_sc_hd__decap_3
X_4088_ _7930_/B _8385_/Q VGND VGND VPWR VPWR _4089_/A sky130_fd_sc_hd__and2_2
XFILLER_24_610 VGND VGND VPWR VPWR sky130_fd_sc_hd__decap_3
XFILLER_55_278 VGND VGND VPWR VPWR sky130_fd_sc_hd__fill_2
XFILLER_70_215 VGND VGND VPWR VPWR sky130_fd_sc_hd__decap_3
X_7916_ _8328_/Q _7930_/B VGND VGND VPWR VPWR _7917_/A sky130_fd_sc_hd__and2_2
XFILLER_102_56 VGND VGND VPWR VPWR sky130_fd_sc_hd__decap_3
XFILLER_70_248 VGND VGND VPWR VPWR sky130_fd_sc_hd__decap_3
XFILLER_70_259 VGND VGND VPWR VPWR sky130_fd_sc_hd__decap_3
X_7847_ _7847_/A VGND VGND VPWR VPWR _8360_/D sky130_fd_sc_hd__buf_1
XTAP_TAPCELL_ROW_54_958 VGND VPWR sky130_fd_sc_hd__tapvpwrvgnd_1
XFILLER_23_153 VGND VGND VPWR VPWR sky130_fd_sc_hd__decap_3
XFILLER_51_473 VGND VGND VPWR VPWR sky130_fd_sc_hd__decap_3
XFILLER_62_38 VGND VGND VPWR VPWR sky130_fd_sc_hd__decap_3
XFILLER_11_326 VGND VGND VPWR VPWR sky130_fd_sc_hd__decap_3
XFILLER_11_337 VGND VGND VPWR VPWR sky130_fd_sc_hd__fill_1
XFILLER_23_175 VGND VGND VPWR VPWR sky130_fd_sc_hd__decap_3
X_7778_ _5684_/S _7747_/A _7776_/Y _7777_/Y VGND VGND VPWR VPWR _7778_/X sky130_fd_sc_hd__a31o_2
XFILLER_109_214 VGND VGND VPWR VPWR sky130_fd_sc_hd__decap_3
Xwire239 _5080_/X VGND VGND VPWR VPWR _7776_/A sky130_fd_sc_hd__buf_6
X_6729_ _8192_/Q _8256_/Q _8258_/Q _6601_/X _6727_/C VGND VGND VPWR VPWR _6729_/X
+ sky130_fd_sc_hd__o2111a_2
XFILLER_109_225 VGND VGND VPWR VPWR sky130_fd_sc_hd__decap_3
XFILLER_109_258 VGND VGND VPWR VPWR sky130_fd_sc_hd__decap_3
XFILLER_11_53 VGND VGND VPWR VPWR sky130_fd_sc_hd__decap_3
XTAP_TAPCELL_ROW_111_1707 VGND VPWR sky130_fd_sc_hd__tapvpwrvgnd_1
XFILLER_105_497 VGND VGND VPWR VPWR sky130_fd_sc_hd__decap_3
XFILLER_78_315 VGND VGND VPWR VPWR sky130_fd_sc_hd__decap_3
XFILLER_78_348 VGND VGND VPWR VPWR sky130_fd_sc_hd__decap_3
XTAP_TAPCELL_ROW_6_341 VGND VPWR sky130_fd_sc_hd__tapvpwrvgnd_1
XFILLER_93_307 VGND VGND VPWR VPWR sky130_fd_sc_hd__decap_3
XTAP_TAPCELL_ROW_70_1172 VGND VPWR sky130_fd_sc_hd__tapvpwrvgnd_1
XFILLER_101_670 VGND VGND VPWR VPWR sky130_fd_sc_hd__fill_2
XFILLER_19_415 VGND VGND VPWR VPWR sky130_fd_sc_hd__fill_1
XFILLER_19_426 VGND VGND VPWR VPWR sky130_fd_sc_hd__decap_3
XFILLER_86_392 VGND VGND VPWR VPWR sky130_fd_sc_hd__decap_3
XFILLER_100_191 VGND VGND VPWR VPWR sky130_fd_sc_hd__decap_3
XFILLER_46_256 VGND VGND VPWR VPWR sky130_fd_sc_hd__fill_2
XFILLER_74_565 VGND VGND VPWR VPWR sky130_fd_sc_hd__decap_3
XFILLER_27_470 VGND VGND VPWR VPWR sky130_fd_sc_hd__decap_3
XFILLER_46_289 VGND VGND VPWR VPWR sky130_fd_sc_hd__decap_3
XFILLER_14_120 VGND VGND VPWR VPWR sky130_fd_sc_hd__decap_3
XFILLER_36_94 VGND VGND VPWR VPWR sky130_fd_sc_hd__fill_2
XFILLER_61_259 VGND VGND VPWR VPWR sky130_fd_sc_hd__decap_3
XFILLER_14_153 VGND VGND VPWR VPWR sky130_fd_sc_hd__decap_3
XFILLER_15_676 VGND VGND VPWR VPWR sky130_fd_sc_hd__decap_3
XFILLER_14_197 VGND VGND VPWR VPWR sky130_fd_sc_hd__decap_3
XFILLER_30_624 VGND VGND VPWR VPWR sky130_fd_sc_hd__decap_3
XFILLER_42_484 VGND VGND VPWR VPWR sky130_fd_sc_hd__fill_1
XFILLER_30_657 VGND VGND VPWR VPWR sky130_fd_sc_hd__decap_3
Xinput36 operand_a[37] VGND VGND VPWR VPWR _4250_/B sky130_fd_sc_hd__clkdlybuf4s25_1
Xinput25 operand_a[27] VGND VGND VPWR VPWR _4230_/B sky130_fd_sc_hd__clkdlybuf4s25_1
Xinput14 operand_a[17] VGND VGND VPWR VPWR _4210_/B sky130_fd_sc_hd__clkdlybuf4s25_1
XFILLER_116_707 VGND VGND VPWR VPWR sky130_fd_sc_hd__decap_3
XFILLER_6_330 VGND VGND VPWR VPWR sky130_fd_sc_hd__fill_2
XFILLER_6_341 VGND VGND VPWR VPWR sky130_fd_sc_hd__decap_3
Xinput69 operand_a[9] VGND VGND VPWR VPWR _4194_/B sky130_fd_sc_hd__clkdlybuf4s25_1
Xinput58 operand_a[57] VGND VGND VPWR VPWR _4290_/B sky130_fd_sc_hd__clkdlybuf4s25_1
Xinput47 operand_a[47] VGND VGND VPWR VPWR _4270_/B sky130_fd_sc_hd__clkdlybuf4s25_1
XFILLER_115_228 VGND VGND VPWR VPWR sky130_fd_sc_hd__decap_3
XFILLER_6_374 VGND VGND VPWR VPWR sky130_fd_sc_hd__decap_3
XFILLER_97_602 VGND VGND VPWR VPWR sky130_fd_sc_hd__fill_1
XFILLER_111_412 VGND VGND VPWR VPWR sky130_fd_sc_hd__decap_3
XFILLER_96_112 VGND VGND VPWR VPWR sky130_fd_sc_hd__fill_2
XFILLER_97_635 VGND VGND VPWR VPWR sky130_fd_sc_hd__decap_3
XFILLER_69_337 VGND VGND VPWR VPWR sky130_fd_sc_hd__fill_2
XFILLER_97_668 VGND VGND VPWR VPWR sky130_fd_sc_hd__decap_3
X_5060_ _8270_/Q _5058_/Y _5059_/X VGND VGND VPWR VPWR _5061_/B sky130_fd_sc_hd__a21oi_2
XFILLER_84_307 VGND VGND VPWR VPWR sky130_fd_sc_hd__fill_1
XFILLER_84_318 VGND VGND VPWR VPWR sky130_fd_sc_hd__decap_3
X_4011_ _8335_/Q _8334_/Q _8337_/Q _4011_/D VGND VGND VPWR VPWR _4033_/A sky130_fd_sc_hd__or4_2
XTAP_TAPCELL_ROW_88_1400 VGND VPWR sky130_fd_sc_hd__tapvpwrvgnd_1
XFILLER_96_189 VGND VGND VPWR VPWR sky130_fd_sc_hd__decap_3
XFILLER_37_234 VGND VGND VPWR VPWR sky130_fd_sc_hd__decap_3
XFILLER_92_340 VGND VGND VPWR VPWR sky130_fd_sc_hd__decap_3
XFILLER_65_598 VGND VGND VPWR VPWR sky130_fd_sc_hd__fill_2
XFILLER_80_524 VGND VGND VPWR VPWR sky130_fd_sc_hd__decap_3
X_5962_ _5528_/A _5955_/Y _5959_/Y _5961_/Y VGND VGND VPWR VPWR _5963_/C sky130_fd_sc_hd__a22o_2
XFILLER_52_259 VGND VGND VPWR VPWR sky130_fd_sc_hd__decap_3
XFILLER_80_557 VGND VGND VPWR VPWR sky130_fd_sc_hd__decap_3
XFILLER_92_395 VGND VGND VPWR VPWR sky130_fd_sc_hd__decap_3
X_7701_ _5950_/A _7699_/Y _7700_/Y _7796_/A VGND VGND VPWR VPWR _7701_/X sky130_fd_sc_hd__a22o_2
X_4913_ _8179_/Q _4913_/B VGND VGND VPWR VPWR _6394_/B sky130_fd_sc_hd__nor2_2
XFILLER_33_473 VGND VGND VPWR VPWR sky130_fd_sc_hd__decap_3
X_5893_ _5662_/X _5925_/B _5925_/C _5892_/X VGND VGND VPWR VPWR _5894_/B sky130_fd_sc_hd__a31o_2
XTAP_TAPCELL_ROW_51_928 VGND VPWR sky130_fd_sc_hd__tapvpwrvgnd_1
XTAP_TAPCELL_ROW_51_917 VGND VPWR sky130_fd_sc_hd__tapvpwrvgnd_1
XFILLER_20_123 VGND VGND VPWR VPWR sky130_fd_sc_hd__decap_3
XFILLER_60_292 VGND VGND VPWR VPWR sky130_fd_sc_hd__decap_3
X_7632_ _7633_/B _4991_/Y _7541_/A VGND VGND VPWR VPWR _7632_/X sky130_fd_sc_hd__a21o_2
X_4844_ _8257_/Q _8193_/Q VGND VGND VPWR VPWR _4845_/B sky130_fd_sc_hd__nand2b_2
XFILLER_119_501 VGND VGND VPWR VPWR sky130_fd_sc_hd__decap_3
XFILLER_20_156 VGND VGND VPWR VPWR sky130_fd_sc_hd__decap_3
X_7563_ _7563_/A _7563_/B VGND VGND VPWR VPWR _7563_/Y sky130_fd_sc_hd__nand2_2
X_4775_ _8208_/Q _7222_/B VGND VGND VPWR VPWR _4776_/B sky130_fd_sc_hd__or2_2
Xrebuffer917 rebuffer933/X VGND VGND VPWR VPWR _7314_/A2 sky130_fd_sc_hd__buf_6
X_6514_ _6509_/X _6511_/X _6513_/X _5464_/A VGND VGND VPWR VPWR _6514_/X sky130_fd_sc_hd__o22a_2
XTAP_TAPCELL_ROW_99_1551 VGND VPWR sky130_fd_sc_hd__tapvpwrvgnd_1
XTAP_TAPCELL_ROW_99_1540 VGND VPWR sky130_fd_sc_hd__tapvpwrvgnd_1
XTAP_TAPCELL_ROW_31_663 VGND VPWR sky130_fd_sc_hd__tapvpwrvgnd_1
XFILLER_106_206 VGND VGND VPWR VPWR sky130_fd_sc_hd__decap_3
XFILLER_107_729 VGND VGND VPWR VPWR sky130_fd_sc_hd__decap_3
XFILLER_119_589 VGND VGND VPWR VPWR sky130_fd_sc_hd__decap_3
X_7494_ _7497_/A _7494_/B VGND VGND VPWR VPWR _7494_/X sky130_fd_sc_hd__xor2_2
XFILLER_106_239 VGND VGND VPWR VPWR sky130_fd_sc_hd__decap_3
X_6445_ _6445_/A1 _6439_/X _6443_/Y _6804_/A _4877_/B VGND VGND VPWR VPWR _6445_/X
+ sky130_fd_sc_hd__o221a_2
X_6376_ _8289_/Q _6372_/X _6375_/X _6769_/B VGND VGND VPWR VPWR _6376_/X sky130_fd_sc_hd__o2bb2a_2
XFILLER_102_401 VGND VGND VPWR VPWR sky130_fd_sc_hd__decap_3
X_8115_ _8382_/CLK _8115_/D VGND VGND VPWR VPWR _8115_/Q sky130_fd_sc_hd__dfxtp_2
X_5327_ _5319_/A _5615_/A split/X VGND VGND VPWR VPWR _5327_/X sky130_fd_sc_hd__mux2_2
XFILLER_102_445 VGND VGND VPWR VPWR sky130_fd_sc_hd__decap_3
XFILLER_114_283 VGND VGND VPWR VPWR sky130_fd_sc_hd__fill_1
X_8046_ clkload9/A _8046_/D VGND VGND VPWR VPWR _8046_/Q sky130_fd_sc_hd__dfxtp_2
XFILLER_29_702 VGND VGND VPWR VPWR sky130_fd_sc_hd__decap_3
XFILLER_57_27 VGND VGND VPWR VPWR sky130_fd_sc_hd__decap_3
X_5258_ _5256_/X _5257_/X _7653_/A VGND VGND VPWR VPWR _5258_/X sky130_fd_sc_hd__mux2_2
XTAP_TAPCELL_ROW_3_300 VGND VPWR sky130_fd_sc_hd__tapvpwrvgnd_1
XFILLER_102_489 VGND VGND VPWR VPWR sky130_fd_sc_hd__decap_3
XFILLER_75_329 VGND VGND VPWR VPWR sky130_fd_sc_hd__decap_3
X_5189_ _4716_/X _4718_/X _7844_/A _5188_/X VGND VGND VPWR VPWR _8294_/D sky130_fd_sc_hd__a211oi_2
X_4209_ _4209_/A VGND VGND VPWR VPWR _8042_/D sky130_fd_sc_hd__buf_1
XFILLER_113_33 VGND VGND VPWR VPWR sky130_fd_sc_hd__decap_3
XFILLER_28_234 VGND VGND VPWR VPWR sky130_fd_sc_hd__decap_3
XFILLER_113_77 VGND VGND VPWR VPWR sky130_fd_sc_hd__decap_3
XFILLER_16_407 VGND VGND VPWR VPWR sky130_fd_sc_hd__decap_3
XFILLER_16_418 VGND VGND VPWR VPWR sky130_fd_sc_hd__fill_2
XFILLER_83_373 VGND VGND VPWR VPWR sky130_fd_sc_hd__decap_3
XTAP_TAPCELL_ROW_39_763 VGND VPWR sky130_fd_sc_hd__tapvpwrvgnd_1
XFILLER_113_99 VGND VGND VPWR VPWR sky130_fd_sc_hd__decap_3
XFILLER_73_48 VGND VGND VPWR VPWR sky130_fd_sc_hd__decap_3
XFILLER_24_462 VGND VGND VPWR VPWR sky130_fd_sc_hd__fill_1
XFILLER_71_579 VGND VGND VPWR VPWR sky130_fd_sc_hd__decap_3
XFILLER_24_495 VGND VGND VPWR VPWR sky130_fd_sc_hd__decap_3
XFILLER_51_281 VGND VGND VPWR VPWR sky130_fd_sc_hd__decap_3
XFILLER_11_145 VGND VGND VPWR VPWR sky130_fd_sc_hd__decap_3
XFILLER_8_617 VGND VGND VPWR VPWR sky130_fd_sc_hd__decap_3
XFILLER_7_116 VGND VGND VPWR VPWR sky130_fd_sc_hd__decap_3
XFILLER_7_138 VGND VGND VPWR VPWR sky130_fd_sc_hd__decap_3
XFILLER_20_690 VGND VGND VPWR VPWR sky130_fd_sc_hd__decap_3
XFILLER_22_85 VGND VGND VPWR VPWR sky130_fd_sc_hd__decap_3
XTAP_TAPCELL_ROW_59_1023 VGND VPWR sky130_fd_sc_hd__tapvpwrvgnd_1
XTAP_TAPCELL_ROW_72_1201 VGND VPWR sky130_fd_sc_hd__tapvpwrvgnd_1
XFILLER_3_366 VGND VGND VPWR VPWR sky130_fd_sc_hd__decap_3
XFILLER_105_272 VGND VGND VPWR VPWR sky130_fd_sc_hd__decap_3
XFILLER_66_318 VGND VGND VPWR VPWR sky130_fd_sc_hd__decap_3
XFILLER_78_178 VGND VGND VPWR VPWR sky130_fd_sc_hd__decap_3
XFILLER_79_679 VGND VGND VPWR VPWR sky130_fd_sc_hd__decap_3
XFILLER_94_627 VGND VGND VPWR VPWR sky130_fd_sc_hd__decap_3
XFILLER_19_201 VGND VGND VPWR VPWR sky130_fd_sc_hd__decap_3
XFILLER_93_137 VGND VGND VPWR VPWR sky130_fd_sc_hd__fill_2
XFILLER_47_543 VGND VGND VPWR VPWR sky130_fd_sc_hd__decap_3
XFILLER_74_351 VGND VGND VPWR VPWR sky130_fd_sc_hd__decap_3
XFILLER_47_576 VGND VGND VPWR VPWR sky130_fd_sc_hd__decap_3
XFILLER_74_395 VGND VGND VPWR VPWR sky130_fd_sc_hd__decap_3
XTAP_TAPCELL_ROW_83_1341 VGND VPWR sky130_fd_sc_hd__tapvpwrvgnd_1
XTAP_TAPCELL_ROW_17_479 VGND VPWR sky130_fd_sc_hd__tapvpwrvgnd_1
XFILLER_30_421 VGND VGND VPWR VPWR sky130_fd_sc_hd__decap_3
XFILLER_63_81 VGND VGND VPWR VPWR sky130_fd_sc_hd__decap_3
XFILLER_30_443 VGND VGND VPWR VPWR sky130_fd_sc_hd__decap_3
XFILLER_8_76 VGND VGND VPWR VPWR sky130_fd_sc_hd__fill_1
X_4560_ _7843_/A _8084_/Q VGND VGND VPWR VPWR _4561_/A sky130_fd_sc_hd__and2_2
XFILLER_7_694 VGND VGND VPWR VPWR sky130_fd_sc_hd__fill_1
X_4491_ _4491_/A VGND VGND VPWR VPWR _8183_/D sky130_fd_sc_hd__buf_1
XFILLER_116_548 VGND VGND VPWR VPWR sky130_fd_sc_hd__decap_3
X_6230_ _5587_/X _6228_/X _6229_/X _5108_/X VGND VGND VPWR VPWR _6230_/X sky130_fd_sc_hd__a22o_2
XFILLER_69_101 VGND VGND VPWR VPWR sky130_fd_sc_hd__fill_2
X_6161_ _5278_/X _6297_/C _6160_/Y VGND VGND VPWR VPWR _6161_/Y sky130_fd_sc_hd__a21oi_2
XTAP_TAPCELL_ROW_94_1481 VGND VPWR sky130_fd_sc_hd__tapvpwrvgnd_1
XFILLER_112_732 VGND VGND VPWR VPWR sky130_fd_sc_hd__fill_1
XFILLER_97_421 VGND VGND VPWR VPWR sky130_fd_sc_hd__fill_1
XFILLER_97_432 VGND VGND VPWR VPWR sky130_fd_sc_hd__decap_3
X_5112_ _6571_/B _5488_/B _5290_/A _4718_/B _5111_/X VGND VGND VPWR VPWR _5113_/B
+ sky130_fd_sc_hd__a221o_2
XFILLER_111_231 VGND VGND VPWR VPWR sky130_fd_sc_hd__decap_3
XFILLER_69_156 VGND VGND VPWR VPWR sky130_fd_sc_hd__decap_3
XFILLER_97_476 VGND VGND VPWR VPWR sky130_fd_sc_hd__decap_3
X_6092_ _6769_/B _6088_/X _6091_/X _8289_/Q VGND VGND VPWR VPWR _6092_/X sky130_fd_sc_hd__a2bb2o_2
XFILLER_111_297 VGND VGND VPWR VPWR sky130_fd_sc_hd__decap_3
XFILLER_69_178 VGND VGND VPWR VPWR sky130_fd_sc_hd__decap_3
XFILLER_84_137 VGND VGND VPWR VPWR sky130_fd_sc_hd__decap_3
X_5043_ _8246_/Q _5042_/X _6257_/B1_N VGND VGND VPWR VPWR _5043_/X sky130_fd_sc_hd__o21ba_2
XFILLER_38_554 VGND VGND VPWR VPWR sky130_fd_sc_hd__decap_3
XFILLER_65_340 VGND VGND VPWR VPWR sky130_fd_sc_hd__decap_3
XFILLER_38_576 VGND VGND VPWR VPWR sky130_fd_sc_hd__decap_3
XFILLER_25_248 VGND VGND VPWR VPWR sky130_fd_sc_hd__decap_3
X_6994_ _4813_/B _6994_/A2 _6993_/X VGND VGND VPWR VPWR _7027_/B sky130_fd_sc_hd__a21oi_2
XTAP_TAPCELL_ROW_36_733 VGND VPWR sky130_fd_sc_hd__tapvpwrvgnd_1
XTAP_TAPCELL_ROW_36_722 VGND VPWR sky130_fd_sc_hd__tapvpwrvgnd_1
XFILLER_80_365 VGND VGND VPWR VPWR sky130_fd_sc_hd__decap_3
X_5945_ _7264_/A _6825_/A VGND VGND VPWR VPWR _5946_/B sky130_fd_sc_hd__nor2_2
XFILLER_33_281 VGND VGND VPWR VPWR sky130_fd_sc_hd__fill_2
X_5876_ _5876_/A _5876_/B VGND VGND VPWR VPWR _5876_/Y sky130_fd_sc_hd__xnor2_2
X_7615_ _7619_/A _8287_/Q VGND VGND VPWR VPWR _7615_/Y sky130_fd_sc_hd__nor2_2
X_4827_ _8197_/Q _4827_/B VGND VGND VPWR VPWR _5004_/A sky130_fd_sc_hd__and2_2
XFILLER_21_465 VGND VGND VPWR VPWR sky130_fd_sc_hd__decap_3
XFILLER_21_498 VGND VGND VPWR VPWR sky130_fd_sc_hd__decap_3
X_7546_ _8284_/Q _7522_/B _7545_/X VGND VGND VPWR VPWR _7547_/B sky130_fd_sc_hd__a21bo_2
Xrebuffer736 _5310_/B VGND VGND VPWR VPWR _6199_/S1 sky130_fd_sc_hd__buf_2
X_4758_ _7319_/A _8277_/Q VGND VGND VPWR VPWR _7366_/B sky130_fd_sc_hd__and2_2
X_7477_ _4749_/A _7473_/X _7476_/X VGND VGND VPWR VPWR _7483_/A sky130_fd_sc_hd__o21a_2
X_4689_ _4689_/A VGND VGND VPWR VPWR _8282_/D sky130_fd_sc_hd__buf_1
XFILLER_107_548 VGND VGND VPWR VPWR sky130_fd_sc_hd__decap_3
X_6428_ _5477_/X _6427_/X _6355_/X _5441_/X VGND VGND VPWR VPWR _6428_/X sky130_fd_sc_hd__o2bb2a_2
XFILLER_88_432 VGND VGND VPWR VPWR sky130_fd_sc_hd__decap_3
X_6359_ _8248_/Q _6359_/B VGND VGND VPWR VPWR _6359_/X sky130_fd_sc_hd__or2_2
XFILLER_102_253 VGND VGND VPWR VPWR sky130_fd_sc_hd__fill_2
XFILLER_48_307 VGND VGND VPWR VPWR sky130_fd_sc_hd__fill_1
XFILLER_102_275 VGND VGND VPWR VPWR sky130_fd_sc_hd__decap_3
X_8029_ _8224_/CLK _8029_/D VGND VGND VPWR VPWR _8029_/Q sky130_fd_sc_hd__dfxtp_2
XFILLER_75_148 VGND VGND VPWR VPWR sky130_fd_sc_hd__decap_3
XFILLER_84_14 VGND VGND VPWR VPWR sky130_fd_sc_hd__decap_3
XFILLER_16_215 VGND VGND VPWR VPWR sky130_fd_sc_hd__decap_3
XFILLER_29_587 VGND VGND VPWR VPWR sky130_fd_sc_hd__decap_3
XFILLER_44_513 VGND VGND VPWR VPWR sky130_fd_sc_hd__decap_3
XFILLER_44_524 VGND VGND VPWR VPWR sky130_fd_sc_hd__decap_3
XFILLER_56_351 VGND VGND VPWR VPWR sky130_fd_sc_hd__fill_2
XFILLER_84_660 VGND VGND VPWR VPWR sky130_fd_sc_hd__fill_2
XFILLER_16_248 VGND VGND VPWR VPWR sky130_fd_sc_hd__decap_3
XFILLER_56_395 VGND VGND VPWR VPWR sky130_fd_sc_hd__decap_3
XTAP_TAPCELL_ROW_106_1639 VGND VPWR sky130_fd_sc_hd__tapvpwrvgnd_1
XFILLER_16_259 VGND VGND VPWR VPWR sky130_fd_sc_hd__decap_3
XFILLER_71_376 VGND VGND VPWR VPWR sky130_fd_sc_hd__decap_3
XFILLER_12_410 VGND VGND VPWR VPWR sky130_fd_sc_hd__decap_3
XFILLER_12_421 VGND VGND VPWR VPWR sky130_fd_sc_hd__decap_3
XFILLER_12_454 VGND VGND VPWR VPWR sky130_fd_sc_hd__decap_3
XFILLER_33_40 VGND VGND VPWR VPWR sky130_fd_sc_hd__decap_3
XTAP_TAPCELL_ROW_14_438 VGND VPWR sky130_fd_sc_hd__tapvpwrvgnd_1
XFILLER_12_487 VGND VGND VPWR VPWR sky130_fd_sc_hd__fill_1
XFILLER_8_436 VGND VGND VPWR VPWR sky130_fd_sc_hd__decap_3
XTAP_TAPCELL_ROW_117_1779 VGND VPWR sky130_fd_sc_hd__tapvpwrvgnd_1
XFILLER_113_518 VGND VGND VPWR VPWR sky130_fd_sc_hd__decap_3
XFILLER_3_152 VGND VGND VPWR VPWR sky130_fd_sc_hd__decap_3
XFILLER_106_581 VGND VGND VPWR VPWR sky130_fd_sc_hd__decap_3
XFILLER_3_196 VGND VGND VPWR VPWR sky130_fd_sc_hd__decap_3
XFILLER_79_410 VGND VGND VPWR VPWR sky130_fd_sc_hd__decap_3
XFILLER_79_498 VGND VGND VPWR VPWR sky130_fd_sc_hd__decap_3
XFILLER_94_413 VGND VGND VPWR VPWR sky130_fd_sc_hd__decap_3
XFILLER_94_424 VGND VGND VPWR VPWR sky130_fd_sc_hd__decap_3
XFILLER_47_340 VGND VGND VPWR VPWR sky130_fd_sc_hd__decap_3
XFILLER_66_137 VGND VGND VPWR VPWR sky130_fd_sc_hd__decap_3
XFILLER_94_468 VGND VGND VPWR VPWR sky130_fd_sc_hd__decap_3
XFILLER_75_682 VGND VGND VPWR VPWR sky130_fd_sc_hd__decap_3
XFILLER_81_107 VGND VGND VPWR VPWR sky130_fd_sc_hd__decap_3
XFILLER_47_384 VGND VGND VPWR VPWR sky130_fd_sc_hd__decap_3
XFILLER_62_321 VGND VGND VPWR VPWR sky130_fd_sc_hd__decap_3
XFILLER_74_192 VGND VGND VPWR VPWR sky130_fd_sc_hd__decap_3
XFILLER_90_641 VGND VGND VPWR VPWR sky130_fd_sc_hd__decap_3
XFILLER_35_579 VGND VGND VPWR VPWR sky130_fd_sc_hd__decap_3
XFILLER_50_505 VGND VGND VPWR VPWR sky130_fd_sc_hd__decap_3
XFILLER_62_365 VGND VGND VPWR VPWR sky130_fd_sc_hd__decap_3
XFILLER_90_674 VGND VGND VPWR VPWR sky130_fd_sc_hd__decap_3
X_3991_ _3991_/A VGND VGND VPWR VPWR _7944_/D sky130_fd_sc_hd__buf_1
XFILLER_90_696 VGND VGND VPWR VPWR sky130_fd_sc_hd__decap_3
X_5730_ _7612_/A _5733_/B VGND VGND VPWR VPWR _5730_/Y sky130_fd_sc_hd__nor2_2
XFILLER_15_281 VGND VGND VPWR VPWR sky130_fd_sc_hd__decap_3
XFILLER_30_251 VGND VGND VPWR VPWR sky130_fd_sc_hd__fill_1
XFILLER_30_262 VGND VGND VPWR VPWR sky130_fd_sc_hd__decap_3
X_7400_ _8278_/Q _7399_/X _8214_/Q VGND VGND VPWR VPWR _7400_/X sky130_fd_sc_hd__o21a_2
X_5661_ _5657_/X _5658_/X _5660_/X _5656_/B _8230_/Q VGND VGND VPWR VPWR _5661_/X
+ sky130_fd_sc_hd__a221o_2
X_8380_ _8380_/CLK _8380_/D VGND VGND VPWR VPWR _8380_/Q sky130_fd_sc_hd__dfxtp_2
X_5592_ _6717_/A _5592_/B VGND VGND VPWR VPWR _5593_/C sky130_fd_sc_hd__nor2_2
X_4612_ _7898_/B _8110_/Q VGND VGND VPWR VPWR _4613_/A sky130_fd_sc_hd__and2_2
XTAP_TAPCELL_ROW_96_1510 VGND VPWR sky130_fd_sc_hd__tapvpwrvgnd_1
XTAP_TAPCELL_ROW_41_791 VGND VPWR sky130_fd_sc_hd__tapvpwrvgnd_1
XFILLER_116_312 VGND VGND VPWR VPWR sky130_fd_sc_hd__decap_3
X_7331_ _8291_/Q _7331_/B VGND VGND VPWR VPWR _7331_/Y sky130_fd_sc_hd__nor2_2
X_4543_ _4543_/A VGND VGND VPWR VPWR _8209_/D sky130_fd_sc_hd__buf_1
X_7262_ _8291_/Q _7259_/X _7261_/X _8211_/Q VGND VGND VPWR VPWR _7262_/X sky130_fd_sc_hd__a2bb2o_2
XFILLER_104_518 VGND VGND VPWR VPWR sky130_fd_sc_hd__decap_3
XFILLER_116_389 VGND VGND VPWR VPWR sky130_fd_sc_hd__decap_3
X_6213_ _6804_/A _6210_/X _6213_/B1 _5966_/A _6297_/B VGND VGND VPWR VPWR _6213_/X
+ sky130_fd_sc_hd__o221a_2
X_4474_ _7898_/B _8041_/Q VGND VGND VPWR VPWR _4475_/A sky130_fd_sc_hd__and2_2
X_7193_ _7193_/A _7193_/B VGND VGND VPWR VPWR _7193_/Y sky130_fd_sc_hd__nand2_2
XFILLER_58_605 VGND VGND VPWR VPWR sky130_fd_sc_hd__fill_2
XFILLER_85_402 VGND VGND VPWR VPWR sky130_fd_sc_hd__decap_3
XFILLER_97_240 VGND VGND VPWR VPWR sky130_fd_sc_hd__decap_3
X_6144_ _6445_/A1 _6143_/B1 _6144_/B1 _5433_/A VGND VGND VPWR VPWR _6144_/X sky130_fd_sc_hd__a2bb2o_2
XFILLER_112_595 VGND VGND VPWR VPWR sky130_fd_sc_hd__decap_3
XFILLER_38_29 VGND VGND VPWR VPWR sky130_fd_sc_hd__decap_3
XFILLER_97_262 VGND VGND VPWR VPWR sky130_fd_sc_hd__decap_3
X_6075_ _6184_/B _6043_/Y _6046_/Y _5508_/A _6074_/X VGND VGND VPWR VPWR _6076_/B
+ sky130_fd_sc_hd__o221a_2
XFILLER_57_137 VGND VGND VPWR VPWR sky130_fd_sc_hd__decap_3
XFILLER_85_446 VGND VGND VPWR VPWR sky130_fd_sc_hd__fill_2
X_5026_ _5026_/A_N _5026_/B VGND VGND VPWR VPWR _5027_/A sky130_fd_sc_hd__and2b_2
XFILLER_26_502 VGND VGND VPWR VPWR sky130_fd_sc_hd__decap_3
XFILLER_38_351 VGND VGND VPWR VPWR sky130_fd_sc_hd__decap_3
XFILLER_66_671 VGND VGND VPWR VPWR sky130_fd_sc_hd__decap_3
XFILLER_38_395 VGND VGND VPWR VPWR sky130_fd_sc_hd__decap_3
XFILLER_53_332 VGND VGND VPWR VPWR sky130_fd_sc_hd__decap_3
XFILLER_65_181 VGND VGND VPWR VPWR sky130_fd_sc_hd__decap_3
XFILLER_81_630 VGND VGND VPWR VPWR sky130_fd_sc_hd__decap_3
XTAP_TAPCELL_ROW_49_891 VGND VPWR sky130_fd_sc_hd__tapvpwrvgnd_1
XFILLER_41_505 VGND VGND VPWR VPWR sky130_fd_sc_hd__decap_3
XFILLER_53_343 VGND VGND VPWR VPWR sky130_fd_sc_hd__fill_1
XFILLER_53_354 VGND VGND VPWR VPWR sky130_fd_sc_hd__decap_3
X_6977_ _8203_/Q _8202_/Q _8201_/Q _8200_/Q _6380_/S _5452_/S VGND VGND VPWR VPWR
+ _6977_/X sky130_fd_sc_hd__mux4_2
XFILLER_13_218 VGND VGND VPWR VPWR sky130_fd_sc_hd__decap_3
XFILLER_41_538 VGND VGND VPWR VPWR sky130_fd_sc_hd__fill_1
XFILLER_81_685 VGND VGND VPWR VPWR sky130_fd_sc_hd__decap_3
X_5928_ _5928_/A _5928_/B VGND VGND VPWR VPWR _5929_/A sky130_fd_sc_hd__and2_4
XFILLER_80_195 VGND VGND VPWR VPWR sky130_fd_sc_hd__fill_1
XFILLER_110_78 VGND VGND VPWR VPWR sky130_fd_sc_hd__decap_3
XFILLER_21_240 VGND VGND VPWR VPWR sky130_fd_sc_hd__decap_3
XFILLER_21_273 VGND VGND VPWR VPWR sky130_fd_sc_hd__decap_3
XFILLER_70_38 VGND VGND VPWR VPWR sky130_fd_sc_hd__decap_3
XTAP_TAPCELL_ROW_101_1569 VGND VPWR sky130_fd_sc_hd__tapvpwrvgnd_1
XTAP_TAPCELL_ROW_11_408 VGND VPWR sky130_fd_sc_hd__tapvpwrvgnd_1
X_5859_ _6130_/A _6132_/A VGND VGND VPWR VPWR _7202_/A sky130_fd_sc_hd__nor2_2
XFILLER_107_312 VGND VGND VPWR VPWR sky130_fd_sc_hd__decap_3
XFILLER_119_32 VGND VGND VPWR VPWR sky130_fd_sc_hd__decap_3
X_7529_ _7020_/X _7528_/X _6742_/X _7297_/X _6819_/A _7745_/A VGND VGND VPWR VPWR
+ _7529_/X sky130_fd_sc_hd__mux4_2
XFILLER_5_439 VGND VGND VPWR VPWR sky130_fd_sc_hd__decap_3
XFILLER_107_378 VGND VGND VPWR VPWR sky130_fd_sc_hd__decap_3
XFILLER_0_100 VGND VGND VPWR VPWR sky130_fd_sc_hd__decap_3
XFILLER_1_612 VGND VGND VPWR VPWR sky130_fd_sc_hd__fill_1
XFILLER_0_122 VGND VGND VPWR VPWR sky130_fd_sc_hd__decap_3
XFILLER_103_540 VGND VGND VPWR VPWR sky130_fd_sc_hd__decap_3
XFILLER_88_251 VGND VGND VPWR VPWR sky130_fd_sc_hd__fill_1
XFILLER_48_126 VGND VGND VPWR VPWR sky130_fd_sc_hd__decap_3
XFILLER_49_649 VGND VGND VPWR VPWR sky130_fd_sc_hd__decap_3
XFILLER_76_413 VGND VGND VPWR VPWR sky130_fd_sc_hd__decap_3
XFILLER_76_424 VGND VGND VPWR VPWR sky130_fd_sc_hd__decap_3
XFILLER_88_262 VGND VGND VPWR VPWR sky130_fd_sc_hd__decap_3
XFILLER_95_24 VGND VGND VPWR VPWR sky130_fd_sc_hd__decap_3
XFILLER_95_57 VGND VGND VPWR VPWR sky130_fd_sc_hd__decap_3
XFILLER_76_468 VGND VGND VPWR VPWR sky130_fd_sc_hd__decap_3
XFILLER_28_62 VGND VGND VPWR VPWR sky130_fd_sc_hd__decap_3
XFILLER_29_362 VGND VGND VPWR VPWR sky130_fd_sc_hd__decap_3
XFILLER_57_660 VGND VGND VPWR VPWR sky130_fd_sc_hd__decap_3
XFILLER_63_107 VGND VGND VPWR VPWR sky130_fd_sc_hd__decap_3
XFILLER_91_405 VGND VGND VPWR VPWR sky130_fd_sc_hd__decap_3
XTAP_TAPCELL_ROW_19_508 VGND VPWR sky130_fd_sc_hd__tapvpwrvgnd_1
XFILLER_17_535 VGND VGND VPWR VPWR sky130_fd_sc_hd__decap_3
XFILLER_29_384 VGND VGND VPWR VPWR sky130_fd_sc_hd__decap_3
XFILLER_44_321 VGND VGND VPWR VPWR sky130_fd_sc_hd__decap_3
XFILLER_56_192 VGND VGND VPWR VPWR sky130_fd_sc_hd__decap_3
XFILLER_72_630 VGND VGND VPWR VPWR sky130_fd_sc_hd__decap_3
XFILLER_91_449 VGND VGND VPWR VPWR sky130_fd_sc_hd__decap_3
XTAP_TAPCELL_ROW_67_1133 VGND VPWR sky130_fd_sc_hd__tapvpwrvgnd_1
XFILLER_17_557 VGND VGND VPWR VPWR sky130_fd_sc_hd__decap_3
XFILLER_44_365 VGND VGND VPWR VPWR sky130_fd_sc_hd__decap_3
XFILLER_44_398 VGND VGND VPWR VPWR sky130_fd_sc_hd__decap_3
XTAP_TAPCELL_ROW_80_1300 VGND VPWR sky130_fd_sc_hd__tapvpwrvgnd_1
XFILLER_12_251 VGND VGND VPWR VPWR sky130_fd_sc_hd__fill_1
XFILLER_12_262 VGND VGND VPWR VPWR sky130_fd_sc_hd__decap_3
XFILLER_8_200 VGND VGND VPWR VPWR sky130_fd_sc_hd__fill_2
XTAP_TAPCELL_ROW_119_1808 VGND VPWR sky130_fd_sc_hd__tapvpwrvgnd_1
XFILLER_12_284 VGND VGND VPWR VPWR sky130_fd_sc_hd__decap_3
XTAP_TAPCELL_ROW_119_1819 VGND VPWR sky130_fd_sc_hd__tapvpwrvgnd_1
XFILLER_60_71 VGND VGND VPWR VPWR sky130_fd_sc_hd__decap_3
XFILLER_8_299 VGND VGND VPWR VPWR sky130_fd_sc_hd__decap_3
XFILLER_99_505 VGND VGND VPWR VPWR sky130_fd_sc_hd__decap_3
XTAP_TAPCELL_ROW_78_1273 VGND VPWR sky130_fd_sc_hd__tapvpwrvgnd_1
XFILLER_113_315 VGND VGND VPWR VPWR sky130_fd_sc_hd__decap_3
XFILLER_113_337 VGND VGND VPWR VPWR sky130_fd_sc_hd__decap_3
XFILLER_4_483 VGND VGND VPWR VPWR sky130_fd_sc_hd__decap_3
XFILLER_99_549 VGND VGND VPWR VPWR sky130_fd_sc_hd__decap_3
XTAP_TAPCELL_ROW_91_1440 VGND VPWR sky130_fd_sc_hd__tapvpwrvgnd_1
X_4190_ _7898_/B _4190_/B VGND VGND VPWR VPWR _4191_/A sky130_fd_sc_hd__and2_2
XFILLER_67_402 VGND VGND VPWR VPWR sky130_fd_sc_hd__decap_3
XFILLER_79_262 VGND VGND VPWR VPWR sky130_fd_sc_hd__decap_3
XFILLER_79_284 VGND VGND VPWR VPWR sky130_fd_sc_hd__decap_3
XFILLER_55_608 VGND VGND VPWR VPWR sky130_fd_sc_hd__decap_3
XFILLER_67_435 VGND VGND VPWR VPWR sky130_fd_sc_hd__decap_3
XFILLER_94_232 VGND VGND VPWR VPWR sky130_fd_sc_hd__fill_2
XFILLER_48_660 VGND VGND VPWR VPWR sky130_fd_sc_hd__decap_3
XFILLER_54_118 VGND VGND VPWR VPWR sky130_fd_sc_hd__decap_3
XFILLER_82_416 VGND VGND VPWR VPWR sky130_fd_sc_hd__decap_3
XFILLER_82_427 VGND VGND VPWR VPWR sky130_fd_sc_hd__decap_3
XFILLER_94_265 VGND VGND VPWR VPWR sky130_fd_sc_hd__decap_3
XFILLER_48_693 VGND VGND VPWR VPWR sky130_fd_sc_hd__decap_3
XFILLER_75_490 VGND VGND VPWR VPWR sky130_fd_sc_hd__decap_3
XFILLER_85_90 VGND VGND VPWR VPWR sky130_fd_sc_hd__decap_3
XFILLER_94_298 VGND VGND VPWR VPWR sky130_fd_sc_hd__decap_3
X_7880_ _8310_/Q _7898_/B VGND VGND VPWR VPWR _7881_/A sky130_fd_sc_hd__and2_2
X_6900_ _8198_/Q _8199_/Q _6900_/C VGND VGND VPWR VPWR _6926_/B sky130_fd_sc_hd__or3_4
XFILLER_90_460 VGND VGND VPWR VPWR sky130_fd_sc_hd__decap_3
X_6831_ _6999_/A1 _6829_/X _6848_/B VGND VGND VPWR VPWR _6831_/X sky130_fd_sc_hd__a21bo_2
XTAP_TAPCELL_ROW_46_861 VGND VPWR sky130_fd_sc_hd__tapvpwrvgnd_1
XFILLER_35_376 VGND VGND VPWR VPWR sky130_fd_sc_hd__decap_3
XFILLER_50_324 VGND VGND VPWR VPWR sky130_fd_sc_hd__decap_3
XFILLER_62_162 VGND VGND VPWR VPWR sky130_fd_sc_hd__decap_3
X_6762_ _6874_/A _6807_/B VGND VGND VPWR VPWR _6762_/Y sky130_fd_sc_hd__xnor2_2
X_3974_ _8340_/Q _7930_/B VGND VGND VPWR VPWR _3975_/A sky130_fd_sc_hd__and2_2
XFILLER_50_368 VGND VGND VPWR VPWR sky130_fd_sc_hd__fill_1
X_6693_ _8258_/Q _6674_/X _6692_/X VGND VGND VPWR VPWR _6695_/B sky130_fd_sc_hd__o21a_4
X_5713_ _5867_/A _5715_/B VGND VGND VPWR VPWR _5716_/A sky130_fd_sc_hd__nor2_2
X_5644_ _7135_/B _7745_/B _6269_/B VGND VGND VPWR VPWR _5644_/X sky130_fd_sc_hd__a21o_2
XFILLER_117_610 VGND VGND VPWR VPWR sky130_fd_sc_hd__fill_1
X_8363_ _8387_/CLK _8363_/D VGND VGND VPWR VPWR _8363_/Q sky130_fd_sc_hd__dfxtp_2
XFILLER_116_131 VGND VGND VPWR VPWR sky130_fd_sc_hd__decap_3
XFILLER_117_632 VGND VGND VPWR VPWR sky130_fd_sc_hd__fill_1
X_7314_ _8276_/Q _7314_/A2 _7313_/X VGND VGND VPWR VPWR _7338_/B sky130_fd_sc_hd__o21a_4
X_5575_ _5361_/X _5366_/A _5579_/S VGND VGND VPWR VPWR _5576_/B sky130_fd_sc_hd__mux2_2
XFILLER_116_153 VGND VGND VPWR VPWR sky130_fd_sc_hd__decap_3
XFILLER_117_676 VGND VGND VPWR VPWR sky130_fd_sc_hd__decap_3
X_8294_ _8322_/CLK _8294_/D VGND VGND VPWR VPWR _8294_/Q sky130_fd_sc_hd__dfxtp_2
X_4526_ _7898_/B _8067_/Q VGND VGND VPWR VPWR _4527_/A sky130_fd_sc_hd__and2_2
X_7245_ _8274_/Q _5422_/X _6687_/X _7244_/X VGND VGND VPWR VPWR _7245_/X sky130_fd_sc_hd__a211o_2
X_4457_ _4457_/A VGND VGND VPWR VPWR _8166_/D sky130_fd_sc_hd__buf_1
X_7176_ _8203_/Q _8267_/Q _7174_/X _8266_/Q _7175_/X VGND VGND VPWR VPWR _7176_/X
+ sky130_fd_sc_hd__a221o_2
XFILLER_58_413 VGND VGND VPWR VPWR sky130_fd_sc_hd__decap_3
XFILLER_58_424 VGND VGND VPWR VPWR sky130_fd_sc_hd__decap_3
XFILLER_98_582 VGND VGND VPWR VPWR sky130_fd_sc_hd__decap_3
X_6127_ _8179_/Q _8178_/Q _8177_/Q _6097_/A _5678_/S _6199_/S1 VGND VGND VPWR VPWR
+ _6127_/X sky130_fd_sc_hd__mux4_2
X_4388_ _7930_/B _4388_/B VGND VGND VPWR VPWR _4389_/A sky130_fd_sc_hd__and2_2
XFILLER_112_392 VGND VGND VPWR VPWR sky130_fd_sc_hd__decap_3
XFILLER_58_457 VGND VGND VPWR VPWR sky130_fd_sc_hd__decap_3
XFILLER_85_221 VGND VGND VPWR VPWR sky130_fd_sc_hd__decap_3
XFILLER_85_243 VGND VGND VPWR VPWR sky130_fd_sc_hd__decap_3
XFILLER_100_576 VGND VGND VPWR VPWR sky130_fd_sc_hd__decap_3
XFILLER_65_38 VGND VGND VPWR VPWR sky130_fd_sc_hd__decap_3
XFILLER_73_427 VGND VGND VPWR VPWR sky130_fd_sc_hd__decap_3
X_6058_ _8177_/Q _6097_/A _6024_/B _6024_/A _5286_/A _6199_/S1 VGND VGND VPWR VPWR
+ _6058_/X sky130_fd_sc_hd__mux4_2
XFILLER_39_682 VGND VGND VPWR VPWR sky130_fd_sc_hd__decap_3
XFILLER_85_287 VGND VGND VPWR VPWR sky130_fd_sc_hd__decap_3
X_5009_ _5491_/C VGND VGND VPWR VPWR _5318_/B sky130_fd_sc_hd__inv_2
XFILLER_54_663 VGND VGND VPWR VPWR sky130_fd_sc_hd__decap_3
XFILLER_26_398 VGND VGND VPWR VPWR sky130_fd_sc_hd__decap_3
XFILLER_53_151 VGND VGND VPWR VPWR sky130_fd_sc_hd__fill_2
XFILLER_53_184 VGND VGND VPWR VPWR sky130_fd_sc_hd__decap_3
XFILLER_81_26 VGND VGND VPWR VPWR sky130_fd_sc_hd__decap_3
XFILLER_81_493 VGND VGND VPWR VPWR sky130_fd_sc_hd__fill_1
XFILLER_41_346 VGND VGND VPWR VPWR sky130_fd_sc_hd__fill_2
XFILLER_22_571 VGND VGND VPWR VPWR sky130_fd_sc_hd__decap_3
XFILLER_41_368 VGND VGND VPWR VPWR sky130_fd_sc_hd__decap_3
XTAP_TAPCELL_ROW_62_1063 VGND VPWR sky130_fd_sc_hd__tapvpwrvgnd_1
XTAP_TAPCELL_ROW_24_577 VGND VPWR sky130_fd_sc_hd__tapvpwrvgnd_1
XTAP_TAPCELL_ROW_24_566 VGND VPWR sky130_fd_sc_hd__tapvpwrvgnd_1
XFILLER_108_654 VGND VGND VPWR VPWR sky130_fd_sc_hd__decap_3
XFILLER_5_225 VGND VGND VPWR VPWR sky130_fd_sc_hd__fill_1
XFILLER_5_236 VGND VGND VPWR VPWR sky130_fd_sc_hd__decap_3
XFILLER_107_131 VGND VGND VPWR VPWR sky130_fd_sc_hd__decap_3
XFILLER_108_687 VGND VGND VPWR VPWR sky130_fd_sc_hd__decap_3
XFILLER_30_52 VGND VGND VPWR VPWR sky130_fd_sc_hd__decap_3
XFILLER_30_63 VGND VGND VPWR VPWR sky130_fd_sc_hd__decap_3
XTAP_TAPCELL_ROW_114_1738 VGND VPWR sky130_fd_sc_hd__tapvpwrvgnd_1
XFILLER_107_175 VGND VGND VPWR VPWR sky130_fd_sc_hd__decap_3
XFILLER_30_85 VGND VGND VPWR VPWR sky130_fd_sc_hd__decap_3
XFILLER_1_475 VGND VGND VPWR VPWR sky130_fd_sc_hd__fill_1
XFILLER_39_50 VGND VGND VPWR VPWR sky130_fd_sc_hd__decap_3
XFILLER_39_72 VGND VGND VPWR VPWR sky130_fd_sc_hd__decap_3
XFILLER_49_435 VGND VGND VPWR VPWR sky130_fd_sc_hd__decap_3
XFILLER_37_608 VGND VGND VPWR VPWR sky130_fd_sc_hd__decap_3
XFILLER_49_479 VGND VGND VPWR VPWR sky130_fd_sc_hd__fill_1
XFILLER_64_405 VGND VGND VPWR VPWR sky130_fd_sc_hd__decap_3
XFILLER_76_276 VGND VGND VPWR VPWR sky130_fd_sc_hd__fill_2
XFILLER_17_310 VGND VGND VPWR VPWR sky130_fd_sc_hd__decap_3
XFILLER_36_129 VGND VGND VPWR VPWR sky130_fd_sc_hd__fill_1
XFILLER_64_449 VGND VGND VPWR VPWR sky130_fd_sc_hd__decap_3
XFILLER_76_287 VGND VGND VPWR VPWR sky130_fd_sc_hd__decap_3
XPHY_EDGE_ROW_101_Right_101 VGND VGND VPWR VPWR sky130_fd_sc_hd__decap_3
XFILLER_17_343 VGND VGND VPWR VPWR sky130_fd_sc_hd__decap_3
XFILLER_45_663 VGND VGND VPWR VPWR sky130_fd_sc_hd__decap_3
XFILLER_91_257 VGND VGND VPWR VPWR sky130_fd_sc_hd__decap_3
XFILLER_17_387 VGND VGND VPWR VPWR sky130_fd_sc_hd__fill_2
XFILLER_60_622 VGND VGND VPWR VPWR sky130_fd_sc_hd__fill_1
XTAP_TAPCELL_ROW_43_820 VGND VPWR sky130_fd_sc_hd__tapvpwrvgnd_1
XFILLER_44_184 VGND VGND VPWR VPWR sky130_fd_sc_hd__decap_3
XFILLER_20_508 VGND VGND VPWR VPWR sky130_fd_sc_hd__decap_3
XFILLER_71_81 VGND VGND VPWR VPWR sky130_fd_sc_hd__decap_3
XFILLER_9_586 VGND VGND VPWR VPWR sky130_fd_sc_hd__decap_3
XFILLER_58_3 VGND VGND VPWR VPWR sky130_fd_sc_hd__decap_3
X_5360_ _5133_/X _5125_/X _5444_/S VGND VGND VPWR VPWR _5360_/X sky130_fd_sc_hd__mux2_2
XFILLER_114_624 VGND VGND VPWR VPWR sky130_fd_sc_hd__fill_1
XFILLER_99_335 VGND VGND VPWR VPWR sky130_fd_sc_hd__fill_1
X_5291_ _5858_/B _7631_/C VGND VGND VPWR VPWR _5292_/A sky130_fd_sc_hd__nor2_2
X_4311_ _4311_/A VGND VGND VPWR VPWR _8093_/D sky130_fd_sc_hd__buf_1
XFILLER_87_508 VGND VGND VPWR VPWR sky130_fd_sc_hd__decap_3
XFILLER_99_379 VGND VGND VPWR VPWR sky130_fd_sc_hd__decap_3
X_7030_ _7030_/A VGND VGND VPWR VPWR _7030_/Y sky130_fd_sc_hd__inv_2
X_4242_ _7898_/B _4242_/B VGND VGND VPWR VPWR _4243_/A sky130_fd_sc_hd__and2_2
XFILLER_101_318 VGND VGND VPWR VPWR sky130_fd_sc_hd__fill_1
XFILLER_67_210 VGND VGND VPWR VPWR sky130_fd_sc_hd__decap_3
XFILLER_67_243 VGND VGND VPWR VPWR sky130_fd_sc_hd__decap_3
X_4173_ _4173_/A VGND VGND VPWR VPWR _8024_/D sky130_fd_sc_hd__buf_1
XFILLER_55_405 VGND VGND VPWR VPWR sky130_fd_sc_hd__decap_3
XFILLER_83_703 VGND VGND VPWR VPWR sky130_fd_sc_hd__decap_3
XFILLER_82_224 VGND VGND VPWR VPWR sky130_fd_sc_hd__decap_3
XFILLER_95_596 VGND VGND VPWR VPWR sky130_fd_sc_hd__decap_3
X_7932_ _8402_/CLK _7932_/D VGND VGND VPWR VPWR _7932_/Q sky130_fd_sc_hd__dfxtp_2
XFILLER_51_611 VGND VGND VPWR VPWR sky130_fd_sc_hd__decap_3
XFILLER_70_419 VGND VGND VPWR VPWR sky130_fd_sc_hd__fill_1
X_7863_ _7863_/A VGND VGND VPWR VPWR _8368_/D sky130_fd_sc_hd__buf_1
XFILLER_23_335 VGND VGND VPWR VPWR sky130_fd_sc_hd__fill_1
XFILLER_23_346 VGND VGND VPWR VPWR sky130_fd_sc_hd__decap_3
XFILLER_51_633 VGND VGND VPWR VPWR sky130_fd_sc_hd__fill_2
XFILLER_90_290 VGND VGND VPWR VPWR sky130_fd_sc_hd__fill_2
X_7794_ _7812_/A _8193_/Q _7820_/B VGND VGND VPWR VPWR _7794_/X sky130_fd_sc_hd__and3_2
X_6814_ _6801_/X _6811_/X _6813_/X VGND VGND VPWR VPWR _6814_/Y sky130_fd_sc_hd__a21oi_4
XFILLER_23_368 VGND VGND VPWR VPWR sky130_fd_sc_hd__fill_1
XFILLER_50_165 VGND VGND VPWR VPWR sky130_fd_sc_hd__decap_3
X_6745_ _7825_/A _6743_/X _6744_/X _5464_/A VGND VGND VPWR VPWR _6745_/X sky130_fd_sc_hd__o211a_2
XTAP_TAPCELL_ROW_21_536 VGND VPWR sky130_fd_sc_hd__tapvpwrvgnd_1
XFILLER_109_418 VGND VGND VPWR VPWR sky130_fd_sc_hd__fill_1
X_6676_ _8194_/Q _8193_/Q _7796_/A VGND VGND VPWR VPWR _6676_/X sky130_fd_sc_hd__mux2_2
X_5627_ _5627_/A VGND VGND VPWR VPWR _5627_/X sky130_fd_sc_hd__clkbuf_1
X_8346_ _8349_/CLK _8346_/D VGND VGND VPWR VPWR _8346_/Q sky130_fd_sc_hd__dfxtp_2
X_5558_ _7930_/B _5558_/B VGND VGND VPWR VPWR _5559_/A sky130_fd_sc_hd__and2_2
XFILLER_105_635 VGND VGND VPWR VPWR sky130_fd_sc_hd__decap_3
XFILLER_2_217 VGND VGND VPWR VPWR sky130_fd_sc_hd__decap_3
XFILLER_3_729 VGND VGND VPWR VPWR sky130_fd_sc_hd__decap_3
X_8277_ _8280_/CLK _8277_/D VGND VGND VPWR VPWR _8277_/Q sky130_fd_sc_hd__dfxtp_2
X_4509_ _4509_/A VGND VGND VPWR VPWR _8192_/D sky130_fd_sc_hd__buf_1
XFILLER_105_679 VGND VGND VPWR VPWR sky130_fd_sc_hd__fill_2
XFILLER_78_508 VGND VGND VPWR VPWR sky130_fd_sc_hd__fill_1
X_7228_ _8206_/Q _7228_/B _7228_/C VGND VGND VPWR VPWR _7229_/C sky130_fd_sc_hd__and3_2
X_5489_ _8162_/Q _8161_/Q _8160_/Q _8163_/Q VGND VGND VPWR VPWR _5535_/C sky130_fd_sc_hd__or4_4
XFILLER_116_66 VGND VGND VPWR VPWR sky130_fd_sc_hd__decap_3
XFILLER_76_15 VGND VGND VPWR VPWR sky130_fd_sc_hd__decap_3
XFILLER_58_210 VGND VGND VPWR VPWR sky130_fd_sc_hd__fill_2
XFILLER_86_530 VGND VGND VPWR VPWR sky130_fd_sc_hd__fill_2
XFILLER_98_390 VGND VGND VPWR VPWR sky130_fd_sc_hd__decap_3
X_7159_ _7159_/A _7159_/B VGND VGND VPWR VPWR _7159_/Y sky130_fd_sc_hd__nand2_2
XFILLER_100_362 VGND VGND VPWR VPWR sky130_fd_sc_hd__fill_2
XFILLER_19_608 VGND VGND VPWR VPWR sky130_fd_sc_hd__fill_2
XFILLER_46_405 VGND VGND VPWR VPWR sky130_fd_sc_hd__decap_3
XFILLER_58_265 VGND VGND VPWR VPWR sky130_fd_sc_hd__decap_3
XFILLER_86_563 VGND VGND VPWR VPWR sky130_fd_sc_hd__decap_3
XFILLER_100_395 VGND VGND VPWR VPWR sky130_fd_sc_hd__decap_3
XFILLER_46_427 VGND VGND VPWR VPWR sky130_fd_sc_hd__decap_3
XFILLER_58_298 VGND VGND VPWR VPWR sky130_fd_sc_hd__decap_3
XFILLER_73_213 VGND VGND VPWR VPWR sky130_fd_sc_hd__decap_3
XTAP_TAPCELL_ROW_29_636 VGND VPWR sky130_fd_sc_hd__tapvpwrvgnd_1
XFILLER_61_408 VGND VGND VPWR VPWR sky130_fd_sc_hd__decap_3
XFILLER_73_257 VGND VGND VPWR VPWR sky130_fd_sc_hd__decap_3
Xclkbuf_leaf_38_clk clkload0/A VGND VGND VPWR VPWR clkload6/A sky130_fd_sc_hd__clkbuf_8
XFILLER_14_302 VGND VGND VPWR VPWR sky130_fd_sc_hd__decap_3
XFILLER_26_162 VGND VGND VPWR VPWR sky130_fd_sc_hd__decap_3
XFILLER_73_279 VGND VGND VPWR VPWR sky130_fd_sc_hd__fill_1
XTAP_TAPCELL_ROW_1_272 VGND VPWR sky130_fd_sc_hd__tapvpwrvgnd_1
XFILLER_14_346 VGND VGND VPWR VPWR sky130_fd_sc_hd__decap_3
XFILLER_41_132 VGND VGND VPWR VPWR sky130_fd_sc_hd__decap_3
XFILLER_42_633 VGND VGND VPWR VPWR sky130_fd_sc_hd__decap_3
XFILLER_81_290 VGND VGND VPWR VPWR sky130_fd_sc_hd__fill_2
XFILLER_14_368 VGND VGND VPWR VPWR sky130_fd_sc_hd__fill_1
XFILLER_25_85 VGND VGND VPWR VPWR sky130_fd_sc_hd__decap_3
XFILLER_41_187 VGND VGND VPWR VPWR sky130_fd_sc_hd__decap_3
XFILLER_6_501 VGND VGND VPWR VPWR sky130_fd_sc_hd__decap_3
XFILLER_10_563 VGND VGND VPWR VPWR sky130_fd_sc_hd__fill_2
XFILLER_10_596 VGND VGND VPWR VPWR sky130_fd_sc_hd__decap_3
XFILLER_41_84 VGND VGND VPWR VPWR sky130_fd_sc_hd__decap_3
XFILLER_6_545 VGND VGND VPWR VPWR sky130_fd_sc_hd__fill_1
XFILLER_108_440 VGND VGND VPWR VPWR sky130_fd_sc_hd__decap_3
XFILLER_108_473 VGND VGND VPWR VPWR sky130_fd_sc_hd__decap_3
XFILLER_6_589 VGND VGND VPWR VPWR sky130_fd_sc_hd__decap_3
XTAP_TAPCELL_ROW_75_1232 VGND VPWR sky130_fd_sc_hd__tapvpwrvgnd_1
XFILLER_69_508 VGND VGND VPWR VPWR sky130_fd_sc_hd__decap_3
XFILLER_110_104 VGND VGND VPWR VPWR sky130_fd_sc_hd__decap_3
XFILLER_96_305 VGND VGND VPWR VPWR sky130_fd_sc_hd__decap_3
XFILLER_96_316 VGND VGND VPWR VPWR sky130_fd_sc_hd__decap_3
XTAP_TAPCELL_ROW_9_372 VGND VPWR sky130_fd_sc_hd__tapvpwrvgnd_1
XFILLER_2_56 VGND VGND VPWR VPWR sky130_fd_sc_hd__decap_3
XFILLER_37_405 VGND VGND VPWR VPWR sky130_fd_sc_hd__decap_3
XFILLER_49_254 VGND VGND VPWR VPWR sky130_fd_sc_hd__decap_3
XFILLER_49_265 VGND VGND VPWR VPWR sky130_fd_sc_hd__decap_3
XFILLER_77_574 VGND VGND VPWR VPWR sky130_fd_sc_hd__decap_3
XFILLER_37_427 VGND VGND VPWR VPWR sky130_fd_sc_hd__decap_3
XFILLER_37_449 VGND VGND VPWR VPWR sky130_fd_sc_hd__decap_3
XFILLER_49_287 VGND VGND VPWR VPWR sky130_fd_sc_hd__decap_3
XFILLER_92_533 VGND VGND VPWR VPWR sky130_fd_sc_hd__decap_3
XFILLER_92_577 VGND VGND VPWR VPWR sky130_fd_sc_hd__decap_3
Xclkbuf_leaf_29_clk clkbuf_2_2__f_clk/X VGND VGND VPWR VPWR _8388_/CLK sky130_fd_sc_hd__clkbuf_8
XFILLER_17_151 VGND VGND VPWR VPWR sky130_fd_sc_hd__decap_3
XFILLER_18_696 VGND VGND VPWR VPWR sky130_fd_sc_hd__decap_3
XFILLER_33_600 VGND VGND VPWR VPWR sky130_fd_sc_hd__decap_3
XFILLER_33_611 VGND VGND VPWR VPWR sky130_fd_sc_hd__decap_3
XFILLER_64_279 VGND VGND VPWR VPWR sky130_fd_sc_hd__decap_3
XFILLER_92_599 VGND VGND VPWR VPWR sky130_fd_sc_hd__decap_3
XTAP_TAPCELL_ROW_86_1372 VGND VPWR sky130_fd_sc_hd__tapvpwrvgnd_1
X_4860_ _8188_/Q VGND VGND VPWR VPWR _4861_/A sky130_fd_sc_hd__inv_2
XTAP_TAPCELL_ROW_86_1383 VGND VPWR sky130_fd_sc_hd__tapvpwrvgnd_1
XFILLER_82_91 VGND VGND VPWR VPWR sky130_fd_sc_hd__decap_3
XANTENNA_17 _5866_/X VGND VGND VPWR VPWR sky130_fd_sc_hd__diode_2
XANTENNA_28 _8200_/Q VGND VGND VPWR VPWR sky130_fd_sc_hd__diode_2
XFILLER_20_327 VGND VGND VPWR VPWR sky130_fd_sc_hd__decap_3
XFILLER_60_496 VGND VGND VPWR VPWR sky130_fd_sc_hd__decap_3
X_6530_ _8190_/Q _6712_/B _7796_/A VGND VGND VPWR VPWR _6530_/X sky130_fd_sc_hd__mux2_2
X_4791_ _4973_/A _4973_/B _4791_/C _4791_/D VGND VGND VPWR VPWR _5069_/A sky130_fd_sc_hd__or4_2
XFILLER_119_716 VGND VGND VPWR VPWR sky130_fd_sc_hd__decap_3
X_6461_ _8188_/Q _8252_/Q VGND VGND VPWR VPWR _6462_/C sky130_fd_sc_hd__nor2_2
X_8200_ _8207_/CLK _8200_/D VGND VGND VPWR VPWR _8200_/Q sky130_fd_sc_hd__dfxtp_2
X_6392_ _4882_/A _6391_/X _4881_/A VGND VGND VPWR VPWR _6564_/C sky130_fd_sc_hd__a21o_2
X_5412_ _6099_/A _5412_/B VGND VGND VPWR VPWR _5412_/Y sky130_fd_sc_hd__nor2_2
XFILLER_114_410 VGND VGND VPWR VPWR sky130_fd_sc_hd__decap_3
XFILLER_99_110 VGND VGND VPWR VPWR sky130_fd_sc_hd__fill_2
X_8131_ _8401_/CLK _8131_/D VGND VGND VPWR VPWR _8131_/Q sky130_fd_sc_hd__dfxtp_2
X_5343_ _5396_/A _5343_/B VGND VGND VPWR VPWR _5343_/Y sky130_fd_sc_hd__nor2_2
XFILLER_99_143 VGND VGND VPWR VPWR sky130_fd_sc_hd__decap_3
Xoutput168 _7994_/Q VGND VGND VPWR VPWR result[36] sky130_fd_sc_hd__clkdlybuf4s25_1
Xoutput157 _7984_/Q VGND VGND VPWR VPWR result[26] sky130_fd_sc_hd__clkdlybuf4s25_1
Xoutput146 _7974_/Q VGND VGND VPWR VPWR result[16] sky130_fd_sc_hd__clkdlybuf4s25_1
XFILLER_102_627 VGND VGND VPWR VPWR sky130_fd_sc_hd__decap_3
XFILLER_114_465 VGND VGND VPWR VPWR sky130_fd_sc_hd__fill_2
X_8062_ _8199_/CLK _8062_/D VGND VGND VPWR VPWR _8062_/Q sky130_fd_sc_hd__dfxtp_2
Xoutput179 _8004_/Q VGND VGND VPWR VPWR result[46] sky130_fd_sc_hd__clkdlybuf4s25_1
X_5274_ _6507_/S _5596_/S VGND VGND VPWR VPWR _6130_/B sky130_fd_sc_hd__nor2_2
X_7013_ _8204_/Q _7005_/Y _7006_/X _7012_/Y VGND VGND VPWR VPWR _7024_/B sky130_fd_sc_hd__o31a_2
X_4225_ _4225_/A VGND VGND VPWR VPWR _8050_/D sky130_fd_sc_hd__buf_1
XFILLER_101_159 VGND VGND VPWR VPWR sky130_fd_sc_hd__decap_3
XFILLER_68_563 VGND VGND VPWR VPWR sky130_fd_sc_hd__decap_3
XFILLER_83_500 VGND VGND VPWR VPWR sky130_fd_sc_hd__fill_1
X_4156_ _7930_/B _7948_/Q VGND VGND VPWR VPWR _4157_/A sky130_fd_sc_hd__and2_2
XFILLER_110_693 VGND VGND VPWR VPWR sky130_fd_sc_hd__fill_1
XFILLER_28_427 VGND VGND VPWR VPWR sky130_fd_sc_hd__fill_1
XFILLER_28_449 VGND VGND VPWR VPWR sky130_fd_sc_hd__decap_3
XFILLER_46_29 VGND VGND VPWR VPWR sky130_fd_sc_hd__decap_3
XFILLER_83_511 VGND VGND VPWR VPWR sky130_fd_sc_hd__decap_3
XFILLER_95_382 VGND VGND VPWR VPWR sky130_fd_sc_hd__decap_3
XFILLER_95_393 VGND VGND VPWR VPWR sky130_fd_sc_hd__decap_3
XFILLER_43_408 VGND VGND VPWR VPWR sky130_fd_sc_hd__decap_3
XFILLER_55_235 VGND VGND VPWR VPWR sky130_fd_sc_hd__decap_3
XFILLER_83_544 VGND VGND VPWR VPWR sky130_fd_sc_hd__decap_3
X_4087_ _4087_/A VGND VGND VPWR VPWR _7981_/D sky130_fd_sc_hd__buf_1
XFILLER_102_35 VGND VGND VPWR VPWR sky130_fd_sc_hd__decap_3
XFILLER_36_460 VGND VGND VPWR VPWR sky130_fd_sc_hd__decap_3
XFILLER_70_227 VGND VGND VPWR VPWR sky130_fd_sc_hd__decap_3
X_7915_ _7915_/A VGND VGND VPWR VPWR _8394_/D sky130_fd_sc_hd__buf_1
X_7846_ _7898_/B _8293_/Q VGND VGND VPWR VPWR _7847_/A sky130_fd_sc_hd__and2_2
XTAP_TAPCELL_ROW_54_959 VGND VPWR sky130_fd_sc_hd__tapvpwrvgnd_1
XFILLER_11_305 VGND VGND VPWR VPWR sky130_fd_sc_hd__decap_3
XFILLER_23_165 VGND VGND VPWR VPWR sky130_fd_sc_hd__decap_3
XFILLER_24_688 VGND VGND VPWR VPWR sky130_fd_sc_hd__decap_3
XFILLER_51_485 VGND VGND VPWR VPWR sky130_fd_sc_hd__decap_3
X_7777_ _7805_/A _7776_/B _7656_/B _5596_/S VGND VGND VPWR VPWR _7777_/Y sky130_fd_sc_hd__a211oi_2
X_4989_ _8283_/Q _4989_/B VGND VGND VPWR VPWR _4989_/X sky130_fd_sc_hd__or2_2
XFILLER_7_309 VGND VGND VPWR VPWR sky130_fd_sc_hd__fill_2
X_6728_ _6725_/D _6727_/X _8258_/Q VGND VGND VPWR VPWR _6728_/X sky130_fd_sc_hd__o21a_2
XFILLER_109_237 VGND VGND VPWR VPWR sky130_fd_sc_hd__decap_3
X_6659_ _8192_/Q _6670_/C VGND VGND VPWR VPWR _6660_/B sky130_fd_sc_hd__nand2_2
X_8329_ _8392_/CLK _8329_/D VGND VGND VPWR VPWR _8329_/Q sky130_fd_sc_hd__dfxtp_2
XFILLER_117_281 VGND VGND VPWR VPWR sky130_fd_sc_hd__fill_1
XTAP_TAPCELL_ROW_111_1708 VGND VPWR sky130_fd_sc_hd__tapvpwrvgnd_1
XFILLER_105_465 VGND VGND VPWR VPWR sky130_fd_sc_hd__decap_3
XFILLER_78_305 VGND VGND VPWR VPWR sky130_fd_sc_hd__decap_3
XFILLER_78_327 VGND VGND VPWR VPWR sky130_fd_sc_hd__decap_3
XTAP_TAPCELL_ROW_6_342 VGND VPWR sky130_fd_sc_hd__tapvpwrvgnd_1
XTAP_TAPCELL_ROW_6_331 VGND VPWR sky130_fd_sc_hd__tapvpwrvgnd_1
XFILLER_93_319 VGND VGND VPWR VPWR sky130_fd_sc_hd__decap_3
XTAP_TAPCELL_ROW_70_1173 VGND VPWR sky130_fd_sc_hd__tapvpwrvgnd_1
XFILLER_100_170 VGND VGND VPWR VPWR sky130_fd_sc_hd__decap_3
XFILLER_46_224 VGND VGND VPWR VPWR sky130_fd_sc_hd__decap_3
XFILLER_74_533 VGND VGND VPWR VPWR sky130_fd_sc_hd__fill_1
XFILLER_19_449 VGND VGND VPWR VPWR sky130_fd_sc_hd__decap_3
XFILLER_34_419 VGND VGND VPWR VPWR sky130_fd_sc_hd__fill_1
XFILLER_46_279 VGND VGND VPWR VPWR sky130_fd_sc_hd__fill_1
XFILLER_74_577 VGND VGND VPWR VPWR sky130_fd_sc_hd__decap_3
XFILLER_42_430 VGND VGND VPWR VPWR sky130_fd_sc_hd__decap_3
XFILLER_61_238 VGND VGND VPWR VPWR sky130_fd_sc_hd__decap_3
XFILLER_14_132 VGND VGND VPWR VPWR sky130_fd_sc_hd__decap_3
XFILLER_15_666 VGND VGND VPWR VPWR sky130_fd_sc_hd__decap_3
XFILLER_30_603 VGND VGND VPWR VPWR sky130_fd_sc_hd__decap_3
XFILLER_14_165 VGND VGND VPWR VPWR sky130_fd_sc_hd__decap_3
XFILLER_30_669 VGND VGND VPWR VPWR sky130_fd_sc_hd__decap_3
XFILLER_52_94 VGND VGND VPWR VPWR sky130_fd_sc_hd__decap_3
Xinput37 operand_a[38] VGND VGND VPWR VPWR _4252_/B sky130_fd_sc_hd__clkdlybuf4s25_1
Xinput26 operand_a[28] VGND VGND VPWR VPWR _4232_/B sky130_fd_sc_hd__clkdlybuf4s25_1
Xinput15 operand_a[18] VGND VGND VPWR VPWR _4212_/B sky130_fd_sc_hd__clkdlybuf4s25_1
XFILLER_6_353 VGND VGND VPWR VPWR sky130_fd_sc_hd__decap_3
Xinput59 operand_a[58] VGND VGND VPWR VPWR _4292_/B sky130_fd_sc_hd__clkdlybuf4s25_1
Xinput48 operand_a[48] VGND VGND VPWR VPWR _4272_/B sky130_fd_sc_hd__clkdlybuf4s25_1
XFILLER_6_386 VGND VGND VPWR VPWR sky130_fd_sc_hd__fill_1
XFILLER_69_305 VGND VGND VPWR VPWR sky130_fd_sc_hd__decap_3
XFILLER_111_446 VGND VGND VPWR VPWR sky130_fd_sc_hd__fill_2
XFILLER_69_349 VGND VGND VPWR VPWR sky130_fd_sc_hd__decap_3
XFILLER_96_135 VGND VGND VPWR VPWR sky130_fd_sc_hd__fill_1
XFILLER_97_647 VGND VGND VPWR VPWR sky130_fd_sc_hd__decap_3
XFILLER_96_168 VGND VGND VPWR VPWR sky130_fd_sc_hd__decap_3
X_4010_ _8328_/Q _8333_/Q _8332_/Q _8336_/Q VGND VGND VPWR VPWR _4011_/D sky130_fd_sc_hd__or4_2
XFILLER_37_202 VGND VGND VPWR VPWR sky130_fd_sc_hd__fill_1
XFILLER_37_213 VGND VGND VPWR VPWR sky130_fd_sc_hd__decap_3
XFILLER_65_511 VGND VGND VPWR VPWR sky130_fd_sc_hd__decap_3
XFILLER_77_393 VGND VGND VPWR VPWR sky130_fd_sc_hd__fill_1
XTAP_TAPCELL_ROW_88_1401 VGND VPWR sky130_fd_sc_hd__tapvpwrvgnd_1
XFILLER_37_246 VGND VGND VPWR VPWR sky130_fd_sc_hd__fill_2
XFILLER_65_555 VGND VGND VPWR VPWR sky130_fd_sc_hd__decap_3
XFILLER_25_419 VGND VGND VPWR VPWR sky130_fd_sc_hd__decap_3
XFILLER_92_374 VGND VGND VPWR VPWR sky130_fd_sc_hd__decap_3
X_5961_ _5528_/A _5960_/X _5785_/A VGND VGND VPWR VPWR _5961_/Y sky130_fd_sc_hd__o21ai_2
XFILLER_45_290 VGND VGND VPWR VPWR sky130_fd_sc_hd__decap_3
XFILLER_52_238 VGND VGND VPWR VPWR sky130_fd_sc_hd__decap_3
XFILLER_80_536 VGND VGND VPWR VPWR sky130_fd_sc_hd__fill_2
XFILLER_93_90 VGND VGND VPWR VPWR sky130_fd_sc_hd__decap_3
X_7700_ _8187_/Q _7660_/A _7664_/X VGND VGND VPWR VPWR _7700_/Y sky130_fd_sc_hd__o21ai_2
X_4912_ _8243_/Q VGND VGND VPWR VPWR _4913_/B sky130_fd_sc_hd__inv_2
XFILLER_33_441 VGND VGND VPWR VPWR sky130_fd_sc_hd__decap_3
XFILLER_33_452 VGND VGND VPWR VPWR sky130_fd_sc_hd__decap_3
XFILLER_80_569 VGND VGND VPWR VPWR sky130_fd_sc_hd__decap_3
X_7631_ _7631_/A _7631_/B _7631_/C _7631_/D VGND VGND VPWR VPWR _7631_/X sky130_fd_sc_hd__or4_4
X_5892_ _5925_/B _5890_/X _5891_/X VGND VGND VPWR VPWR _5892_/X sky130_fd_sc_hd__a21o_2
XTAP_TAPCELL_ROW_51_918 VGND VPWR sky130_fd_sc_hd__tapvpwrvgnd_1
XFILLER_33_485 VGND VGND VPWR VPWR sky130_fd_sc_hd__decap_3
XFILLER_60_271 VGND VGND VPWR VPWR sky130_fd_sc_hd__decap_3
X_4843_ _8193_/Q _8257_/Q VGND VGND VPWR VPWR _4998_/A sky130_fd_sc_hd__or2b_2
XFILLER_20_135 VGND VGND VPWR VPWR sky130_fd_sc_hd__decap_3
X_7562_ _7562_/A _7562_/B VGND VGND VPWR VPWR _7563_/B sky130_fd_sc_hd__nand2_2
X_4774_ _8208_/Q _7222_/B VGND VGND VPWR VPWR _4776_/A sky130_fd_sc_hd__nand2_2
XFILLER_20_168 VGND VGND VPWR VPWR sky130_fd_sc_hd__decap_3
X_7493_ _7575_/A _7575_/B _7575_/C VGND VGND VPWR VPWR _7494_/B sky130_fd_sc_hd__nor3_2
Xrebuffer918 _7216_/X VGND VGND VPWR VPWR _7218_/A sky130_fd_sc_hd__buf_2
X_6513_ _6130_/B _5913_/B _6571_/C _6512_/X _5477_/X VGND VGND VPWR VPWR _6513_/X
+ sky130_fd_sc_hd__a32o_2
XTAP_TAPCELL_ROW_99_1552 VGND VPWR sky130_fd_sc_hd__tapvpwrvgnd_1
XTAP_TAPCELL_ROW_99_1541 VGND VPWR sky130_fd_sc_hd__tapvpwrvgnd_1
XTAP_TAPCELL_ROW_31_664 VGND VPWR sky130_fd_sc_hd__tapvpwrvgnd_1
XFILLER_119_557 VGND VGND VPWR VPWR sky130_fd_sc_hd__decap_3
Xclkbuf_leaf_9_clk clkload1/A VGND VGND VPWR VPWR _8285_/CLK sky130_fd_sc_hd__clkbuf_8
X_6444_ _7640_/A1 _6439_/X _6443_/Y _6220_/A VGND VGND VPWR VPWR _6444_/X sky130_fd_sc_hd__a22o_2
XFILLER_106_218 VGND VGND VPWR VPWR sky130_fd_sc_hd__decap_3
X_6375_ _8186_/Q _5701_/X _6374_/X _8288_/Q VGND VGND VPWR VPWR _6375_/X sky130_fd_sc_hd__o22a_2
XFILLER_87_102 VGND VGND VPWR VPWR sky130_fd_sc_hd__fill_1
X_8114_ _8382_/CLK _8114_/D VGND VGND VPWR VPWR _8114_/Q sky130_fd_sc_hd__dfxtp_2
X_5326_ _6706_/S _5411_/B _5858_/B VGND VGND VPWR VPWR _5326_/X sky130_fd_sc_hd__a21o_2
XFILLER_102_413 VGND VGND VPWR VPWR sky130_fd_sc_hd__decap_3
XFILLER_102_424 VGND VGND VPWR VPWR sky130_fd_sc_hd__decap_3
XFILLER_87_113 VGND VGND VPWR VPWR sky130_fd_sc_hd__decap_3
XFILLER_88_658 VGND VGND VPWR VPWR sky130_fd_sc_hd__fill_2
X_8045_ clkload9/A _8045_/D VGND VGND VPWR VPWR _8045_/Q sky130_fd_sc_hd__dfxtp_2
X_5257_ _8185_/Q _8186_/Q _7805_/A VGND VGND VPWR VPWR _5257_/X sky130_fd_sc_hd__mux2_2
XFILLER_102_468 VGND VGND VPWR VPWR sky130_fd_sc_hd__decap_3
XFILLER_57_39 VGND VGND VPWR VPWR sky130_fd_sc_hd__decap_3
XFILLER_75_308 VGND VGND VPWR VPWR sky130_fd_sc_hd__fill_2
X_4208_ _7898_/B _4208_/B VGND VGND VPWR VPWR _4209_/A sky130_fd_sc_hd__and2_2
XTAP_TAPCELL_ROW_3_301 VGND VPWR sky130_fd_sc_hd__tapvpwrvgnd_1
XFILLER_113_12 VGND VGND VPWR VPWR sky130_fd_sc_hd__decap_3
XFILLER_56_511 VGND VGND VPWR VPWR sky130_fd_sc_hd__decap_3
XFILLER_68_371 VGND VGND VPWR VPWR sky130_fd_sc_hd__fill_1
XFILLER_96_691 VGND VGND VPWR VPWR sky130_fd_sc_hd__decap_3
X_5188_ _6686_/A _5073_/X _5076_/Y _5187_/X VGND VGND VPWR VPWR _5188_/X sky130_fd_sc_hd__o31a_2
XFILLER_28_246 VGND VGND VPWR VPWR sky130_fd_sc_hd__decap_3
XFILLER_56_533 VGND VGND VPWR VPWR sky130_fd_sc_hd__decap_3
XFILLER_56_555 VGND VGND VPWR VPWR sky130_fd_sc_hd__decap_3
XFILLER_83_330 VGND VGND VPWR VPWR sky130_fd_sc_hd__decap_3
X_4139_ _4139_/A VGND VGND VPWR VPWR _8007_/D sky130_fd_sc_hd__buf_1
XFILLER_71_503 VGND VGND VPWR VPWR sky130_fd_sc_hd__fill_1
XFILLER_71_514 VGND VGND VPWR VPWR sky130_fd_sc_hd__decap_3
XFILLER_83_352 VGND VGND VPWR VPWR sky130_fd_sc_hd__decap_3
XFILLER_83_385 VGND VGND VPWR VPWR sky130_fd_sc_hd__decap_3
XTAP_TAPCELL_ROW_39_764 VGND VPWR sky130_fd_sc_hd__tapvpwrvgnd_1
XFILLER_83_396 VGND VGND VPWR VPWR sky130_fd_sc_hd__fill_1
XFILLER_36_290 VGND VGND VPWR VPWR sky130_fd_sc_hd__decap_3
XFILLER_11_113 VGND VGND VPWR VPWR sky130_fd_sc_hd__fill_1
XFILLER_12_614 VGND VGND VPWR VPWR sky130_fd_sc_hd__decap_3
XFILLER_51_260 VGND VGND VPWR VPWR sky130_fd_sc_hd__decap_3
X_7829_ _7748_/X _7824_/X _7829_/S VGND VGND VPWR VPWR _7829_/X sky130_fd_sc_hd__mux2_2
XFILLER_11_157 VGND VGND VPWR VPWR sky130_fd_sc_hd__decap_3
XFILLER_22_97 VGND VGND VPWR VPWR sky130_fd_sc_hd__decap_3
XTAP_TAPCELL_ROW_59_1024 VGND VPWR sky130_fd_sc_hd__tapvpwrvgnd_1
XFILLER_98_68 VGND VGND VPWR VPWR sky130_fd_sc_hd__decap_3
XFILLER_105_240 VGND VGND VPWR VPWR sky130_fd_sc_hd__decap_3
XFILLER_79_614 VGND VGND VPWR VPWR sky130_fd_sc_hd__fill_2
XFILLER_105_284 VGND VGND VPWR VPWR sky130_fd_sc_hd__decap_3
XFILLER_78_157 VGND VGND VPWR VPWR sky130_fd_sc_hd__decap_3
XFILLER_94_606 VGND VGND VPWR VPWR sky130_fd_sc_hd__fill_2
XFILLER_59_382 VGND VGND VPWR VPWR sky130_fd_sc_hd__decap_3
XFILLER_93_116 VGND VGND VPWR VPWR sky130_fd_sc_hd__decap_3
XFILLER_94_639 VGND VGND VPWR VPWR sky130_fd_sc_hd__decap_3
XFILLER_19_246 VGND VGND VPWR VPWR sky130_fd_sc_hd__fill_1
XFILLER_47_555 VGND VGND VPWR VPWR sky130_fd_sc_hd__decap_3
XFILLER_59_393 VGND VGND VPWR VPWR sky130_fd_sc_hd__decap_3
XFILLER_74_330 VGND VGND VPWR VPWR sky130_fd_sc_hd__decap_3
XFILLER_19_257 VGND VGND VPWR VPWR sky130_fd_sc_hd__decap_3
XFILLER_47_588 VGND VGND VPWR VPWR sky130_fd_sc_hd__decap_3
XFILLER_62_503 VGND VGND VPWR VPWR sky130_fd_sc_hd__decap_3
XFILLER_62_525 VGND VGND VPWR VPWR sky130_fd_sc_hd__decap_3
XFILLER_74_363 VGND VGND VPWR VPWR sky130_fd_sc_hd__fill_1
XFILLER_74_374 VGND VGND VPWR VPWR sky130_fd_sc_hd__decap_3
XFILLER_34_249 VGND VGND VPWR VPWR sky130_fd_sc_hd__decap_3
XFILLER_15_463 VGND VGND VPWR VPWR sky130_fd_sc_hd__decap_3
XFILLER_27_290 VGND VGND VPWR VPWR sky130_fd_sc_hd__decap_3
XFILLER_62_569 VGND VGND VPWR VPWR sky130_fd_sc_hd__decap_3
XFILLER_63_60 VGND VGND VPWR VPWR sky130_fd_sc_hd__decap_3
XTAP_TAPCELL_ROW_83_1342 VGND VPWR sky130_fd_sc_hd__tapvpwrvgnd_1
XFILLER_15_474 VGND VGND VPWR VPWR sky130_fd_sc_hd__decap_3
XFILLER_30_411 VGND VGND VPWR VPWR sky130_fd_sc_hd__decap_3
XFILLER_42_282 VGND VGND VPWR VPWR sky130_fd_sc_hd__decap_3
XFILLER_116_505 VGND VGND VPWR VPWR sky130_fd_sc_hd__decap_3
XFILLER_8_88 VGND VGND VPWR VPWR sky130_fd_sc_hd__fill_1
XFILLER_6_150 VGND VGND VPWR VPWR sky130_fd_sc_hd__fill_2
XFILLER_6_161 VGND VGND VPWR VPWR sky130_fd_sc_hd__decap_3
XFILLER_7_662 VGND VGND VPWR VPWR sky130_fd_sc_hd__decap_3
XFILLER_7_673 VGND VGND VPWR VPWR sky130_fd_sc_hd__decap_3
X_4490_ _7898_/B _8049_/Q VGND VGND VPWR VPWR _4491_/A sky130_fd_sc_hd__and2_2
XFILLER_6_183 VGND VGND VPWR VPWR sky130_fd_sc_hd__decap_3
XFILLER_40_3 VGND VGND VPWR VPWR sky130_fd_sc_hd__fill_2
X_6160_ _8289_/Q _6159_/Y _8290_/Q VGND VGND VPWR VPWR _6160_/Y sky130_fd_sc_hd__a21oi_2
XTAP_TAPCELL_ROW_94_1482 VGND VPWR sky130_fd_sc_hd__tapvpwrvgnd_1
XFILLER_69_113 VGND VGND VPWR VPWR sky130_fd_sc_hd__decap_3
XFILLER_97_444 VGND VGND VPWR VPWR sky130_fd_sc_hd__decap_3
X_5111_ _5108_/X _5110_/Y _7631_/B VGND VGND VPWR VPWR _5111_/X sky130_fd_sc_hd__o21a_2
XFILLER_111_243 VGND VGND VPWR VPWR sky130_fd_sc_hd__decap_3
XFILLER_85_606 VGND VGND VPWR VPWR sky130_fd_sc_hd__decap_3
XFILLER_97_455 VGND VGND VPWR VPWR sky130_fd_sc_hd__decap_3
X_6091_ _5587_/X _6089_/X _6090_/X _5108_/X VGND VGND VPWR VPWR _6091_/X sky130_fd_sc_hd__a22o_2
XFILLER_111_265 VGND VGND VPWR VPWR sky130_fd_sc_hd__decap_3
XFILLER_111_287 VGND VGND VPWR VPWR sky130_fd_sc_hd__decap_3
XFILLER_57_319 VGND VGND VPWR VPWR sky130_fd_sc_hd__decap_3
XFILLER_84_105 VGND VGND VPWR VPWR sky130_fd_sc_hd__decap_3
XFILLER_85_628 VGND VGND VPWR VPWR sky130_fd_sc_hd__decap_3
XFILLER_97_488 VGND VGND VPWR VPWR sky130_fd_sc_hd__decap_3
X_5042_ _6393_/B _4897_/A _4893_/X VGND VGND VPWR VPWR _5042_/X sky130_fd_sc_hd__o21a_2
XFILLER_93_650 VGND VGND VPWR VPWR sky130_fd_sc_hd__decap_3
XFILLER_25_205 VGND VGND VPWR VPWR sky130_fd_sc_hd__fill_2
XFILLER_53_514 VGND VGND VPWR VPWR sky130_fd_sc_hd__decap_3
XFILLER_65_352 VGND VGND VPWR VPWR sky130_fd_sc_hd__decap_3
XFILLER_92_160 VGND VGND VPWR VPWR sky130_fd_sc_hd__fill_1
XFILLER_53_558 VGND VGND VPWR VPWR sky130_fd_sc_hd__fill_2
XFILLER_65_396 VGND VGND VPWR VPWR sky130_fd_sc_hd__decap_3
XFILLER_80_322 VGND VGND VPWR VPWR sky130_fd_sc_hd__decap_3
XFILLER_92_182 VGND VGND VPWR VPWR sky130_fd_sc_hd__decap_3
X_6993_ _4813_/B _6968_/Y _8203_/Q VGND VGND VPWR VPWR _6993_/X sky130_fd_sc_hd__o21ba_2
XTAP_TAPCELL_ROW_36_723 VGND VPWR sky130_fd_sc_hd__tapvpwrvgnd_1
XFILLER_41_709 VGND VGND VPWR VPWR sky130_fd_sc_hd__fill_2
X_5944_ _6095_/A _8173_/Q _5944_/C _5944_/D VGND VGND VPWR VPWR _6825_/A sky130_fd_sc_hd__nand4_4
XFILLER_21_422 VGND VGND VPWR VPWR sky130_fd_sc_hd__decap_3
XFILLER_61_580 VGND VGND VPWR VPWR sky130_fd_sc_hd__decap_3
X_5875_ _4947_/B _5562_/B _5868_/X _5874_/X VGND VGND VPWR VPWR _5876_/B sky130_fd_sc_hd__a31o_2
X_7614_ _8223_/Q _7646_/B _7840_/C _8222_/Q VGND VGND VPWR VPWR _7614_/X sky130_fd_sc_hd__o211a_2
X_4826_ _8197_/Q _4827_/B VGND VGND VPWR VPWR _4828_/A sky130_fd_sc_hd__nor2_2
XFILLER_21_477 VGND VGND VPWR VPWR sky130_fd_sc_hd__fill_1
X_7545_ _7582_/B _7583_/C _7583_/D _8220_/Q VGND VGND VPWR VPWR _7545_/X sky130_fd_sc_hd__a31o_2
XFILLER_119_332 VGND VGND VPWR VPWR sky130_fd_sc_hd__decap_3
Xrebuffer726 _6177_/X VGND VGND VPWR VPWR _6178_/B sky130_fd_sc_hd__buf_2
Xrebuffer737 _5310_/B VGND VGND VPWR VPWR _5430_/B sky130_fd_sc_hd__buf_4
X_4757_ _8213_/Q VGND VGND VPWR VPWR _7319_/A sky130_fd_sc_hd__inv_2
XFILLER_107_505 VGND VGND VPWR VPWR sky130_fd_sc_hd__decap_3
XFILLER_107_516 VGND VGND VPWR VPWR sky130_fd_sc_hd__decap_3
XFILLER_119_365 VGND VGND VPWR VPWR sky130_fd_sc_hd__decap_3
XFILLER_4_109 VGND VGND VPWR VPWR sky130_fd_sc_hd__decap_3
X_7476_ _8218_/Q _7476_/B _7476_/C VGND VGND VPWR VPWR _7476_/X sky130_fd_sc_hd__or3_2
X_4688_ _7843_/A _8148_/Q VGND VGND VPWR VPWR _4689_/A sky130_fd_sc_hd__and2_2
XFILLER_108_12 VGND VGND VPWR VPWR sky130_fd_sc_hd__fill_1
X_6427_ _8223_/Q _5822_/B _6641_/C VGND VGND VPWR VPWR _6427_/X sky130_fd_sc_hd__mux2_2
X_6358_ _8290_/Q _6343_/Y _6345_/X _5812_/A _6357_/Y VGND VGND VPWR VPWR _6358_/X
+ sky130_fd_sc_hd__a221o_2
XFILLER_0_337 VGND VGND VPWR VPWR sky130_fd_sc_hd__decap_3
XFILLER_102_221 VGND VGND VPWR VPWR sky130_fd_sc_hd__decap_3
XFILLER_88_411 VGND VGND VPWR VPWR sky130_fd_sc_hd__fill_1
X_5309_ _5193_/X _5197_/X _5198_/Y _5308_/Y _7898_/B VGND VGND VPWR VPWR _8295_/D
+ sky130_fd_sc_hd__o311a_2
XFILLER_0_348 VGND VGND VPWR VPWR sky130_fd_sc_hd__decap_3
XFILLER_76_617 VGND VGND VPWR VPWR sky130_fd_sc_hd__decap_3
XFILLER_88_455 VGND VGND VPWR VPWR sky130_fd_sc_hd__decap_3
XFILLER_88_477 VGND VGND VPWR VPWR sky130_fd_sc_hd__decap_3
X_6289_ _8243_/Q _6290_/B _8179_/Q VGND VGND VPWR VPWR _6289_/X sky130_fd_sc_hd__o21a_2
XFILLER_102_287 VGND VGND VPWR VPWR sky130_fd_sc_hd__decap_3
XFILLER_29_511 VGND VGND VPWR VPWR sky130_fd_sc_hd__decap_3
X_8028_ clkload3/A _8028_/D VGND VGND VPWR VPWR _8028_/Q sky130_fd_sc_hd__dfxtp_2
XFILLER_29_544 VGND VGND VPWR VPWR sky130_fd_sc_hd__decap_3
XFILLER_56_330 VGND VGND VPWR VPWR sky130_fd_sc_hd__decap_3
XFILLER_84_26 VGND VGND VPWR VPWR sky130_fd_sc_hd__fill_2
XFILLER_56_374 VGND VGND VPWR VPWR sky130_fd_sc_hd__decap_3
XFILLER_84_672 VGND VGND VPWR VPWR sky130_fd_sc_hd__decap_3
XFILLER_90_108 VGND VGND VPWR VPWR sky130_fd_sc_hd__decap_3
XFILLER_16_227 VGND VGND VPWR VPWR sky130_fd_sc_hd__decap_3
XFILLER_83_182 VGND VGND VPWR VPWR sky130_fd_sc_hd__decap_3
XFILLER_44_558 VGND VGND VPWR VPWR sky130_fd_sc_hd__fill_2
XFILLER_71_355 VGND VGND VPWR VPWR sky130_fd_sc_hd__decap_3
XFILLER_31_219 VGND VGND VPWR VPWR sky130_fd_sc_hd__decap_3
XFILLER_71_388 VGND VGND VPWR VPWR sky130_fd_sc_hd__decap_3
XFILLER_71_399 VGND VGND VPWR VPWR sky130_fd_sc_hd__decap_3
XFILLER_12_433 VGND VGND VPWR VPWR sky130_fd_sc_hd__decap_3
XFILLER_24_293 VGND VGND VPWR VPWR sky130_fd_sc_hd__decap_3
XTAP_TAPCELL_ROW_14_439 VGND VPWR sky130_fd_sc_hd__tapvpwrvgnd_1
XFILLER_12_466 VGND VGND VPWR VPWR sky130_fd_sc_hd__decap_3
XFILLER_8_415 VGND VGND VPWR VPWR sky130_fd_sc_hd__decap_3
XFILLER_8_448 VGND VGND VPWR VPWR sky130_fd_sc_hd__decap_3
XFILLER_8_459 VGND VGND VPWR VPWR sky130_fd_sc_hd__decap_3
XFILLER_4_632 VGND VGND VPWR VPWR sky130_fd_sc_hd__decap_3
XFILLER_99_709 VGND VGND VPWR VPWR sky130_fd_sc_hd__fill_2
XFILLER_106_560 VGND VGND VPWR VPWR sky130_fd_sc_hd__decap_3
XFILLER_113_508 VGND VGND VPWR VPWR sky130_fd_sc_hd__fill_1
XFILLER_4_654 VGND VGND VPWR VPWR sky130_fd_sc_hd__decap_3
XFILLER_79_422 VGND VGND VPWR VPWR sky130_fd_sc_hd__decap_3
XFILLER_39_308 VGND VGND VPWR VPWR sky130_fd_sc_hd__decap_3
XFILLER_67_617 VGND VGND VPWR VPWR sky130_fd_sc_hd__decap_3
XFILLER_79_444 VGND VGND VPWR VPWR sky130_fd_sc_hd__decap_3
XFILLER_79_455 VGND VGND VPWR VPWR sky130_fd_sc_hd__fill_2
XFILLER_58_71 VGND VGND VPWR VPWR sky130_fd_sc_hd__decap_3
XFILLER_79_477 VGND VGND VPWR VPWR sky130_fd_sc_hd__decap_3
XFILLER_94_436 VGND VGND VPWR VPWR sky130_fd_sc_hd__decap_3
XFILLER_47_330 VGND VGND VPWR VPWR sky130_fd_sc_hd__decap_3
XFILLER_66_149 VGND VGND VPWR VPWR sky130_fd_sc_hd__fill_2
XFILLER_82_609 VGND VGND VPWR VPWR sky130_fd_sc_hd__decap_3
XFILLER_47_363 VGND VGND VPWR VPWR sky130_fd_sc_hd__decap_3
XFILLER_81_119 VGND VGND VPWR VPWR sky130_fd_sc_hd__decap_3
XFILLER_35_536 VGND VGND VPWR VPWR sky130_fd_sc_hd__decap_3
XFILLER_47_396 VGND VGND VPWR VPWR sky130_fd_sc_hd__decap_3
XFILLER_62_333 VGND VGND VPWR VPWR sky130_fd_sc_hd__decap_3
XFILLER_75_694 VGND VGND VPWR VPWR sky130_fd_sc_hd__fill_1
XFILLER_35_558 VGND VGND VPWR VPWR sky130_fd_sc_hd__fill_2
XFILLER_74_81 VGND VGND VPWR VPWR sky130_fd_sc_hd__decap_3
XFILLER_74_92 VGND VGND VPWR VPWR sky130_fd_sc_hd__decap_3
X_3990_ _8348_/Q _7930_/B VGND VGND VPWR VPWR _3991_/A sky130_fd_sc_hd__and2_2
XFILLER_22_219 VGND VGND VPWR VPWR sky130_fd_sc_hd__decap_3
XFILLER_50_528 VGND VGND VPWR VPWR sky130_fd_sc_hd__decap_3
XFILLER_50_539 VGND VGND VPWR VPWR sky130_fd_sc_hd__decap_3
XFILLER_62_388 VGND VGND VPWR VPWR sky130_fd_sc_hd__decap_3
XFILLER_15_293 VGND VGND VPWR VPWR sky130_fd_sc_hd__decap_3
X_5660_ _6707_/S _5417_/A _5659_/X _5528_/A _5017_/Y VGND VGND VPWR VPWR _5660_/X
+ sky130_fd_sc_hd__o221a_2
X_4611_ _4611_/A VGND VGND VPWR VPWR _8243_/D sky130_fd_sc_hd__buf_1
XFILLER_30_274 VGND VGND VPWR VPWR sky130_fd_sc_hd__fill_1
XFILLER_30_285 VGND VGND VPWR VPWR sky130_fd_sc_hd__decap_3
X_5591_ _7562_/A _5690_/C VGND VGND VPWR VPWR _5593_/B sky130_fd_sc_hd__and2_2
XTAP_TAPCELL_ROW_96_1511 VGND VPWR sky130_fd_sc_hd__tapvpwrvgnd_1
XTAP_TAPCELL_ROW_41_792 VGND VPWR sky130_fd_sc_hd__tapvpwrvgnd_1
X_7330_ _7326_/Y _7551_/B _7329_/Y _5076_/Y VGND VGND VPWR VPWR _7331_/B sky130_fd_sc_hd__o22a_2
X_4542_ _7843_/A _8075_/Q VGND VGND VPWR VPWR _4543_/A sky130_fd_sc_hd__and2_2
XFILLER_7_481 VGND VGND VPWR VPWR sky130_fd_sc_hd__decap_3
X_7261_ _5333_/A _8290_/Q _7260_/Y _5626_/A _8275_/Q VGND VGND VPWR VPWR _7261_/X
+ sky130_fd_sc_hd__a32o_2
X_4473_ _4473_/A VGND VGND VPWR VPWR _8174_/D sky130_fd_sc_hd__buf_1
XFILLER_116_357 VGND VGND VPWR VPWR sky130_fd_sc_hd__decap_3
XFILLER_116_368 VGND VGND VPWR VPWR sky130_fd_sc_hd__decap_3
XFILLER_89_208 VGND VGND VPWR VPWR sky130_fd_sc_hd__decap_3
X_6212_ _5433_/X _6210_/X _6213_/B1 _5665_/X VGND VGND VPWR VPWR _6212_/X sky130_fd_sc_hd__a22o_2
XPHY_EDGE_ROW_115_Right_115 VGND VGND VPWR VPWR sky130_fd_sc_hd__decap_3
X_7192_ _8290_/Q _7188_/Y _7191_/X _5627_/A _6687_/A VGND VGND VPWR VPWR _7192_/X
+ sky130_fd_sc_hd__a221o_2
X_6143_ _5435_/A _6144_/B1 _6143_/B1 _6624_/A VGND VGND VPWR VPWR _6143_/X sky130_fd_sc_hd__a2bb2o_2
XFILLER_112_563 VGND VGND VPWR VPWR sky130_fd_sc_hd__decap_3
XFILLER_57_116 VGND VGND VPWR VPWR sky130_fd_sc_hd__decap_3
XFILLER_85_425 VGND VGND VPWR VPWR sky130_fd_sc_hd__decap_3
XFILLER_97_274 VGND VGND VPWR VPWR sky130_fd_sc_hd__decap_3
X_6074_ _6074_/A _6074_/B _6074_/C VGND VGND VPWR VPWR _6074_/X sky130_fd_sc_hd__and3_2
XFILLER_85_458 VGND VGND VPWR VPWR sky130_fd_sc_hd__decap_3
X_5025_ _5888_/A _5888_/B VGND VGND VPWR VPWR _5886_/B sky130_fd_sc_hd__nand2_2
XFILLER_26_514 VGND VGND VPWR VPWR sky130_fd_sc_hd__decap_3
XFILLER_38_363 VGND VGND VPWR VPWR sky130_fd_sc_hd__fill_1
XFILLER_26_536 VGND VGND VPWR VPWR sky130_fd_sc_hd__decap_3
XFILLER_38_374 VGND VGND VPWR VPWR sky130_fd_sc_hd__decap_3
XFILLER_53_300 VGND VGND VPWR VPWR sky130_fd_sc_hd__decap_3
XFILLER_54_18 VGND VGND VPWR VPWR sky130_fd_sc_hd__decap_3
XFILLER_54_29 VGND VGND VPWR VPWR sky130_fd_sc_hd__decap_3
XFILLER_66_683 VGND VGND VPWR VPWR sky130_fd_sc_hd__decap_3
XFILLER_93_491 VGND VGND VPWR VPWR sky130_fd_sc_hd__decap_3
XTAP_TAPCELL_ROW_49_892 VGND VPWR sky130_fd_sc_hd__tapvpwrvgnd_1
XFILLER_26_558 VGND VGND VPWR VPWR sky130_fd_sc_hd__decap_3
XFILLER_53_366 VGND VGND VPWR VPWR sky130_fd_sc_hd__decap_3
XFILLER_65_193 VGND VGND VPWR VPWR sky130_fd_sc_hd__decap_3
XFILLER_80_141 VGND VGND VPWR VPWR sky130_fd_sc_hd__decap_3
X_6976_ _8203_/Q _6976_/B VGND VGND VPWR VPWR _6976_/Y sky130_fd_sc_hd__xnor2_2
XFILLER_34_580 VGND VGND VPWR VPWR sky130_fd_sc_hd__decap_3
XFILLER_41_517 VGND VGND VPWR VPWR sky130_fd_sc_hd__decap_3
X_5927_ _5900_/S _8237_/Q _5890_/X _5925_/B _5891_/X VGND VGND VPWR VPWR _5928_/B
+ sky130_fd_sc_hd__a221o_2
XFILLER_110_68 VGND VGND VPWR VPWR sky130_fd_sc_hd__decap_3
XFILLER_22_731 VGND VGND VPWR VPWR sky130_fd_sc_hd__fill_2
XFILLER_70_17 VGND VGND VPWR VPWR sky130_fd_sc_hd__decap_3
XFILLER_21_252 VGND VGND VPWR VPWR sky130_fd_sc_hd__decap_3
XFILLER_21_263 VGND VGND VPWR VPWR sky130_fd_sc_hd__fill_2
X_5858_ _6775_/B _5858_/B VGND VGND VPWR VPWR _6132_/A sky130_fd_sc_hd__or2_2
XFILLER_21_296 VGND VGND VPWR VPWR sky130_fd_sc_hd__decap_3
XPHY_EDGE_ROW_17_Right_17 VGND VGND VPWR VPWR sky130_fd_sc_hd__decap_3
X_5789_ _5026_/B _5757_/Y _7783_/B VGND VGND VPWR VPWR _5789_/X sky130_fd_sc_hd__a21o_2
X_4809_ _6903_/S _8264_/Q VGND VGND VPWR VPWR _6873_/A sky130_fd_sc_hd__nor2_2
XFILLER_119_44 VGND VGND VPWR VPWR sky130_fd_sc_hd__decap_3
X_7528_ _7527_/X _7478_/X _7418_/X _7348_/X _7812_/A _7670_/A VGND VGND VPWR VPWR
+ _7528_/X sky130_fd_sc_hd__mux4_2
XFILLER_107_324 VGND VGND VPWR VPWR sky130_fd_sc_hd__decap_3
X_7459_ _8217_/Q _8281_/Q _7458_/X VGND VGND VPWR VPWR _7460_/B sky130_fd_sc_hd__o21ai_2
XFILLER_119_88 VGND VGND VPWR VPWR sky130_fd_sc_hd__decap_3
XFILLER_103_552 VGND VGND VPWR VPWR sky130_fd_sc_hd__decap_3
XFILLER_49_617 VGND VGND VPWR VPWR sky130_fd_sc_hd__fill_1
XFILLER_88_274 VGND VGND VPWR VPWR sky130_fd_sc_hd__fill_1
XFILLER_95_36 VGND VGND VPWR VPWR sky130_fd_sc_hd__decap_3
XPHY_EDGE_ROW_26_Right_26 VGND VGND VPWR VPWR sky130_fd_sc_hd__decap_3
XFILLER_28_41 VGND VGND VPWR VPWR sky130_fd_sc_hd__decap_3
XFILLER_48_138 VGND VGND VPWR VPWR sky130_fd_sc_hd__fill_2
XFILLER_76_436 VGND VGND VPWR VPWR sky130_fd_sc_hd__fill_1
XFILLER_88_296 VGND VGND VPWR VPWR sky130_fd_sc_hd__decap_3
XFILLER_28_74 VGND VGND VPWR VPWR sky130_fd_sc_hd__decap_3
XFILLER_63_119 VGND VGND VPWR VPWR sky130_fd_sc_hd__decap_3
XFILLER_91_417 VGND VGND VPWR VPWR sky130_fd_sc_hd__decap_3
XTAP_TAPCELL_ROW_19_509 VGND VPWR sky130_fd_sc_hd__tapvpwrvgnd_1
XFILLER_28_85 VGND VGND VPWR VPWR sky130_fd_sc_hd__decap_3
XFILLER_29_396 VGND VGND VPWR VPWR sky130_fd_sc_hd__decap_3
XFILLER_56_171 VGND VGND VPWR VPWR sky130_fd_sc_hd__fill_2
XFILLER_84_480 VGND VGND VPWR VPWR sky130_fd_sc_hd__fill_2
XFILLER_91_439 VGND VGND VPWR VPWR sky130_fd_sc_hd__fill_2
XTAP_TAPCELL_ROW_67_1134 VGND VPWR sky130_fd_sc_hd__tapvpwrvgnd_1
XFILLER_17_569 VGND VGND VPWR VPWR sky130_fd_sc_hd__decap_3
XFILLER_72_642 VGND VGND VPWR VPWR sky130_fd_sc_hd__fill_2
XFILLER_72_653 VGND VGND VPWR VPWR sky130_fd_sc_hd__decap_3
XFILLER_32_517 VGND VGND VPWR VPWR sky130_fd_sc_hd__decap_3
XFILLER_44_377 VGND VGND VPWR VPWR sky130_fd_sc_hd__decap_3
XFILLER_44_40 VGND VGND VPWR VPWR sky130_fd_sc_hd__decap_3
XFILLER_72_686 VGND VGND VPWR VPWR sky130_fd_sc_hd__fill_2
XTAP_TAPCELL_ROW_80_1301 VGND VPWR sky130_fd_sc_hd__tapvpwrvgnd_1
XFILLER_12_230 VGND VGND VPWR VPWR sky130_fd_sc_hd__decap_3
XFILLER_9_702 VGND VGND VPWR VPWR sky130_fd_sc_hd__decap_3
XFILLER_40_572 VGND VGND VPWR VPWR sky130_fd_sc_hd__decap_3
XPHY_EDGE_ROW_35_Right_35 VGND VGND VPWR VPWR sky130_fd_sc_hd__decap_3
XFILLER_12_296 VGND VGND VPWR VPWR sky130_fd_sc_hd__fill_2
XFILLER_8_234 VGND VGND VPWR VPWR sky130_fd_sc_hd__decap_3
XTAP_TAPCELL_ROW_119_1809 VGND VPWR sky130_fd_sc_hd__tapvpwrvgnd_1
XFILLER_60_83 VGND VGND VPWR VPWR sky130_fd_sc_hd__fill_1
XFILLER_8_256 VGND VGND VPWR VPWR sky130_fd_sc_hd__decap_3
XFILLER_8_278 VGND VGND VPWR VPWR sky130_fd_sc_hd__decap_3
XFILLER_60_94 VGND VGND VPWR VPWR sky130_fd_sc_hd__decap_3
XFILLER_99_517 VGND VGND VPWR VPWR sky130_fd_sc_hd__decap_3
XFILLER_99_528 VGND VGND VPWR VPWR sky130_fd_sc_hd__decap_3
XTAP_TAPCELL_ROW_78_1274 VGND VPWR sky130_fd_sc_hd__tapvpwrvgnd_1
XTAP_TAPCELL_ROW_91_1441 VGND VPWR sky130_fd_sc_hd__tapvpwrvgnd_1
XFILLER_113_349 VGND VGND VPWR VPWR sky130_fd_sc_hd__decap_3
XFILLER_79_241 VGND VGND VPWR VPWR sky130_fd_sc_hd__fill_1
XPHY_EDGE_ROW_44_Right_44 VGND VGND VPWR VPWR sky130_fd_sc_hd__decap_3
XFILLER_39_105 VGND VGND VPWR VPWR sky130_fd_sc_hd__decap_3
XFILLER_39_116 VGND VGND VPWR VPWR sky130_fd_sc_hd__fill_2
XFILLER_67_414 VGND VGND VPWR VPWR sky130_fd_sc_hd__decap_3
XFILLER_94_200 VGND VGND VPWR VPWR sky130_fd_sc_hd__decap_3
XFILLER_39_127 VGND VGND VPWR VPWR sky130_fd_sc_hd__decap_3
XFILLER_67_447 VGND VGND VPWR VPWR sky130_fd_sc_hd__fill_1
XFILLER_67_458 VGND VGND VPWR VPWR sky130_fd_sc_hd__decap_3
XFILLER_79_296 VGND VGND VPWR VPWR sky130_fd_sc_hd__decap_3
XFILLER_94_244 VGND VGND VPWR VPWR sky130_fd_sc_hd__decap_3
XFILLER_48_672 VGND VGND VPWR VPWR sky130_fd_sc_hd__decap_3
XFILLER_94_277 VGND VGND VPWR VPWR sky130_fd_sc_hd__decap_3
XPHY_EDGE_ROW_19_Left_139 VGND VGND VPWR VPWR sky130_fd_sc_hd__decap_3
XFILLER_47_160 VGND VGND VPWR VPWR sky130_fd_sc_hd__decap_3
XFILLER_63_620 VGND VGND VPWR VPWR sky130_fd_sc_hd__fill_2
XFILLER_82_439 VGND VGND VPWR VPWR sky130_fd_sc_hd__decap_3
XFILLER_35_333 VGND VGND VPWR VPWR sky130_fd_sc_hd__decap_3
XFILLER_35_355 VGND VGND VPWR VPWR sky130_fd_sc_hd__decap_3
XFILLER_62_130 VGND VGND VPWR VPWR sky130_fd_sc_hd__decap_3
XFILLER_62_141 VGND VGND VPWR VPWR sky130_fd_sc_hd__decap_3
XFILLER_63_653 VGND VGND VPWR VPWR sky130_fd_sc_hd__decap_3
X_6830_ _8198_/Q _8262_/Q VGND VGND VPWR VPWR _6848_/B sky130_fd_sc_hd__nand2_2
XTAP_TAPCELL_ROW_46_851 VGND VPWR sky130_fd_sc_hd__tapvpwrvgnd_1
XFILLER_35_399 VGND VGND VPWR VPWR sky130_fd_sc_hd__decap_3
XFILLER_90_472 VGND VGND VPWR VPWR sky130_fd_sc_hd__decap_3
XFILLER_90_483 VGND VGND VPWR VPWR sky130_fd_sc_hd__decap_3
X_6761_ _8260_/Q _6736_/B _6760_/X VGND VGND VPWR VPWR _6807_/B sky130_fd_sc_hd__o21a_2
XTAP_TAPCELL_ROW_46_862 VGND VPWR sky130_fd_sc_hd__tapvpwrvgnd_1
XFILLER_50_336 VGND VGND VPWR VPWR sky130_fd_sc_hd__decap_3
XFILLER_62_185 VGND VGND VPWR VPWR sky130_fd_sc_hd__decap_3
XPHY_EDGE_ROW_53_Right_53 VGND VGND VPWR VPWR sky130_fd_sc_hd__decap_3
X_5712_ _8231_/Q _5662_/X _5711_/X VGND VGND VPWR VPWR _5715_/B sky130_fd_sc_hd__o21a_2
X_3973_ _3973_/A VGND VGND VPWR VPWR _7935_/D sky130_fd_sc_hd__buf_1
XFILLER_31_561 VGND VGND VPWR VPWR sky130_fd_sc_hd__decap_3
X_6692_ _8258_/Q _6674_/X _8194_/Q VGND VGND VPWR VPWR _6692_/X sky130_fd_sc_hd__a21bo_2
XFILLER_31_594 VGND VGND VPWR VPWR sky130_fd_sc_hd__fill_1
X_5643_ _6353_/B _8223_/Q VGND VGND VPWR VPWR _6269_/B sky130_fd_sc_hd__nand2_2
XPHY_EDGE_ROW_28_Left_148 VGND VGND VPWR VPWR sky130_fd_sc_hd__decap_3
X_8362_ _8385_/CLK _8362_/D VGND VGND VPWR VPWR _8362_/Q sky130_fd_sc_hd__dfxtp_2
X_5574_ _5574_/A VGND VGND VPWR VPWR _5574_/Y sky130_fd_sc_hd__inv_2
X_7313_ _7280_/B _8276_/Q _8212_/Q VGND VGND VPWR VPWR _7313_/X sky130_fd_sc_hd__a21o_2
X_4525_ _4525_/A VGND VGND VPWR VPWR _8200_/D sky130_fd_sc_hd__buf_1
X_8293_ clkload9/A _8293_/D VGND VGND VPWR VPWR _8293_/Q sky130_fd_sc_hd__dfxtp_2
XFILLER_116_165 VGND VGND VPWR VPWR sky130_fd_sc_hd__decap_3
XPHY_EDGE_ROW_62_Right_62 VGND VGND VPWR VPWR sky130_fd_sc_hd__decap_3
X_7244_ _7619_/A _8274_/Q _5323_/Y _7631_/B _8210_/Q VGND VGND VPWR VPWR _7244_/X
+ sky130_fd_sc_hd__o2111a_2
X_4456_ _7898_/B _8032_/Q VGND VGND VPWR VPWR _4457_/A sky130_fd_sc_hd__and2_2
XFILLER_98_550 VGND VGND VPWR VPWR sky130_fd_sc_hd__decap_3
X_7175_ _8266_/Q _7174_/X _8202_/Q VGND VGND VPWR VPWR _7175_/X sky130_fd_sc_hd__o21a_2
X_4387_ _4387_/A VGND VGND VPWR VPWR _8131_/D sky130_fd_sc_hd__buf_1
XFILLER_112_371 VGND VGND VPWR VPWR sky130_fd_sc_hd__decap_3
XFILLER_85_200 VGND VGND VPWR VPWR sky130_fd_sc_hd__decap_3
XPHY_EDGE_ROW_0_Left_120 VGND VGND VPWR VPWR sky130_fd_sc_hd__decap_3
X_6126_ _8179_/Q _6101_/X _6117_/X _6125_/X VGND VGND VPWR VPWR _6126_/X sky130_fd_sc_hd__a211o_2
XFILLER_100_522 VGND VGND VPWR VPWR sky130_fd_sc_hd__decap_3
XFILLER_100_544 VGND VGND VPWR VPWR sky130_fd_sc_hd__fill_2
XFILLER_105_46 VGND VGND VPWR VPWR sky130_fd_sc_hd__fill_1
XFILLER_105_57 VGND VGND VPWR VPWR sky130_fd_sc_hd__decap_3
XFILLER_58_436 VGND VGND VPWR VPWR sky130_fd_sc_hd__decap_3
XPHY_EDGE_ROW_37_Left_157 VGND VGND VPWR VPWR sky130_fd_sc_hd__decap_3
XFILLER_39_650 VGND VGND VPWR VPWR sky130_fd_sc_hd__decap_3
XFILLER_58_469 VGND VGND VPWR VPWR sky130_fd_sc_hd__decap_3
XFILLER_73_406 VGND VGND VPWR VPWR sky130_fd_sc_hd__decap_3
XFILLER_85_255 VGND VGND VPWR VPWR sky130_fd_sc_hd__decap_3
XFILLER_85_266 VGND VGND VPWR VPWR sky130_fd_sc_hd__decap_3
X_6057_ _6132_/A VGND VGND VPWR VPWR _6650_/B sky130_fd_sc_hd__buf_1
XFILLER_100_599 VGND VGND VPWR VPWR sky130_fd_sc_hd__decap_3
XFILLER_39_694 VGND VGND VPWR VPWR sky130_fd_sc_hd__decap_3
XFILLER_45_119 VGND VGND VPWR VPWR sky130_fd_sc_hd__fill_2
XFILLER_66_480 VGND VGND VPWR VPWR sky130_fd_sc_hd__decap_3
X_5008_ _4855_/B _5003_/Y _5007_/X VGND VGND VPWR VPWR _5008_/X sky130_fd_sc_hd__o21a_2
XFILLER_38_193 VGND VGND VPWR VPWR sky130_fd_sc_hd__decap_3
XFILLER_14_539 VGND VGND VPWR VPWR sky130_fd_sc_hd__decap_3
XFILLER_53_163 VGND VGND VPWR VPWR sky130_fd_sc_hd__decap_3
XFILLER_81_472 VGND VGND VPWR VPWR sky130_fd_sc_hd__decap_3
XPHY_EDGE_ROW_71_Right_71 VGND VGND VPWR VPWR sky130_fd_sc_hd__decap_3
XFILLER_41_325 VGND VGND VPWR VPWR sky130_fd_sc_hd__fill_2
X_6959_ _6958_/Y _6846_/B _4823_/B _6873_/A VGND VGND VPWR VPWR _6960_/B sky130_fd_sc_hd__a211o_2
XPHY_EDGE_ROW_46_Left_166 VGND VGND VPWR VPWR sky130_fd_sc_hd__decap_3
XTAP_TAPCELL_ROW_62_1064 VGND VPWR sky130_fd_sc_hd__tapvpwrvgnd_1
XTAP_TAPCELL_ROW_24_567 VGND VPWR sky130_fd_sc_hd__tapvpwrvgnd_1
XFILLER_6_727 VGND VGND VPWR VPWR sky130_fd_sc_hd__decap_3
XFILLER_30_20 VGND VGND VPWR VPWR sky130_fd_sc_hd__decap_3
XFILLER_5_215 VGND VGND VPWR VPWR sky130_fd_sc_hd__decap_3
XPHY_EDGE_ROW_80_Right_80 VGND VGND VPWR VPWR sky130_fd_sc_hd__decap_3
Xrebuffer397 _8228_/Q VGND VGND VPWR VPWR _6353_/A sky130_fd_sc_hd__buf_2
XFILLER_107_187 VGND VGND VPWR VPWR sky130_fd_sc_hd__decap_3
XFILLER_108_699 VGND VGND VPWR VPWR sky130_fd_sc_hd__fill_1
XTAP_TAPCELL_ROW_114_1739 VGND VPWR sky130_fd_sc_hd__tapvpwrvgnd_1
XFILLER_96_509 VGND VGND VPWR VPWR sky130_fd_sc_hd__decap_3
XFILLER_76_200 VGND VGND VPWR VPWR sky130_fd_sc_hd__decap_3
XFILLER_89_561 VGND VGND VPWR VPWR sky130_fd_sc_hd__decap_3
XFILLER_89_572 VGND VGND VPWR VPWR sky130_fd_sc_hd__decap_3
XFILLER_89_583 VGND VGND VPWR VPWR sky130_fd_sc_hd__decap_3
XPHY_EDGE_ROW_55_Left_175 VGND VGND VPWR VPWR sky130_fd_sc_hd__decap_3
XFILLER_103_393 VGND VGND VPWR VPWR sky130_fd_sc_hd__decap_3
XFILLER_49_447 VGND VGND VPWR VPWR sky130_fd_sc_hd__fill_1
XFILLER_49_458 VGND VGND VPWR VPWR sky130_fd_sc_hd__decap_3
XFILLER_76_233 VGND VGND VPWR VPWR sky130_fd_sc_hd__fill_1
XFILLER_36_108 VGND VGND VPWR VPWR sky130_fd_sc_hd__decap_3
XFILLER_64_417 VGND VGND VPWR VPWR sky130_fd_sc_hd__decap_3
XFILLER_92_715 VGND VGND VPWR VPWR sky130_fd_sc_hd__fill_1
XFILLER_45_631 VGND VGND VPWR VPWR sky130_fd_sc_hd__decap_3
XFILLER_57_480 VGND VGND VPWR VPWR sky130_fd_sc_hd__decap_3
XFILLER_76_299 VGND VGND VPWR VPWR sky130_fd_sc_hd__decap_3
XFILLER_91_214 VGND VGND VPWR VPWR sky130_fd_sc_hd__decap_3
XFILLER_91_225 VGND VGND VPWR VPWR sky130_fd_sc_hd__decap_3
XFILLER_17_355 VGND VGND VPWR VPWR sky130_fd_sc_hd__decap_3
XFILLER_44_130 VGND VGND VPWR VPWR sky130_fd_sc_hd__decap_3
XFILLER_44_141 VGND VGND VPWR VPWR sky130_fd_sc_hd__decap_3
XFILLER_44_163 VGND VGND VPWR VPWR sky130_fd_sc_hd__decap_3
XFILLER_45_686 VGND VGND VPWR VPWR sky130_fd_sc_hd__fill_2
XFILLER_55_94 VGND VGND VPWR VPWR sky130_fd_sc_hd__decap_3
XFILLER_60_601 VGND VGND VPWR VPWR sky130_fd_sc_hd__decap_3
XFILLER_72_461 VGND VGND VPWR VPWR sky130_fd_sc_hd__decap_3
XFILLER_72_483 VGND VGND VPWR VPWR sky130_fd_sc_hd__decap_3
XFILLER_60_634 VGND VGND VPWR VPWR sky130_fd_sc_hd__decap_3
XFILLER_60_645 VGND VGND VPWR VPWR sky130_fd_sc_hd__decap_3
XPHY_EDGE_ROW_64_Left_184 VGND VGND VPWR VPWR sky130_fd_sc_hd__decap_3
XTAP_TAPCELL_ROW_43_821 VGND VPWR sky130_fd_sc_hd__tapvpwrvgnd_1
XFILLER_13_561 VGND VGND VPWR VPWR sky130_fd_sc_hd__fill_1
XFILLER_32_358 VGND VGND VPWR VPWR sky130_fd_sc_hd__decap_3
XFILLER_60_689 VGND VGND VPWR VPWR sky130_fd_sc_hd__decap_3
XFILLER_13_572 VGND VGND VPWR VPWR sky130_fd_sc_hd__decap_3
XFILLER_71_60 VGND VGND VPWR VPWR sky130_fd_sc_hd__decap_3
XFILLER_9_521 VGND VGND VPWR VPWR sky130_fd_sc_hd__decap_3
XFILLER_40_391 VGND VGND VPWR VPWR sky130_fd_sc_hd__decap_3
XFILLER_71_93 VGND VGND VPWR VPWR sky130_fd_sc_hd__decap_3
XFILLER_113_113 VGND VGND VPWR VPWR sky130_fd_sc_hd__decap_3
XFILLER_114_614 VGND VGND VPWR VPWR sky130_fd_sc_hd__decap_3
X_5290_ _5290_/A VGND VGND VPWR VPWR _5313_/A sky130_fd_sc_hd__clkbuf_1
X_4310_ _7898_/B _4310_/B VGND VGND VPWR VPWR _4311_/A sky130_fd_sc_hd__and2_2
XFILLER_4_292 VGND VGND VPWR VPWR sky130_fd_sc_hd__decap_3
XPHY_EDGE_ROW_73_Left_193 VGND VGND VPWR VPWR sky130_fd_sc_hd__decap_3
X_4241_ _4241_/A VGND VGND VPWR VPWR _8058_/D sky130_fd_sc_hd__buf_1
XFILLER_101_308 VGND VGND VPWR VPWR sky130_fd_sc_hd__fill_2
XFILLER_67_200 VGND VGND VPWR VPWR sky130_fd_sc_hd__fill_1
XFILLER_67_222 VGND VGND VPWR VPWR sky130_fd_sc_hd__fill_2
X_4172_ _7843_/A _7956_/Q VGND VGND VPWR VPWR _4173_/A sky130_fd_sc_hd__and2_2
XFILLER_67_255 VGND VGND VPWR VPWR sky130_fd_sc_hd__decap_3
XFILLER_95_564 VGND VGND VPWR VPWR sky130_fd_sc_hd__decap_3
XFILLER_48_480 VGND VGND VPWR VPWR sky130_fd_sc_hd__decap_3
XFILLER_55_417 VGND VGND VPWR VPWR sky130_fd_sc_hd__decap_3
XFILLER_55_439 VGND VGND VPWR VPWR sky130_fd_sc_hd__decap_3
XFILLER_82_203 VGND VGND VPWR VPWR sky130_fd_sc_hd__decap_3
X_7931_ _7931_/A VGND VGND VPWR VPWR _8402_/D sky130_fd_sc_hd__buf_1
XFILLER_36_631 VGND VGND VPWR VPWR sky130_fd_sc_hd__fill_2
XFILLER_82_236 VGND VGND VPWR VPWR sky130_fd_sc_hd__decap_3
XFILLER_82_269 VGND VGND VPWR VPWR sky130_fd_sc_hd__decap_3
XFILLER_23_314 VGND VGND VPWR VPWR sky130_fd_sc_hd__decap_3
XFILLER_63_472 VGND VGND VPWR VPWR sky130_fd_sc_hd__fill_1
X_7862_ _8301_/Q _7930_/B VGND VGND VPWR VPWR _7863_/A sky130_fd_sc_hd__and2_2
XFILLER_50_100 VGND VGND VPWR VPWR sky130_fd_sc_hd__fill_1
X_7793_ _7812_/A _7789_/X _7792_/X VGND VGND VPWR VPWR _7793_/Y sky130_fd_sc_hd__a21oi_2
X_6813_ _8261_/Q _6801_/X _6812_/X VGND VGND VPWR VPWR _6813_/X sky130_fd_sc_hd__o21a_4
XFILLER_50_144 VGND VGND VPWR VPWR sky130_fd_sc_hd__decap_3
XFILLER_51_689 VGND VGND VPWR VPWR sky130_fd_sc_hd__fill_1
X_6744_ _6784_/A _6744_/B VGND VGND VPWR VPWR _6744_/X sky130_fd_sc_hd__or2_2
X_6675_ _6675_/A _6675_/B VGND VGND VPWR VPWR _6675_/Y sky130_fd_sc_hd__xnor2_2
XTAP_TAPCELL_ROW_21_537 VGND VPWR sky130_fd_sc_hd__tapvpwrvgnd_1
XTAP_TAPCELL_ROW_21_526 VGND VPWR sky130_fd_sc_hd__tapvpwrvgnd_1
XFILLER_31_391 VGND VGND VPWR VPWR sky130_fd_sc_hd__fill_1
X_5626_ _5626_/A VGND VGND VPWR VPWR _5627_/A sky130_fd_sc_hd__buf_1
XFILLER_105_603 VGND VGND VPWR VPWR sky130_fd_sc_hd__fill_1
XFILLER_117_430 VGND VGND VPWR VPWR sky130_fd_sc_hd__fill_1
XFILLER_3_719 VGND VGND VPWR VPWR sky130_fd_sc_hd__decap_3
X_8345_ _8349_/CLK _8345_/D VGND VGND VPWR VPWR _8345_/Q sky130_fd_sc_hd__dfxtp_2
X_5557_ _7193_/A _5525_/Y _5526_/Y _5513_/Y _5556_/X VGND VGND VPWR VPWR _5558_/B
+ sky130_fd_sc_hd__a221o_2
XFILLER_117_496 VGND VGND VPWR VPWR sky130_fd_sc_hd__fill_2
X_8276_ _8280_/CLK _8276_/D VGND VGND VPWR VPWR _8276_/Q sky130_fd_sc_hd__dfxtp_2
X_5488_ _6421_/S _5488_/B VGND VGND VPWR VPWR _5488_/X sky130_fd_sc_hd__and2b_2
X_4508_ _7930_/B _8058_/Q VGND VGND VPWR VPWR _4509_/A sky130_fd_sc_hd__and2_2
XFILLER_104_124 VGND VGND VPWR VPWR sky130_fd_sc_hd__decap_3
XFILLER_105_669 VGND VGND VPWR VPWR sky130_fd_sc_hd__decap_3
XFILLER_116_12 VGND VGND VPWR VPWR sky130_fd_sc_hd__decap_3
X_7227_ _8208_/Q _8209_/Q _7227_/C VGND VGND VPWR VPWR _7281_/C sky130_fd_sc_hd__or3_4
X_4439_ _4439_/A VGND VGND VPWR VPWR _8157_/D sky130_fd_sc_hd__buf_1
XFILLER_116_78 VGND VGND VPWR VPWR sky130_fd_sc_hd__decap_3
XFILLER_58_200 VGND VGND VPWR VPWR sky130_fd_sc_hd__decap_3
XFILLER_58_233 VGND VGND VPWR VPWR sky130_fd_sc_hd__decap_3
XFILLER_76_27 VGND VGND VPWR VPWR sky130_fd_sc_hd__fill_1
X_7158_ _7017_/A _7157_/X _7166_/A _7030_/A VGND VGND VPWR VPWR _7159_/B sky130_fd_sc_hd__a211o_2
XFILLER_74_704 VGND VGND VPWR VPWR sky130_fd_sc_hd__decap_3
XFILLER_86_575 VGND VGND VPWR VPWR sky130_fd_sc_hd__decap_3
X_7089_ _7166_/A _6997_/X _7167_/C _7080_/X _7088_/Y VGND VGND VPWR VPWR _7098_/S
+ sky130_fd_sc_hd__a41o_2
X_6109_ _6109_/A _6109_/B VGND VGND VPWR VPWR _6109_/Y sky130_fd_sc_hd__nor2_2
XFILLER_100_374 VGND VGND VPWR VPWR sky130_fd_sc_hd__decap_3
XFILLER_18_108 VGND VGND VPWR VPWR sky130_fd_sc_hd__decap_3
XFILLER_27_620 VGND VGND VPWR VPWR sky130_fd_sc_hd__decap_3
XFILLER_39_480 VGND VGND VPWR VPWR sky130_fd_sc_hd__fill_1
XFILLER_46_417 VGND VGND VPWR VPWR sky130_fd_sc_hd__decap_3
XFILLER_46_439 VGND VGND VPWR VPWR sky130_fd_sc_hd__decap_3
XTAP_TAPCELL_ROW_29_637 VGND VPWR sky130_fd_sc_hd__tapvpwrvgnd_1
XFILLER_39_491 VGND VGND VPWR VPWR sky130_fd_sc_hd__fill_1
XFILLER_73_236 VGND VGND VPWR VPWR sky130_fd_sc_hd__decap_3
XFILLER_27_686 VGND VGND VPWR VPWR sky130_fd_sc_hd__decap_3
XFILLER_54_461 VGND VGND VPWR VPWR sky130_fd_sc_hd__decap_3
XFILLER_92_37 VGND VGND VPWR VPWR sky130_fd_sc_hd__decap_3
XTAP_TAPCELL_ROW_1_273 VGND VPWR sky130_fd_sc_hd__tapvpwrvgnd_1
XFILLER_26_174 VGND VGND VPWR VPWR sky130_fd_sc_hd__decap_3
XFILLER_41_111 VGND VGND VPWR VPWR sky130_fd_sc_hd__fill_1
XFILLER_42_645 VGND VGND VPWR VPWR sky130_fd_sc_hd__decap_3
XFILLER_54_483 VGND VGND VPWR VPWR sky130_fd_sc_hd__decap_3
XFILLER_14_358 VGND VGND VPWR VPWR sky130_fd_sc_hd__decap_3
XFILLER_25_64 VGND VGND VPWR VPWR sky130_fd_sc_hd__decap_3
XFILLER_25_97 VGND VGND VPWR VPWR sky130_fd_sc_hd__decap_3
XFILLER_41_144 VGND VGND VPWR VPWR sky130_fd_sc_hd__decap_3
XFILLER_41_199 VGND VGND VPWR VPWR sky130_fd_sc_hd__fill_1
XFILLER_10_531 VGND VGND VPWR VPWR sky130_fd_sc_hd__fill_1
XFILLER_22_391 VGND VGND VPWR VPWR sky130_fd_sc_hd__decap_3
XFILLER_10_575 VGND VGND VPWR VPWR sky130_fd_sc_hd__fill_2
XFILLER_10_586 VGND VGND VPWR VPWR sky130_fd_sc_hd__fill_2
XFILLER_108_452 VGND VGND VPWR VPWR sky130_fd_sc_hd__decap_3
XTAP_TAPCELL_ROW_75_1233 VGND VPWR sky130_fd_sc_hd__tapvpwrvgnd_1
XFILLER_111_617 VGND VGND VPWR VPWR sky130_fd_sc_hd__decap_3
XFILLER_96_328 VGND VGND VPWR VPWR sky130_fd_sc_hd__decap_3
XTAP_TAPCELL_ROW_9_373 VGND VPWR sky130_fd_sc_hd__tapvpwrvgnd_1
XFILLER_111_639 VGND VGND VPWR VPWR sky130_fd_sc_hd__decap_3
XFILLER_49_222 VGND VGND VPWR VPWR sky130_fd_sc_hd__fill_2
XFILLER_49_233 VGND VGND VPWR VPWR sky130_fd_sc_hd__decap_3
XFILLER_89_380 VGND VGND VPWR VPWR sky130_fd_sc_hd__decap_3
XFILLER_103_190 VGND VGND VPWR VPWR sky130_fd_sc_hd__decap_3
XFILLER_2_68 VGND VGND VPWR VPWR sky130_fd_sc_hd__decap_3
XFILLER_65_704 VGND VGND VPWR VPWR sky130_fd_sc_hd__decap_3
XFILLER_37_439 VGND VGND VPWR VPWR sky130_fd_sc_hd__decap_3
XFILLER_49_299 VGND VGND VPWR VPWR sky130_fd_sc_hd__decap_3
XFILLER_64_203 VGND VGND VPWR VPWR sky130_fd_sc_hd__decap_3
XFILLER_66_82 VGND VGND VPWR VPWR sky130_fd_sc_hd__fill_2
XFILLER_92_545 VGND VGND VPWR VPWR sky130_fd_sc_hd__decap_3
XFILLER_17_163 VGND VGND VPWR VPWR sky130_fd_sc_hd__decap_3
XFILLER_92_589 VGND VGND VPWR VPWR sky130_fd_sc_hd__fill_1
XTAP_TAPCELL_ROW_86_1373 VGND VPWR sky130_fd_sc_hd__tapvpwrvgnd_1
XFILLER_32_100 VGND VGND VPWR VPWR sky130_fd_sc_hd__decap_3
XFILLER_33_634 VGND VGND VPWR VPWR sky130_fd_sc_hd__decap_3
XFILLER_33_656 VGND VGND VPWR VPWR sky130_fd_sc_hd__decap_3
XFILLER_45_494 VGND VGND VPWR VPWR sky130_fd_sc_hd__fill_1
XFILLER_72_280 VGND VGND VPWR VPWR sky130_fd_sc_hd__decap_3
XFILLER_72_291 VGND VGND VPWR VPWR sky130_fd_sc_hd__decap_3
XTAP_TAPCELL_ROW_56_990 VGND VPWR sky130_fd_sc_hd__tapvpwrvgnd_1
XFILLER_60_453 VGND VGND VPWR VPWR sky130_fd_sc_hd__decap_3
X_4790_ _7180_/A _7213_/A _7226_/A _7255_/A VGND VGND VPWR VPWR _4791_/D sky130_fd_sc_hd__or4b_2
XANTENNA_18 _5963_/C VGND VGND VPWR VPWR sky130_fd_sc_hd__diode_2
XANTENNA_29 _8201_/Q VGND VGND VPWR VPWR sky130_fd_sc_hd__diode_2
XFILLER_20_339 VGND VGND VPWR VPWR sky130_fd_sc_hd__fill_1
XFILLER_32_188 VGND VGND VPWR VPWR sky130_fd_sc_hd__decap_3
XFILLER_60_486 VGND VGND VPWR VPWR sky130_fd_sc_hd__fill_2
XFILLER_9_351 VGND VGND VPWR VPWR sky130_fd_sc_hd__decap_3
XFILLER_70_3 VGND VGND VPWR VPWR sky130_fd_sc_hd__fill_2
XFILLER_9_373 VGND VGND VPWR VPWR sky130_fd_sc_hd__decap_3
X_6460_ _4861_/A _4863_/B _8288_/Q VGND VGND VPWR VPWR _6460_/X sky130_fd_sc_hd__mux2_2
X_6391_ _4873_/A _4900_/B _5046_/X VGND VGND VPWR VPWR _6391_/X sky130_fd_sc_hd__a21o_2
X_5411_ split/A _5411_/B VGND VGND VPWR VPWR _5412_/B sky130_fd_sc_hd__nand2_2
XPHY_EDGE_ROW_81_Left_201 VGND VGND VPWR VPWR sky130_fd_sc_hd__decap_3
X_8130_ _8402_/CLK _8130_/D VGND VGND VPWR VPWR _8130_/Q sky130_fd_sc_hd__dfxtp_2
X_5342_ _6706_/S _5618_/A _5337_/A _5411_/B VGND VGND VPWR VPWR _5343_/B sky130_fd_sc_hd__o2bb2a_2
XFILLER_99_122 VGND VGND VPWR VPWR sky130_fd_sc_hd__decap_3
X_8061_ _8199_/CLK _8061_/D VGND VGND VPWR VPWR _8061_/Q sky130_fd_sc_hd__dfxtp_2
Xoutput158 _7985_/Q VGND VGND VPWR VPWR result[27] sky130_fd_sc_hd__clkdlybuf4s25_1
Xoutput147 _7975_/Q VGND VGND VPWR VPWR result[17] sky130_fd_sc_hd__clkdlybuf4s25_1
Xoutput136 _8021_/Q VGND VGND VPWR VPWR carry_out sky130_fd_sc_hd__clkdlybuf4s25_1
XFILLER_99_155 VGND VGND VPWR VPWR sky130_fd_sc_hd__decap_3
Xoutput169 _7995_/Q VGND VGND VPWR VPWR result[37] sky130_fd_sc_hd__clkdlybuf4s25_1
X_7012_ _8204_/Q _7012_/B VGND VGND VPWR VPWR _7012_/Y sky130_fd_sc_hd__nand2_2
X_5273_ _7783_/A _5745_/B VGND VGND VPWR VPWR _5273_/Y sky130_fd_sc_hd__nor2_2
XFILLER_101_116 VGND VGND VPWR VPWR sky130_fd_sc_hd__decap_3
XFILLER_68_520 VGND VGND VPWR VPWR sky130_fd_sc_hd__decap_3
X_4224_ _7898_/B _4224_/B VGND VGND VPWR VPWR _4225_/A sky130_fd_sc_hd__and2_2
XFILLER_56_704 VGND VGND VPWR VPWR sky130_fd_sc_hd__decap_3
XFILLER_68_542 VGND VGND VPWR VPWR sky130_fd_sc_hd__decap_3
XFILLER_68_575 VGND VGND VPWR VPWR sky130_fd_sc_hd__decap_3
X_4155_ _4155_/A VGND VGND VPWR VPWR _8015_/D sky130_fd_sc_hd__buf_1
XFILLER_55_225 VGND VGND VPWR VPWR sky130_fd_sc_hd__decap_3
XFILLER_83_523 VGND VGND VPWR VPWR sky130_fd_sc_hd__decap_3
XFILLER_83_567 VGND VGND VPWR VPWR sky130_fd_sc_hd__fill_1
XPHY_EDGE_ROW_90_Left_210 VGND VGND VPWR VPWR sky130_fd_sc_hd__decap_3
X_4086_ _7930_/B _8384_/Q VGND VGND VPWR VPWR _4087_/A sky130_fd_sc_hd__and2_2
XFILLER_24_601 VGND VGND VPWR VPWR sky130_fd_sc_hd__decap_3
XFILLER_36_472 VGND VGND VPWR VPWR sky130_fd_sc_hd__decap_3
XFILLER_55_269 VGND VGND VPWR VPWR sky130_fd_sc_hd__decap_3
XFILLER_70_206 VGND VGND VPWR VPWR sky130_fd_sc_hd__decap_3
XFILLER_71_729 VGND VGND VPWR VPWR sky130_fd_sc_hd__decap_3
X_7914_ _8327_/Q _7930_/B VGND VGND VPWR VPWR _7915_/A sky130_fd_sc_hd__and2_2
XFILLER_102_47 VGND VGND VPWR VPWR sky130_fd_sc_hd__decap_3
XFILLER_23_111 VGND VGND VPWR VPWR sky130_fd_sc_hd__fill_1
XFILLER_51_420 VGND VGND VPWR VPWR sky130_fd_sc_hd__decap_3
XFILLER_70_239 VGND VGND VPWR VPWR sky130_fd_sc_hd__decap_3
X_7845_ _7843_/A _7842_/Y _7843_/X _7844_/Y VGND VGND VPWR VPWR _8359_/D sky130_fd_sc_hd__a211o_4
XFILLER_24_656 VGND VGND VPWR VPWR sky130_fd_sc_hd__fill_1
XFILLER_51_464 VGND VGND VPWR VPWR sky130_fd_sc_hd__decap_3
XFILLER_11_317 VGND VGND VPWR VPWR sky130_fd_sc_hd__decap_3
XFILLER_51_497 VGND VGND VPWR VPWR sky130_fd_sc_hd__decap_3
X_7776_ _7776_/A _7776_/B VGND VGND VPWR VPWR _7776_/Y sky130_fd_sc_hd__nand2_2
X_4988_ _4750_/A _4987_/Y _4750_/B VGND VGND VPWR VPWR _4989_/B sky130_fd_sc_hd__o21ba_2
XTAP_TAPCELL_ROW_34_695 VGND VPWR sky130_fd_sc_hd__tapvpwrvgnd_1
XFILLER_109_205 VGND VGND VPWR VPWR sky130_fd_sc_hd__decap_3
Xwire208 _5805_/X VGND VGND VPWR VPWR _7844_/C sky130_fd_sc_hd__clkbuf_8
X_6727_ _8192_/Q _8256_/Q _6727_/C VGND VGND VPWR VPWR _6727_/X sky130_fd_sc_hd__and3_2
X_6658_ _6656_/Y _6657_/X _6148_/X VGND VGND VPWR VPWR _6662_/C sky130_fd_sc_hd__o21ai_2
XFILLER_109_249 VGND VGND VPWR VPWR sky130_fd_sc_hd__decap_3
XFILLER_11_11 VGND VGND VPWR VPWR sky130_fd_sc_hd__fill_2
XFILLER_11_33 VGND VGND VPWR VPWR sky130_fd_sc_hd__fill_1
X_5609_ _7193_/A _5609_/B VGND VGND VPWR VPWR _5609_/Y sky130_fd_sc_hd__nand2_2
XFILLER_117_260 VGND VGND VPWR VPWR sky130_fd_sc_hd__decap_3
XFILLER_11_44 VGND VGND VPWR VPWR sky130_fd_sc_hd__decap_3
XFILLER_3_505 VGND VGND VPWR VPWR sky130_fd_sc_hd__fill_2
XFILLER_3_527 VGND VGND VPWR VPWR sky130_fd_sc_hd__decap_3
X_8328_ _8400_/CLK _8328_/D VGND VGND VPWR VPWR _8328_/Q sky130_fd_sc_hd__dfxtp_2
X_6589_ _7640_/A1 _6560_/Y _6568_/Y _6589_/B2 _6588_/X VGND VGND VPWR VPWR _6590_/B
+ sky130_fd_sc_hd__a221o_2
XFILLER_105_422 VGND VGND VPWR VPWR sky130_fd_sc_hd__decap_3
XFILLER_105_433 VGND VGND VPWR VPWR sky130_fd_sc_hd__decap_3
XFILLER_105_477 VGND VGND VPWR VPWR sky130_fd_sc_hd__fill_1
XFILLER_105_488 VGND VGND VPWR VPWR sky130_fd_sc_hd__decap_3
XFILLER_87_48 VGND VGND VPWR VPWR sky130_fd_sc_hd__decap_3
X_8259_ _8397_/CLK _8259_/D VGND VGND VPWR VPWR _8259_/Q sky130_fd_sc_hd__dfxtp_2
XFILLER_78_339 VGND VGND VPWR VPWR sky130_fd_sc_hd__decap_3
XTAP_TAPCELL_ROW_6_343 VGND VPWR sky130_fd_sc_hd__tapvpwrvgnd_1
XTAP_TAPCELL_ROW_6_332 VGND VPWR sky130_fd_sc_hd__tapvpwrvgnd_1
XFILLER_86_350 VGND VGND VPWR VPWR sky130_fd_sc_hd__decap_3
XTAP_TAPCELL_ROW_70_1174 VGND VPWR sky130_fd_sc_hd__tapvpwrvgnd_1
XTAP_TAPCELL_ROW_70_1163 VGND VPWR sky130_fd_sc_hd__tapvpwrvgnd_1
XFILLER_101_661 VGND VGND VPWR VPWR sky130_fd_sc_hd__decap_3
XFILLER_74_512 VGND VGND VPWR VPWR sky130_fd_sc_hd__decap_3
XFILLER_86_383 VGND VGND VPWR VPWR sky130_fd_sc_hd__decap_3
XFILLER_100_182 VGND VGND VPWR VPWR sky130_fd_sc_hd__decap_3
XFILLER_46_247 VGND VGND VPWR VPWR sky130_fd_sc_hd__decap_3
XFILLER_62_707 VGND VGND VPWR VPWR sky130_fd_sc_hd__fill_1
XFILLER_74_556 VGND VGND VPWR VPWR sky130_fd_sc_hd__decap_3
XFILLER_15_601 VGND VGND VPWR VPWR sky130_fd_sc_hd__decap_3
XFILLER_15_612 VGND VGND VPWR VPWR sky130_fd_sc_hd__decap_3
XFILLER_27_461 VGND VGND VPWR VPWR sky130_fd_sc_hd__fill_1
XFILLER_74_589 VGND VGND VPWR VPWR sky130_fd_sc_hd__decap_3
XFILLER_14_111 VGND VGND VPWR VPWR sky130_fd_sc_hd__decap_3
XFILLER_54_280 VGND VGND VPWR VPWR sky130_fd_sc_hd__decap_3
XFILLER_61_228 VGND VGND VPWR VPWR sky130_fd_sc_hd__fill_2
XFILLER_14_144 VGND VGND VPWR VPWR sky130_fd_sc_hd__decap_3
XFILLER_42_442 VGND VGND VPWR VPWR sky130_fd_sc_hd__decap_3
XFILLER_42_453 VGND VGND VPWR VPWR sky130_fd_sc_hd__decap_3
XFILLER_30_637 VGND VGND VPWR VPWR sky130_fd_sc_hd__decap_3
XFILLER_30_648 VGND VGND VPWR VPWR sky130_fd_sc_hd__decap_3
XFILLER_10_350 VGND VGND VPWR VPWR sky130_fd_sc_hd__decap_3
Xinput27 operand_a[29] VGND VGND VPWR VPWR _4234_/B sky130_fd_sc_hd__clkdlybuf4s25_1
Xinput16 operand_a[19] VGND VGND VPWR VPWR _4214_/B sky130_fd_sc_hd__clkdlybuf4s25_1
XFILLER_6_321 VGND VGND VPWR VPWR sky130_fd_sc_hd__decap_3
Xinput49 operand_a[49] VGND VGND VPWR VPWR _4274_/B sky130_fd_sc_hd__clkdlybuf4s25_1
Xinput38 operand_a[39] VGND VGND VPWR VPWR _4254_/B sky130_fd_sc_hd__clkdlybuf4s25_1
XFILLER_6_365 VGND VGND VPWR VPWR sky130_fd_sc_hd__decap_3
XFILLER_108_293 VGND VGND VPWR VPWR sky130_fd_sc_hd__fill_2
XFILLER_69_317 VGND VGND VPWR VPWR sky130_fd_sc_hd__decap_3
XFILLER_96_103 VGND VGND VPWR VPWR sky130_fd_sc_hd__decap_3
XFILLER_97_626 VGND VGND VPWR VPWR sky130_fd_sc_hd__decap_3
XFILLER_2_571 VGND VGND VPWR VPWR sky130_fd_sc_hd__fill_2
XFILLER_69_328 VGND VGND VPWR VPWR sky130_fd_sc_hd__decap_3
XFILLER_97_659 VGND VGND VPWR VPWR sky130_fd_sc_hd__decap_3
XFILLER_38_704 VGND VGND VPWR VPWR sky130_fd_sc_hd__decap_3
XFILLER_84_309 VGND VGND VPWR VPWR sky130_fd_sc_hd__decap_3
XFILLER_38_715 VGND VGND VPWR VPWR sky130_fd_sc_hd__fill_1
XFILLER_77_372 VGND VGND VPWR VPWR sky130_fd_sc_hd__decap_3
XTAP_TAPCELL_ROW_88_1402 VGND VPWR sky130_fd_sc_hd__tapvpwrvgnd_1
XFILLER_53_707 VGND VGND VPWR VPWR sky130_fd_sc_hd__fill_1
XFILLER_65_578 VGND VGND VPWR VPWR sky130_fd_sc_hd__decap_3
XFILLER_65_589 VGND VGND VPWR VPWR sky130_fd_sc_hd__decap_3
X_5960_ _5569_/X _5570_/X _5578_/X _5567_/X _6070_/A _6818_/S VGND VGND VPWR VPWR
+ _5960_/X sky130_fd_sc_hd__mux4_2
XFILLER_18_472 VGND VGND VPWR VPWR sky130_fd_sc_hd__decap_3
XFILLER_18_494 VGND VGND VPWR VPWR sky130_fd_sc_hd__fill_1
XFILLER_33_420 VGND VGND VPWR VPWR sky130_fd_sc_hd__decap_3
XFILLER_80_548 VGND VGND VPWR VPWR sky130_fd_sc_hd__decap_3
XFILLER_92_386 VGND VGND VPWR VPWR sky130_fd_sc_hd__decap_3
X_5891_ _5884_/B _5027_/B _5891_/B1 _8236_/Q VGND VGND VPWR VPWR _5891_/X sky130_fd_sc_hd__o211a_2
X_4911_ _4909_/Y _6138_/B VGND VGND VPWR VPWR _6084_/A sky130_fd_sc_hd__nand2b_2
XFILLER_33_464 VGND VGND VPWR VPWR sky130_fd_sc_hd__fill_2
X_7630_ _7844_/B _7630_/B _7630_/C VGND VGND VPWR VPWR _7631_/D sky130_fd_sc_hd__and3_4
XTAP_TAPCELL_ROW_51_919 VGND VPWR sky130_fd_sc_hd__tapvpwrvgnd_1
XFILLER_33_497 VGND VGND VPWR VPWR sky130_fd_sc_hd__decap_3
XFILLER_60_283 VGND VGND VPWR VPWR sky130_fd_sc_hd__decap_3
X_4842_ _4842_/A _4842_/B VGND VGND VPWR VPWR _6610_/A sky130_fd_sc_hd__nor2_2
XFILLER_20_147 VGND VGND VPWR VPWR sky130_fd_sc_hd__decap_3
X_7561_ _8220_/Q _7561_/B VGND VGND VPWR VPWR _7562_/B sky130_fd_sc_hd__and2_2
X_4773_ _8272_/Q VGND VGND VPWR VPWR _7222_/B sky130_fd_sc_hd__inv_2
X_7492_ _8218_/Q _8282_/Q _7491_/X VGND VGND VPWR VPWR _7575_/C sky130_fd_sc_hd__a21o_2
X_6512_ _8223_/Q _5911_/B _6641_/C VGND VGND VPWR VPWR _6512_/X sky130_fd_sc_hd__mux2_2
XTAP_TAPCELL_ROW_99_1542 VGND VPWR sky130_fd_sc_hd__tapvpwrvgnd_1
XTAP_TAPCELL_ROW_31_665 VGND VPWR sky130_fd_sc_hd__tapvpwrvgnd_1
XFILLER_9_181 VGND VGND VPWR VPWR sky130_fd_sc_hd__decap_3
X_6443_ _6443_/A VGND VGND VPWR VPWR _6443_/Y sky130_fd_sc_hd__inv_2
X_6374_ _8289_/Q _6411_/A _6373_/Y _8290_/Q VGND VGND VPWR VPWR _6374_/X sky130_fd_sc_hd__o22a_2
XFILLER_0_508 VGND VGND VPWR VPWR sky130_fd_sc_hd__decap_3
X_8113_ _8382_/CLK _8113_/D VGND VGND VPWR VPWR _8113_/Q sky130_fd_sc_hd__dfxtp_2
X_5325_ _7619_/A _5325_/B VGND VGND VPWR VPWR _5325_/Y sky130_fd_sc_hd__nand2_2
XFILLER_102_436 VGND VGND VPWR VPWR sky130_fd_sc_hd__decap_3
XFILLER_114_274 VGND VGND VPWR VPWR sky130_fd_sc_hd__decap_3
XFILLER_114_296 VGND VGND VPWR VPWR sky130_fd_sc_hd__fill_1
X_8044_ _8360_/CLK _8044_/D VGND VGND VPWR VPWR _8044_/Q sky130_fd_sc_hd__dfxtp_2
X_5256_ _8187_/Q _8188_/Q _5678_/S VGND VGND VPWR VPWR _5256_/X sky130_fd_sc_hd__mux2_2
XFILLER_57_18 VGND VGND VPWR VPWR sky130_fd_sc_hd__decap_3
X_4207_ _4207_/A VGND VGND VPWR VPWR _8041_/D sky130_fd_sc_hd__buf_1
XTAP_TAPCELL_ROW_3_302 VGND VPWR sky130_fd_sc_hd__tapvpwrvgnd_1
XFILLER_28_203 VGND VGND VPWR VPWR sky130_fd_sc_hd__decap_3
XFILLER_68_350 VGND VGND VPWR VPWR sky130_fd_sc_hd__decap_3
X_5187_ _4972_/B _6765_/B _5700_/B _5114_/X _5186_/Y VGND VGND VPWR VPWR _5187_/X
+ sky130_fd_sc_hd__o311a_2
XFILLER_110_491 VGND VGND VPWR VPWR sky130_fd_sc_hd__decap_3
XFILLER_113_24 VGND VGND VPWR VPWR sky130_fd_sc_hd__decap_3
XFILLER_28_225 VGND VGND VPWR VPWR sky130_fd_sc_hd__decap_3
XFILLER_68_394 VGND VGND VPWR VPWR sky130_fd_sc_hd__decap_3
X_4138_ _7930_/B _7939_/Q VGND VGND VPWR VPWR _4139_/A sky130_fd_sc_hd__and2_2
XFILLER_113_57 VGND VGND VPWR VPWR sky130_fd_sc_hd__decap_3
XFILLER_83_364 VGND VGND VPWR VPWR sky130_fd_sc_hd__decap_3
XTAP_TAPCELL_ROW_108_1660 VGND VPWR sky130_fd_sc_hd__tapvpwrvgnd_1
X_4069_ _4069_/A VGND VGND VPWR VPWR _7972_/D sky130_fd_sc_hd__buf_1
XTAP_TAPCELL_ROW_39_765 VGND VPWR sky130_fd_sc_hd__tapvpwrvgnd_1
XFILLER_43_228 VGND VGND VPWR VPWR sky130_fd_sc_hd__decap_3
XFILLER_73_39 VGND VGND VPWR VPWR sky130_fd_sc_hd__decap_3
XFILLER_24_453 VGND VGND VPWR VPWR sky130_fd_sc_hd__decap_3
XFILLER_12_626 VGND VGND VPWR VPWR sky130_fd_sc_hd__decap_3
XFILLER_12_637 VGND VGND VPWR VPWR sky130_fd_sc_hd__decap_3
XFILLER_24_475 VGND VGND VPWR VPWR sky130_fd_sc_hd__fill_1
XFILLER_51_272 VGND VGND VPWR VPWR sky130_fd_sc_hd__decap_3
X_7828_ _7828_/A _7828_/B VGND VGND VPWR VPWR _7829_/S sky130_fd_sc_hd__nor2_2
XFILLER_11_136 VGND VGND VPWR VPWR sky130_fd_sc_hd__decap_3
XFILLER_12_648 VGND VGND VPWR VPWR sky130_fd_sc_hd__decap_3
X_7759_ _7797_/A1 _8206_/Q _5121_/A _5579_/S VGND VGND VPWR VPWR _7759_/Y sky130_fd_sc_hd__a211oi_2
XFILLER_11_169 VGND VGND VPWR VPWR sky130_fd_sc_hd__decap_3
XFILLER_20_670 VGND VGND VPWR VPWR sky130_fd_sc_hd__decap_3
XFILLER_22_32 VGND VGND VPWR VPWR sky130_fd_sc_hd__decap_3
XFILLER_7_107 VGND VGND VPWR VPWR sky130_fd_sc_hd__decap_3
XTAP_TAPCELL_ROW_59_1025 VGND VPWR sky130_fd_sc_hd__tapvpwrvgnd_1
XFILLER_106_731 VGND VGND VPWR VPWR sky130_fd_sc_hd__fill_2
XFILLER_98_47 VGND VGND VPWR VPWR sky130_fd_sc_hd__decap_3
XFILLER_0_3 VGND VGND VPWR VPWR sky130_fd_sc_hd__decap_3
XFILLER_3_346 VGND VGND VPWR VPWR sky130_fd_sc_hd__decap_3
XFILLER_105_263 VGND VGND VPWR VPWR sky130_fd_sc_hd__decap_3
XFILLER_105_296 VGND VGND VPWR VPWR sky130_fd_sc_hd__decap_3
XFILLER_78_103 VGND VGND VPWR VPWR sky130_fd_sc_hd__decap_3
XFILLER_79_659 VGND VGND VPWR VPWR sky130_fd_sc_hd__fill_1
XFILLER_66_309 VGND VGND VPWR VPWR sky130_fd_sc_hd__fill_2
XFILLER_78_136 VGND VGND VPWR VPWR sky130_fd_sc_hd__decap_3
XFILLER_47_40 VGND VGND VPWR VPWR sky130_fd_sc_hd__decap_3
XFILLER_93_128 VGND VGND VPWR VPWR sky130_fd_sc_hd__decap_3
XFILLER_101_491 VGND VGND VPWR VPWR sky130_fd_sc_hd__decap_3
XFILLER_74_342 VGND VGND VPWR VPWR sky130_fd_sc_hd__decap_3
XFILLER_86_180 VGND VGND VPWR VPWR sky130_fd_sc_hd__decap_3
XFILLER_34_206 VGND VGND VPWR VPWR sky130_fd_sc_hd__decap_3
XFILLER_35_729 VGND VGND VPWR VPWR sky130_fd_sc_hd__decap_3
XFILLER_47_84 VGND VGND VPWR VPWR sky130_fd_sc_hd__decap_3
XFILLER_74_386 VGND VGND VPWR VPWR sky130_fd_sc_hd__decap_3
XTAP_TAPCELL_ROW_83_1343 VGND VPWR sky130_fd_sc_hd__tapvpwrvgnd_1
XTAP_TAPCELL_ROW_83_1332 VGND VPWR sky130_fd_sc_hd__tapvpwrvgnd_1
XFILLER_63_72 VGND VGND VPWR VPWR sky130_fd_sc_hd__decap_3
XFILLER_30_456 VGND VGND VPWR VPWR sky130_fd_sc_hd__decap_3
XFILLER_42_294 VGND VGND VPWR VPWR sky130_fd_sc_hd__decap_3
XFILLER_70_592 VGND VGND VPWR VPWR sky130_fd_sc_hd__decap_3
XFILLER_30_489 VGND VGND VPWR VPWR sky130_fd_sc_hd__fill_2
XFILLER_11_670 VGND VGND VPWR VPWR sky130_fd_sc_hd__fill_2
XFILLER_116_528 VGND VGND VPWR VPWR sky130_fd_sc_hd__decap_3
XFILLER_109_580 VGND VGND VPWR VPWR sky130_fd_sc_hd__decap_3
XFILLER_116_539 VGND VGND VPWR VPWR sky130_fd_sc_hd__decap_3
XFILLER_6_195 VGND VGND VPWR VPWR sky130_fd_sc_hd__fill_1
XFILLER_112_701 VGND VGND VPWR VPWR sky130_fd_sc_hd__decap_3
XTAP_TAPCELL_ROW_94_1483 VGND VPWR sky130_fd_sc_hd__tapvpwrvgnd_1
XFILLER_33_3 VGND VGND VPWR VPWR sky130_fd_sc_hd__decap_3
XFILLER_97_412 VGND VGND VPWR VPWR sky130_fd_sc_hd__decap_3
X_6090_ _8178_/Q _8242_/Q VGND VGND VPWR VPWR _6090_/X sky130_fd_sc_hd__or2_2
X_5110_ _7619_/A _5415_/A VGND VGND VPWR VPWR _5110_/Y sky130_fd_sc_hd__nor2_2
XFILLER_111_222 VGND VGND VPWR VPWR sky130_fd_sc_hd__fill_2
XFILLER_97_467 VGND VGND VPWR VPWR sky130_fd_sc_hd__decap_3
X_5041_ _8183_/Q VGND VGND VPWR VPWR _5041_/Y sky130_fd_sc_hd__inv_2
XFILLER_111_277 VGND VGND VPWR VPWR sky130_fd_sc_hd__decap_3
XFILLER_38_501 VGND VGND VPWR VPWR sky130_fd_sc_hd__decap_3
XFILLER_38_545 VGND VGND VPWR VPWR sky130_fd_sc_hd__decap_3
XFILLER_65_320 VGND VGND VPWR VPWR sky130_fd_sc_hd__decap_3
XFILLER_38_567 VGND VGND VPWR VPWR sky130_fd_sc_hd__decap_3
XFILLER_65_364 VGND VGND VPWR VPWR sky130_fd_sc_hd__decap_3
XFILLER_80_301 VGND VGND VPWR VPWR sky130_fd_sc_hd__fill_1
XFILLER_93_662 VGND VGND VPWR VPWR sky130_fd_sc_hd__decap_3
XFILLER_93_673 VGND VGND VPWR VPWR sky130_fd_sc_hd__fill_2
XFILLER_25_217 VGND VGND VPWR VPWR sky130_fd_sc_hd__fill_2
XFILLER_53_537 VGND VGND VPWR VPWR sky130_fd_sc_hd__decap_3
XFILLER_80_334 VGND VGND VPWR VPWR sky130_fd_sc_hd__decap_3
XFILLER_92_194 VGND VGND VPWR VPWR sky130_fd_sc_hd__fill_2
X_6992_ _6992_/A _7030_/A VGND VGND VPWR VPWR _7017_/A sky130_fd_sc_hd__nor2_2
XTAP_TAPCELL_ROW_36_724 VGND VPWR sky130_fd_sc_hd__tapvpwrvgnd_1
XFILLER_18_280 VGND VGND VPWR VPWR sky130_fd_sc_hd__decap_3
X_5943_ _5943_/A _5943_/B _5943_/C _8172_/Q VGND VGND VPWR VPWR _5944_/D sky130_fd_sc_hd__and4_2
XFILLER_80_389 VGND VGND VPWR VPWR sky130_fd_sc_hd__fill_2
X_5874_ _5868_/X _5869_/X _5872_/X _5873_/X VGND VGND VPWR VPWR _5874_/X sky130_fd_sc_hd__a22o_4
XFILLER_21_434 VGND VGND VPWR VPWR sky130_fd_sc_hd__fill_1
XFILLER_21_445 VGND VGND VPWR VPWR sky130_fd_sc_hd__decap_3
XFILLER_33_294 VGND VGND VPWR VPWR sky130_fd_sc_hd__fill_2
XFILLER_61_592 VGND VGND VPWR VPWR sky130_fd_sc_hd__fill_2
X_7613_ _8223_/Q _7613_/B VGND VGND VPWR VPWR _7840_/C sky130_fd_sc_hd__nand2_2
X_4825_ _8261_/Q VGND VGND VPWR VPWR _4827_/B sky130_fd_sc_hd__inv_2
XTAP_TAPCELL_ROW_16_470 VGND VPWR sky130_fd_sc_hd__tapvpwrvgnd_1
XFILLER_21_489 VGND VGND VPWR VPWR sky130_fd_sc_hd__decap_3
X_7544_ _7551_/A _7544_/B VGND VGND VPWR VPWR _7544_/Y sky130_fd_sc_hd__xnor2_2
XFILLER_119_355 VGND VGND VPWR VPWR sky130_fd_sc_hd__decap_3
Xrebuffer727 _6218_/X VGND VGND VPWR VPWR _6219_/B sky130_fd_sc_hd__buf_2
X_4756_ _7407_/A _7437_/A _7463_/A _7649_/B VGND VGND VPWR VPWR _4973_/B sky130_fd_sc_hd__or4_2
XFILLER_119_388 VGND VGND VPWR VPWR sky130_fd_sc_hd__decap_3
X_7475_ _7475_/A _7475_/B VGND VGND VPWR VPWR _7476_/C sky130_fd_sc_hd__nor2_2
X_4687_ _4687_/A VGND VGND VPWR VPWR _8281_/D sky130_fd_sc_hd__buf_1
X_6426_ _7623_/S _6426_/B VGND VGND VPWR VPWR _6641_/C sky130_fd_sc_hd__nor2_2
XFILLER_115_561 VGND VGND VPWR VPWR sky130_fd_sc_hd__fill_2
XFILLER_68_17 VGND VGND VPWR VPWR sky130_fd_sc_hd__decap_3
X_6357_ _6350_/X _6352_/Y _6356_/X _5528_/A VGND VGND VPWR VPWR _6357_/Y sky130_fd_sc_hd__a22oi_2
XFILLER_102_200 VGND VGND VPWR VPWR sky130_fd_sc_hd__decap_3
X_5308_ _6721_/A _5244_/X _5307_/Y VGND VGND VPWR VPWR _5308_/Y sky130_fd_sc_hd__o21ai_2
XFILLER_102_244 VGND VGND VPWR VPWR sky130_fd_sc_hd__decap_3
X_6288_ _6052_/X _6090_/X _6287_/X _6086_/B VGND VGND VPWR VPWR _6290_/B sky130_fd_sc_hd__a31o_2
XFILLER_102_266 VGND VGND VPWR VPWR sky130_fd_sc_hd__decap_3
XFILLER_29_501 VGND VGND VPWR VPWR sky130_fd_sc_hd__decap_3
XFILLER_48_309 VGND VGND VPWR VPWR sky130_fd_sc_hd__decap_3
XFILLER_76_629 VGND VGND VPWR VPWR sky130_fd_sc_hd__fill_2
XFILLER_88_489 VGND VGND VPWR VPWR sky130_fd_sc_hd__fill_2
X_8027_ clkload8/A _8027_/D VGND VGND VPWR VPWR _8027_/Q sky130_fd_sc_hd__dfxtp_2
X_5239_ _6765_/B _5239_/B VGND VGND VPWR VPWR _5477_/A sky130_fd_sc_hd__nor2_2
XFILLER_102_299 VGND VGND VPWR VPWR sky130_fd_sc_hd__decap_3
XFILLER_29_523 VGND VGND VPWR VPWR sky130_fd_sc_hd__decap_3
XFILLER_56_320 VGND VGND VPWR VPWR sky130_fd_sc_hd__decap_3
XFILLER_75_128 VGND VGND VPWR VPWR sky130_fd_sc_hd__decap_3
XFILLER_16_206 VGND VGND VPWR VPWR sky130_fd_sc_hd__fill_2
XFILLER_17_729 VGND VGND VPWR VPWR sky130_fd_sc_hd__decap_3
XFILLER_29_578 VGND VGND VPWR VPWR sky130_fd_sc_hd__decap_3
XFILLER_44_504 VGND VGND VPWR VPWR sky130_fd_sc_hd__decap_3
XFILLER_56_342 VGND VGND VPWR VPWR sky130_fd_sc_hd__decap_3
XFILLER_17_54 VGND VGND VPWR VPWR sky130_fd_sc_hd__fill_2
XFILLER_17_65 VGND VGND VPWR VPWR sky130_fd_sc_hd__decap_3
XFILLER_56_386 VGND VGND VPWR VPWR sky130_fd_sc_hd__decap_3
XFILLER_71_334 VGND VGND VPWR VPWR sky130_fd_sc_hd__fill_2
XFILLER_83_172 VGND VGND VPWR VPWR sky130_fd_sc_hd__fill_1
XFILLER_84_684 VGND VGND VPWR VPWR sky130_fd_sc_hd__decap_3
XFILLER_71_367 VGND VGND VPWR VPWR sky130_fd_sc_hd__decap_3
XFILLER_12_445 VGND VGND VPWR VPWR sky130_fd_sc_hd__decap_3
XFILLER_33_97 VGND VGND VPWR VPWR sky130_fd_sc_hd__decap_3
XFILLER_98_209 VGND VGND VPWR VPWR sky130_fd_sc_hd__fill_1
XFILLER_106_572 VGND VGND VPWR VPWR sky130_fd_sc_hd__decap_3
XFILLER_3_165 VGND VGND VPWR VPWR sky130_fd_sc_hd__decap_3
XFILLER_4_699 VGND VGND VPWR VPWR sky130_fd_sc_hd__fill_1
XFILLER_79_434 VGND VGND VPWR VPWR sky130_fd_sc_hd__fill_1
XFILLER_58_83 VGND VGND VPWR VPWR sky130_fd_sc_hd__fill_1
XFILLER_67_629 VGND VGND VPWR VPWR sky130_fd_sc_hd__decap_3
XFILLER_94_404 VGND VGND VPWR VPWR sky130_fd_sc_hd__decap_3
XFILLER_58_94 VGND VGND VPWR VPWR sky130_fd_sc_hd__decap_3
XFILLER_75_651 VGND VGND VPWR VPWR sky130_fd_sc_hd__decap_3
XFILLER_75_673 VGND VGND VPWR VPWR sky130_fd_sc_hd__decap_3
XFILLER_35_548 VGND VGND VPWR VPWR sky130_fd_sc_hd__fill_1
XFILLER_47_375 VGND VGND VPWR VPWR sky130_fd_sc_hd__decap_3
XFILLER_62_301 VGND VGND VPWR VPWR sky130_fd_sc_hd__decap_3
XFILLER_62_312 VGND VGND VPWR VPWR sky130_fd_sc_hd__decap_3
XFILLER_74_161 VGND VGND VPWR VPWR sky130_fd_sc_hd__decap_3
XFILLER_74_183 VGND VGND VPWR VPWR sky130_fd_sc_hd__decap_3
XFILLER_74_60 VGND VGND VPWR VPWR sky130_fd_sc_hd__decap_3
XFILLER_90_610 VGND VGND VPWR VPWR sky130_fd_sc_hd__decap_3
XFILLER_15_261 VGND VGND VPWR VPWR sky130_fd_sc_hd__decap_3
XFILLER_43_570 VGND VGND VPWR VPWR sky130_fd_sc_hd__decap_3
XFILLER_30_231 VGND VGND VPWR VPWR sky130_fd_sc_hd__decap_3
XFILLER_31_732 VGND VGND VPWR VPWR sky130_fd_sc_hd__fill_1
XFILLER_30_253 VGND VGND VPWR VPWR sky130_fd_sc_hd__decap_3
X_4610_ _7898_/B _8109_/Q VGND VGND VPWR VPWR _4611_/A sky130_fd_sc_hd__and2_2
X_5590_ _5110_/Y _5585_/Y _5588_/X _7619_/A _5589_/X VGND VGND VPWR VPWR _5590_/X
+ sky130_fd_sc_hd__a221o_2
XTAP_TAPCELL_ROW_96_1501 VGND VPWR sky130_fd_sc_hd__tapvpwrvgnd_1
XTAP_TAPCELL_ROW_41_793 VGND VPWR sky130_fd_sc_hd__tapvpwrvgnd_1
X_4541_ _4541_/A VGND VGND VPWR VPWR _8208_/D sky130_fd_sc_hd__buf_1
XTAP_TAPCELL_ROW_96_1512 VGND VPWR sky130_fd_sc_hd__tapvpwrvgnd_1
XFILLER_116_336 VGND VGND VPWR VPWR sky130_fd_sc_hd__decap_3
X_7260_ _8275_/Q _5397_/A _5338_/A VGND VGND VPWR VPWR _7260_/Y sky130_fd_sc_hd__o21ai_2
X_4472_ _7898_/B _8040_/Q VGND VGND VPWR VPWR _4473_/A sky130_fd_sc_hd__and2_2
X_7191_ _7619_/A _7189_/X _7190_/Y VGND VGND VPWR VPWR _7191_/X sky130_fd_sc_hd__a21o_2
X_6211_ _6159_/Y _6177_/X _6157_/X VGND VGND VPWR VPWR _6211_/Y sky130_fd_sc_hd__a21boi_4
XFILLER_98_732 VGND VGND VPWR VPWR sky130_fd_sc_hd__fill_1
X_6142_ _4910_/B _6081_/B _6141_/X VGND VGND VPWR VPWR _6142_/X sky130_fd_sc_hd__a21bo_4
XFILLER_97_231 VGND VGND VPWR VPWR sky130_fd_sc_hd__decap_3
XFILLER_112_586 VGND VGND VPWR VPWR sky130_fd_sc_hd__fill_2
XFILLER_58_629 VGND VGND VPWR VPWR sky130_fd_sc_hd__decap_3
XFILLER_97_253 VGND VGND VPWR VPWR sky130_fd_sc_hd__decap_3
X_6073_ _6064_/X _6066_/Y _6072_/X _6109_/A VGND VGND VPWR VPWR _6074_/C sky130_fd_sc_hd__a22o_2
XFILLER_57_128 VGND VGND VPWR VPWR sky130_fd_sc_hd__decap_3
X_5024_ _5026_/B _5026_/A_N VGND VGND VPWR VPWR _5888_/B sky130_fd_sc_hd__or2b_4
XFILLER_66_662 VGND VGND VPWR VPWR sky130_fd_sc_hd__decap_3
XFILLER_38_386 VGND VGND VPWR VPWR sky130_fd_sc_hd__decap_3
XFILLER_53_323 VGND VGND VPWR VPWR sky130_fd_sc_hd__decap_3
XFILLER_65_161 VGND VGND VPWR VPWR sky130_fd_sc_hd__decap_3
XFILLER_65_172 VGND VGND VPWR VPWR sky130_fd_sc_hd__decap_3
XFILLER_93_470 VGND VGND VPWR VPWR sky130_fd_sc_hd__decap_3
XTAP_TAPCELL_ROW_49_893 VGND VPWR sky130_fd_sc_hd__tapvpwrvgnd_1
XFILLER_80_120 VGND VGND VPWR VPWR sky130_fd_sc_hd__decap_3
XFILLER_81_654 VGND VGND VPWR VPWR sky130_fd_sc_hd__decap_3
XTAP_TAPCELL_ROW_105_1630 VGND VPWR sky130_fd_sc_hd__tapvpwrvgnd_1
X_6975_ _8200_/Q _8201_/Q _8202_/Q _6975_/D VGND VGND VPWR VPWR _6976_/B sky130_fd_sc_hd__and4_2
XFILLER_13_209 VGND VGND VPWR VPWR sky130_fd_sc_hd__decap_3
XFILLER_53_378 VGND VGND VPWR VPWR sky130_fd_sc_hd__decap_3
XFILLER_53_389 VGND VGND VPWR VPWR sky130_fd_sc_hd__decap_3
XFILLER_81_676 VGND VGND VPWR VPWR sky130_fd_sc_hd__decap_3
XFILLER_81_698 VGND VGND VPWR VPWR sky130_fd_sc_hd__decap_3
X_5926_ _5655_/X _5656_/X _5925_/X _5661_/X VGND VGND VPWR VPWR _5929_/B sky130_fd_sc_hd__o211a_4
XFILLER_21_220 VGND VGND VPWR VPWR sky130_fd_sc_hd__decap_3
XFILLER_80_186 VGND VGND VPWR VPWR sky130_fd_sc_hd__decap_3
XFILLER_21_231 VGND VGND VPWR VPWR sky130_fd_sc_hd__decap_3
XFILLER_70_29 VGND VGND VPWR VPWR sky130_fd_sc_hd__decap_3
X_5857_ _5857_/A _5857_/B VGND VGND VPWR VPWR _5857_/Y sky130_fd_sc_hd__nand2_2
X_5788_ _5788_/A _5788_/B _5788_/C _5787_/X VGND VGND VPWR VPWR _5788_/X sky130_fd_sc_hd__or4b_2
X_4808_ _8200_/Q VGND VGND VPWR VPWR _6903_/S sky130_fd_sc_hd__inv_2
XFILLER_107_303 VGND VGND VPWR VPWR sky130_fd_sc_hd__decap_3
XFILLER_119_141 VGND VGND VPWR VPWR sky130_fd_sc_hd__decap_3
X_7527_ _8220_/Q _8219_/Q _7796_/A VGND VGND VPWR VPWR _7527_/X sky130_fd_sc_hd__mux2_2
Xrebuffer546 _7471_/B VGND VGND VPWR VPWR rebuffer546/X sky130_fd_sc_hd__buf_2
X_4739_ _8216_/Q _8280_/Q VGND VGND VPWR VPWR _4741_/A sky130_fd_sc_hd__and2b_2
X_7458_ _8217_/Q _8281_/Q _7434_/B VGND VGND VPWR VPWR _7458_/X sky130_fd_sc_hd__a21bo_2
XFILLER_107_358 VGND VGND VPWR VPWR sky130_fd_sc_hd__decap_3
XTAP_TAPCELL_ROW_116_1770 VGND VPWR sky130_fd_sc_hd__tapvpwrvgnd_1
X_6409_ _8185_/Q _8249_/Q _6408_/X VGND VGND VPWR VPWR _6409_/X sky130_fd_sc_hd__o21a_2
XFILLER_89_732 VGND VGND VPWR VPWR sky130_fd_sc_hd__fill_1
X_7389_ _7388_/X _7269_/X _7623_/S VGND VGND VPWR VPWR _7389_/X sky130_fd_sc_hd__mux2_2
XFILLER_0_113 VGND VGND VPWR VPWR sky130_fd_sc_hd__decap_3
XFILLER_115_391 VGND VGND VPWR VPWR sky130_fd_sc_hd__fill_1
XFILLER_88_220 VGND VGND VPWR VPWR sky130_fd_sc_hd__fill_1
XFILLER_103_564 VGND VGND VPWR VPWR sky130_fd_sc_hd__decap_3
XFILLER_103_575 VGND VGND VPWR VPWR sky130_fd_sc_hd__decap_3
XFILLER_48_117 VGND VGND VPWR VPWR sky130_fd_sc_hd__decap_3
XFILLER_76_404 VGND VGND VPWR VPWR sky130_fd_sc_hd__decap_3
XFILLER_88_253 VGND VGND VPWR VPWR sky130_fd_sc_hd__decap_3
XFILLER_95_48 VGND VGND VPWR VPWR sky130_fd_sc_hd__decap_3
XFILLER_28_20 VGND VGND VPWR VPWR sky130_fd_sc_hd__decap_3
XFILLER_76_459 VGND VGND VPWR VPWR sky130_fd_sc_hd__decap_3
XFILLER_28_53 VGND VGND VPWR VPWR sky130_fd_sc_hd__decap_3
XFILLER_29_331 VGND VGND VPWR VPWR sky130_fd_sc_hd__decap_3
XFILLER_29_353 VGND VGND VPWR VPWR sky130_fd_sc_hd__decap_3
XFILLER_57_673 VGND VGND VPWR VPWR sky130_fd_sc_hd__fill_1
XFILLER_28_97 VGND VGND VPWR VPWR sky130_fd_sc_hd__decap_3
XFILLER_29_375 VGND VGND VPWR VPWR sky130_fd_sc_hd__decap_3
XFILLER_44_312 VGND VGND VPWR VPWR sky130_fd_sc_hd__decap_3
XFILLER_56_150 VGND VGND VPWR VPWR sky130_fd_sc_hd__decap_3
XFILLER_56_183 VGND VGND VPWR VPWR sky130_fd_sc_hd__decap_3
XFILLER_72_621 VGND VGND VPWR VPWR sky130_fd_sc_hd__decap_3
XTAP_TAPCELL_ROW_67_1124 VGND VPWR sky130_fd_sc_hd__tapvpwrvgnd_1
XFILLER_71_142 VGND VGND VPWR VPWR sky130_fd_sc_hd__decap_3
XFILLER_72_665 VGND VGND VPWR VPWR sky130_fd_sc_hd__fill_1
XTAP_TAPCELL_ROW_67_1135 VGND VPWR sky130_fd_sc_hd__tapvpwrvgnd_1
XFILLER_13_710 VGND VGND VPWR VPWR sky130_fd_sc_hd__fill_1
XFILLER_32_529 VGND VGND VPWR VPWR sky130_fd_sc_hd__decap_3
XFILLER_44_389 VGND VGND VPWR VPWR sky130_fd_sc_hd__decap_3
XFILLER_71_164 VGND VGND VPWR VPWR sky130_fd_sc_hd__decap_3
XFILLER_72_698 VGND VGND VPWR VPWR sky130_fd_sc_hd__fill_2
XTAP_TAPCELL_ROW_80_1302 VGND VPWR sky130_fd_sc_hd__tapvpwrvgnd_1
XFILLER_12_220 VGND VGND VPWR VPWR sky130_fd_sc_hd__fill_2
XFILLER_13_732 VGND VGND VPWR VPWR sky130_fd_sc_hd__fill_1
XFILLER_44_85 VGND VGND VPWR VPWR sky130_fd_sc_hd__decap_3
XFILLER_12_242 VGND VGND VPWR VPWR sky130_fd_sc_hd__fill_2
XFILLER_12_253 VGND VGND VPWR VPWR sky130_fd_sc_hd__decap_3
XFILLER_40_562 VGND VGND VPWR VPWR sky130_fd_sc_hd__fill_2
XFILLER_12_275 VGND VGND VPWR VPWR sky130_fd_sc_hd__decap_3
XFILLER_40_595 VGND VGND VPWR VPWR sky130_fd_sc_hd__decap_3
XFILLER_8_224 VGND VGND VPWR VPWR sky130_fd_sc_hd__decap_3
XFILLER_8_246 VGND VGND VPWR VPWR sky130_fd_sc_hd__decap_3
XFILLER_60_62 VGND VGND VPWR VPWR sky130_fd_sc_hd__decap_3
XTAP_TAPCELL_ROW_78_1275 VGND VPWR sky130_fd_sc_hd__tapvpwrvgnd_1
XFILLER_113_306 VGND VGND VPWR VPWR sky130_fd_sc_hd__decap_3
XFILLER_106_380 VGND VGND VPWR VPWR sky130_fd_sc_hd__decap_3
XFILLER_69_60 VGND VGND VPWR VPWR sky130_fd_sc_hd__decap_3
XFILLER_69_82 VGND VGND VPWR VPWR sky130_fd_sc_hd__decap_3
XFILLER_79_220 VGND VGND VPWR VPWR sky130_fd_sc_hd__decap_3
XFILLER_79_231 VGND VGND VPWR VPWR sky130_fd_sc_hd__decap_3
XTAP_TAPCELL_ROW_91_1442 VGND VPWR sky130_fd_sc_hd__tapvpwrvgnd_1
XFILLER_39_139 VGND VGND VPWR VPWR sky130_fd_sc_hd__decap_3
XFILLER_67_426 VGND VGND VPWR VPWR sky130_fd_sc_hd__decap_3
XFILLER_48_651 VGND VGND VPWR VPWR sky130_fd_sc_hd__decap_3
XFILLER_82_407 VGND VGND VPWR VPWR sky130_fd_sc_hd__decap_3
XFILLER_35_312 VGND VGND VPWR VPWR sky130_fd_sc_hd__fill_1
XFILLER_47_172 VGND VGND VPWR VPWR sky130_fd_sc_hd__fill_2
XFILLER_48_684 VGND VGND VPWR VPWR sky130_fd_sc_hd__decap_3
XFILLER_75_470 VGND VGND VPWR VPWR sky130_fd_sc_hd__fill_2
XFILLER_75_481 VGND VGND VPWR VPWR sky130_fd_sc_hd__decap_3
XFILLER_85_81 VGND VGND VPWR VPWR sky130_fd_sc_hd__decap_3
XFILLER_94_289 VGND VGND VPWR VPWR sky130_fd_sc_hd__decap_3
XFILLER_47_183 VGND VGND VPWR VPWR sky130_fd_sc_hd__decap_3
XFILLER_63_665 VGND VGND VPWR VPWR sky130_fd_sc_hd__decap_3
XFILLER_90_451 VGND VGND VPWR VPWR sky130_fd_sc_hd__decap_3
XTAP_TAPCELL_ROW_46_852 VGND VPWR sky130_fd_sc_hd__tapvpwrvgnd_1
XFILLER_35_367 VGND VGND VPWR VPWR sky130_fd_sc_hd__decap_3
XFILLER_62_153 VGND VGND VPWR VPWR sky130_fd_sc_hd__fill_2
X_6760_ _8260_/Q _6735_/A _6735_/B _8196_/Q VGND VGND VPWR VPWR _6760_/X sky130_fd_sc_hd__a31o_2
XTAP_TAPCELL_ROW_46_863 VGND VPWR sky130_fd_sc_hd__tapvpwrvgnd_1
XFILLER_16_581 VGND VGND VPWR VPWR sky130_fd_sc_hd__decap_3
XFILLER_50_348 VGND VGND VPWR VPWR sky130_fd_sc_hd__decap_3
XFILLER_62_197 VGND VGND VPWR VPWR sky130_fd_sc_hd__decap_3
X_5711_ _8231_/Q _5662_/X _8167_/Q VGND VGND VPWR VPWR _5711_/X sky130_fd_sc_hd__a21bo_2
X_3972_ _8339_/Q _7930_/B VGND VGND VPWR VPWR _3973_/A sky130_fd_sc_hd__and2_2
XFILLER_31_551 VGND VGND VPWR VPWR sky130_fd_sc_hd__decap_3
X_6691_ _5966_/X _6668_/Y _6669_/X _6690_/X _7930_/B VGND VGND VPWR VPWR _8328_/D
+ sky130_fd_sc_hd__o311a_4
XTAP_TAPCELL_ROW_100_1560 VGND VPWR sky130_fd_sc_hd__tapvpwrvgnd_1
X_5642_ _6321_/B _5641_/X VGND VGND VPWR VPWR _5642_/X sky130_fd_sc_hd__or2b_2
X_8361_ _8387_/CLK _8361_/D VGND VGND VPWR VPWR _8361_/Q sky130_fd_sc_hd__dfxtp_2
X_5573_ _5579_/S _5573_/B VGND VGND VPWR VPWR _5574_/A sky130_fd_sc_hd__or2_2
XFILLER_117_623 VGND VGND VPWR VPWR sky130_fd_sc_hd__decap_3
X_7312_ _7312_/A _7312_/B VGND VGND VPWR VPWR _7312_/Y sky130_fd_sc_hd__nand2_2
X_4524_ _7898_/B _8066_/Q VGND VGND VPWR VPWR _4525_/A sky130_fd_sc_hd__and2_2
XFILLER_116_144 VGND VGND VPWR VPWR sky130_fd_sc_hd__decap_3
X_8292_ clkload5/A _8292_/D VGND VGND VPWR VPWR _8292_/Q sky130_fd_sc_hd__dfxtp_4
XFILLER_104_306 VGND VGND VPWR VPWR sky130_fd_sc_hd__fill_2
X_7243_ _7243_/A _7243_/B VGND VGND VPWR VPWR _7243_/Y sky130_fd_sc_hd__nand2_2
X_4455_ _4455_/A VGND VGND VPWR VPWR _8165_/D sky130_fd_sc_hd__buf_1
X_7174_ _8201_/Q _8265_/Q _7173_/X VGND VGND VPWR VPWR _7174_/X sky130_fd_sc_hd__o21a_2
X_4386_ _7930_/B _4386_/B VGND VGND VPWR VPWR _4387_/A sky130_fd_sc_hd__and2_2
XFILLER_105_14 VGND VGND VPWR VPWR sky130_fd_sc_hd__fill_2
XFILLER_112_361 VGND VGND VPWR VPWR sky130_fd_sc_hd__decap_3
XFILLER_58_404 VGND VGND VPWR VPWR sky130_fd_sc_hd__decap_3
XFILLER_86_724 VGND VGND VPWR VPWR sky130_fd_sc_hd__decap_3
XFILLER_98_573 VGND VGND VPWR VPWR sky130_fd_sc_hd__decap_3
X_6125_ _8290_/Q _6122_/Y _6124_/X _5812_/A VGND VGND VPWR VPWR _6125_/X sky130_fd_sc_hd__a22o_2
XFILLER_58_448 VGND VGND VPWR VPWR sky130_fd_sc_hd__decap_3
XFILLER_85_212 VGND VGND VPWR VPWR sky130_fd_sc_hd__decap_3
XFILLER_85_234 VGND VGND VPWR VPWR sky130_fd_sc_hd__decap_3
XFILLER_98_595 VGND VGND VPWR VPWR sky130_fd_sc_hd__decap_3
XFILLER_100_567 VGND VGND VPWR VPWR sky130_fd_sc_hd__decap_3
X_6056_ _8177_/Q _6028_/X _6055_/X VGND VGND VPWR VPWR _6074_/B sky130_fd_sc_hd__a21oi_2
XFILLER_100_589 VGND VGND VPWR VPWR sky130_fd_sc_hd__fill_1
XFILLER_26_312 VGND VGND VPWR VPWR sky130_fd_sc_hd__decap_3
XFILLER_39_673 VGND VGND VPWR VPWR sky130_fd_sc_hd__decap_3
XFILLER_54_621 VGND VGND VPWR VPWR sky130_fd_sc_hd__decap_3
XFILLER_73_418 VGND VGND VPWR VPWR sky130_fd_sc_hd__decap_3
XFILLER_85_278 VGND VGND VPWR VPWR sky130_fd_sc_hd__fill_2
X_5007_ _8263_/Q _5005_/X _5006_/X VGND VGND VPWR VPWR _5007_/X sky130_fd_sc_hd__a21o_2
XFILLER_26_334 VGND VGND VPWR VPWR sky130_fd_sc_hd__decap_3
XFILLER_26_356 VGND VGND VPWR VPWR sky130_fd_sc_hd__fill_1
XFILLER_54_632 VGND VGND VPWR VPWR sky130_fd_sc_hd__decap_3
XFILLER_66_492 VGND VGND VPWR VPWR sky130_fd_sc_hd__decap_3
XFILLER_14_507 VGND VGND VPWR VPWR sky130_fd_sc_hd__decap_3
XFILLER_14_529 VGND VGND VPWR VPWR sky130_fd_sc_hd__decap_3
XFILLER_26_389 VGND VGND VPWR VPWR sky130_fd_sc_hd__decap_3
XFILLER_53_142 VGND VGND VPWR VPWR sky130_fd_sc_hd__decap_3
XFILLER_53_175 VGND VGND VPWR VPWR sky130_fd_sc_hd__decap_3
XFILLER_81_17 VGND VGND VPWR VPWR sky130_fd_sc_hd__decap_3
XFILLER_81_484 VGND VGND VPWR VPWR sky130_fd_sc_hd__decap_3
XFILLER_41_337 VGND VGND VPWR VPWR sky130_fd_sc_hd__decap_3
X_6958_ _6958_/A VGND VGND VPWR VPWR _6958_/Y sky130_fd_sc_hd__inv_2
XFILLER_22_551 VGND VGND VPWR VPWR sky130_fd_sc_hd__decap_3
X_6889_ _8200_/Q _8199_/Q _7796_/A VGND VGND VPWR VPWR _6889_/X sky130_fd_sc_hd__mux2_2
X_5909_ _6184_/B _5894_/Y _5900_/X _5908_/Y VGND VGND VPWR VPWR _5909_/X sky130_fd_sc_hd__o211a_2
XTAP_TAPCELL_ROW_24_568 VGND VPWR sky130_fd_sc_hd__tapvpwrvgnd_1
XFILLER_14_55 VGND VGND VPWR VPWR sky130_fd_sc_hd__fill_1
XPHY_EDGE_ROW_101_Left_221 VGND VGND VPWR VPWR sky130_fd_sc_hd__decap_3
XTAP_TAPCELL_ROW_62_1065 VGND VPWR sky130_fd_sc_hd__tapvpwrvgnd_1
Xrebuffer321 _8226_/Q VGND VGND VPWR VPWR _7555_/S sky130_fd_sc_hd__buf_2
Xrebuffer310 rebuffer546/X VGND VGND VPWR VPWR _7441_/B1 sky130_fd_sc_hd__buf_6
XFILLER_108_645 VGND VGND VPWR VPWR sky130_fd_sc_hd__decap_3
XFILLER_107_122 VGND VGND VPWR VPWR sky130_fd_sc_hd__decap_3
XFILLER_108_678 VGND VGND VPWR VPWR sky130_fd_sc_hd__decap_3
XFILLER_100_3 VGND VGND VPWR VPWR sky130_fd_sc_hd__fill_2
XFILLER_107_166 VGND VGND VPWR VPWR sky130_fd_sc_hd__fill_2
XFILLER_30_98 VGND VGND VPWR VPWR sky130_fd_sc_hd__decap_3
XFILLER_107_199 VGND VGND VPWR VPWR sky130_fd_sc_hd__decap_3
XFILLER_1_444 VGND VGND VPWR VPWR sky130_fd_sc_hd__decap_3
XFILLER_110_309 VGND VGND VPWR VPWR sky130_fd_sc_hd__decap_3
XFILLER_39_41 VGND VGND VPWR VPWR sky130_fd_sc_hd__decap_3
XFILLER_49_404 VGND VGND VPWR VPWR sky130_fd_sc_hd__decap_3
XFILLER_89_551 VGND VGND VPWR VPWR sky130_fd_sc_hd__decap_3
XFILLER_103_383 VGND VGND VPWR VPWR sky130_fd_sc_hd__decap_3
XFILLER_39_63 VGND VGND VPWR VPWR sky130_fd_sc_hd__decap_3
XFILLER_49_426 VGND VGND VPWR VPWR sky130_fd_sc_hd__decap_3
XFILLER_76_212 VGND VGND VPWR VPWR sky130_fd_sc_hd__decap_3
XFILLER_89_595 VGND VGND VPWR VPWR sky130_fd_sc_hd__decap_3
XPHY_EDGE_ROW_110_Left_230 VGND VGND VPWR VPWR sky130_fd_sc_hd__decap_3
XFILLER_39_96 VGND VGND VPWR VPWR sky130_fd_sc_hd__decap_3
XFILLER_29_172 VGND VGND VPWR VPWR sky130_fd_sc_hd__decap_3
XFILLER_45_654 VGND VGND VPWR VPWR sky130_fd_sc_hd__decap_3
XFILLER_72_440 VGND VGND VPWR VPWR sky130_fd_sc_hd__decap_3
XFILLER_91_248 VGND VGND VPWR VPWR sky130_fd_sc_hd__decap_3
XFILLER_17_378 VGND VGND VPWR VPWR sky130_fd_sc_hd__decap_3
XFILLER_55_84 VGND VGND VPWR VPWR sky130_fd_sc_hd__fill_2
XFILLER_60_613 VGND VGND VPWR VPWR sky130_fd_sc_hd__decap_3
XFILLER_72_473 VGND VGND VPWR VPWR sky130_fd_sc_hd__decap_3
XFILLER_32_315 VGND VGND VPWR VPWR sky130_fd_sc_hd__decap_3
XFILLER_44_197 VGND VGND VPWR VPWR sky130_fd_sc_hd__decap_3
XFILLER_60_657 VGND VGND VPWR VPWR sky130_fd_sc_hd__fill_2
XFILLER_72_495 VGND VGND VPWR VPWR sky130_fd_sc_hd__decap_3
XTAP_TAPCELL_ROW_43_822 VGND VPWR sky130_fd_sc_hd__tapvpwrvgnd_1
XFILLER_13_540 VGND VGND VPWR VPWR sky130_fd_sc_hd__decap_3
XFILLER_13_584 VGND VGND VPWR VPWR sky130_fd_sc_hd__decap_3
XFILLER_13_595 VGND VGND VPWR VPWR sky130_fd_sc_hd__decap_3
XFILLER_71_72 VGND VGND VPWR VPWR sky130_fd_sc_hd__decap_3
XFILLER_114_637 VGND VGND VPWR VPWR sky130_fd_sc_hd__decap_3
XFILLER_99_326 VGND VGND VPWR VPWR sky130_fd_sc_hd__decap_3
XFILLER_113_125 VGND VGND VPWR VPWR sky130_fd_sc_hd__fill_1
XFILLER_114_648 VGND VGND VPWR VPWR sky130_fd_sc_hd__decap_3
XFILLER_4_271 VGND VGND VPWR VPWR sky130_fd_sc_hd__decap_3
XFILLER_99_337 VGND VGND VPWR VPWR sky130_fd_sc_hd__decap_3
X_4240_ _7930_/B _4240_/B VGND VGND VPWR VPWR _4241_/A sky130_fd_sc_hd__and2_2
XFILLER_113_169 VGND VGND VPWR VPWR sky130_fd_sc_hd__fill_1
X_4171_ _4171_/A VGND VGND VPWR VPWR _8023_/D sky130_fd_sc_hd__buf_1
XFILLER_67_234 VGND VGND VPWR VPWR sky130_fd_sc_hd__decap_3
XFILLER_67_267 VGND VGND VPWR VPWR sky130_fd_sc_hd__decap_3
XFILLER_95_554 VGND VGND VPWR VPWR sky130_fd_sc_hd__decap_3
XFILLER_36_610 VGND VGND VPWR VPWR sky130_fd_sc_hd__decap_3
XFILLER_48_470 VGND VGND VPWR VPWR sky130_fd_sc_hd__decap_3
XFILLER_67_278 VGND VGND VPWR VPWR sky130_fd_sc_hd__fill_2
XFILLER_67_289 VGND VGND VPWR VPWR sky130_fd_sc_hd__decap_3
XFILLER_82_215 VGND VGND VPWR VPWR sky130_fd_sc_hd__decap_3
XFILLER_95_587 VGND VGND VPWR VPWR sky130_fd_sc_hd__decap_3
X_7930_ _8335_/Q _7930_/B VGND VGND VPWR VPWR _7931_/A sky130_fd_sc_hd__and2_2
XFILLER_35_120 VGND VGND VPWR VPWR sky130_fd_sc_hd__decap_3
XFILLER_36_643 VGND VGND VPWR VPWR sky130_fd_sc_hd__fill_1
XFILLER_36_654 VGND VGND VPWR VPWR sky130_fd_sc_hd__decap_3
XFILLER_48_492 VGND VGND VPWR VPWR sky130_fd_sc_hd__decap_3
XFILLER_63_440 VGND VGND VPWR VPWR sky130_fd_sc_hd__decap_3
X_7861_ _7861_/A VGND VGND VPWR VPWR _8367_/D sky130_fd_sc_hd__buf_1
XFILLER_63_462 VGND VGND VPWR VPWR sky130_fd_sc_hd__fill_1
X_6812_ _8261_/Q _6811_/B _8197_/Q VGND VGND VPWR VPWR _6812_/X sky130_fd_sc_hd__o21ba_2
XFILLER_23_326 VGND VGND VPWR VPWR sky130_fd_sc_hd__decap_3
XFILLER_23_337 VGND VGND VPWR VPWR sky130_fd_sc_hd__decap_3
XFILLER_35_175 VGND VGND VPWR VPWR sky130_fd_sc_hd__decap_3
XFILLER_90_281 VGND VGND VPWR VPWR sky130_fd_sc_hd__decap_3
X_7792_ _7754_/A _7790_/Y _7791_/Y _7796_/A VGND VGND VPWR VPWR _7792_/X sky130_fd_sc_hd__a22o_2
XFILLER_23_359 VGND VGND VPWR VPWR sky130_fd_sc_hd__decap_3
XFILLER_51_679 VGND VGND VPWR VPWR sky130_fd_sc_hd__decap_3
X_6743_ _6742_/X _6452_/X _7745_/A VGND VGND VPWR VPWR _6743_/X sky130_fd_sc_hd__mux2_2
X_6674_ _8257_/Q _6636_/B _6673_/X VGND VGND VPWR VPWR _6674_/X sky130_fd_sc_hd__o21a_4
XTAP_TAPCELL_ROW_21_527 VGND VPWR sky130_fd_sc_hd__tapvpwrvgnd_1
XFILLER_109_409 VGND VGND VPWR VPWR sky130_fd_sc_hd__decap_3
X_5625_ _6999_/A1 _5868_/B _5624_/X VGND VGND VPWR VPWR _5625_/X sky130_fd_sc_hd__a21o_2
XTAP_TAPCELL_ROW_21_538 VGND VPWR sky130_fd_sc_hd__tapvpwrvgnd_1
X_8344_ _8365_/CLK _8344_/D VGND VGND VPWR VPWR _8344_/Q sky130_fd_sc_hd__dfxtp_2
X_5556_ _5556_/A _5556_/B _5556_/C VGND VGND VPWR VPWR _5556_/X sky130_fd_sc_hd__or3_2
X_8275_ _8349_/CLK _8275_/D VGND VGND VPWR VPWR _8275_/Q sky130_fd_sc_hd__dfxtp_2
X_5487_ split/A _7670_/A _7754_/A _5486_/X VGND VGND VPWR VPWR _5487_/X sky130_fd_sc_hd__a31o_2
X_4507_ _4507_/A VGND VGND VPWR VPWR _8191_/D sky130_fd_sc_hd__buf_1
XFILLER_104_147 VGND VGND VPWR VPWR sky130_fd_sc_hd__decap_3
XFILLER_116_24 VGND VGND VPWR VPWR sky130_fd_sc_hd__decap_3
X_7226_ _7226_/A _7226_/B VGND VGND VPWR VPWR _7226_/X sky130_fd_sc_hd__xor2_2
X_4438_ _7843_/A input5/X VGND VGND VPWR VPWR _4439_/A sky130_fd_sc_hd__and2_2
XFILLER_116_35 VGND VGND VPWR VPWR sky130_fd_sc_hd__decap_3
XFILLER_116_57 VGND VGND VPWR VPWR sky130_fd_sc_hd__decap_3
XFILLER_59_713 VGND VGND VPWR VPWR sky130_fd_sc_hd__decap_3
XFILLER_58_223 VGND VGND VPWR VPWR sky130_fd_sc_hd__fill_2
XFILLER_86_510 VGND VGND VPWR VPWR sky130_fd_sc_hd__decap_3
XFILLER_98_381 VGND VGND VPWR VPWR sky130_fd_sc_hd__decap_3
X_7157_ _4814_/B _4820_/A _4814_/A VGND VGND VPWR VPWR _7157_/X sky130_fd_sc_hd__a21bo_2
X_4369_ _4369_/A VGND VGND VPWR VPWR _8122_/D sky130_fd_sc_hd__buf_1
XFILLER_58_256 VGND VGND VPWR VPWR sky130_fd_sc_hd__decap_3
XFILLER_86_554 VGND VGND VPWR VPWR sky130_fd_sc_hd__decap_3
X_7088_ _7081_/Y _7087_/Y _7034_/Y VGND VGND VPWR VPWR _7088_/Y sky130_fd_sc_hd__a21oi_2
X_6108_ _5355_/X _5375_/X _5358_/X _5381_/X _6819_/A _7745_/A VGND VGND VPWR VPWR
+ _6109_/B sky130_fd_sc_hd__mux4_2
XFILLER_100_386 VGND VGND VPWR VPWR sky130_fd_sc_hd__decap_3
XFILLER_39_470 VGND VGND VPWR VPWR sky130_fd_sc_hd__decap_3
XFILLER_58_289 VGND VGND VPWR VPWR sky130_fd_sc_hd__decap_3
XFILLER_73_204 VGND VGND VPWR VPWR sky130_fd_sc_hd__decap_3
XFILLER_86_587 VGND VGND VPWR VPWR sky130_fd_sc_hd__fill_1
X_6039_ _6039_/A _6039_/B _6039_/C VGND VGND VPWR VPWR _6395_/A sky130_fd_sc_hd__or3_2
XFILLER_73_248 VGND VGND VPWR VPWR sky130_fd_sc_hd__decap_3
XTAP_TAPCELL_ROW_29_638 VGND VPWR sky130_fd_sc_hd__tapvpwrvgnd_1
XFILLER_26_131 VGND VGND VPWR VPWR sky130_fd_sc_hd__decap_3
XFILLER_27_676 VGND VGND VPWR VPWR sky130_fd_sc_hd__fill_1
XFILLER_54_440 VGND VGND VPWR VPWR sky130_fd_sc_hd__decap_3
XFILLER_54_473 VGND VGND VPWR VPWR sky130_fd_sc_hd__decap_3
XTAP_TAPCELL_ROW_1_274 VGND VPWR sky130_fd_sc_hd__tapvpwrvgnd_1
XFILLER_14_315 VGND VGND VPWR VPWR sky130_fd_sc_hd__decap_3
XFILLER_41_123 VGND VGND VPWR VPWR sky130_fd_sc_hd__decap_3
XFILLER_54_495 VGND VGND VPWR VPWR sky130_fd_sc_hd__decap_3
XFILLER_81_270 VGND VGND VPWR VPWR sky130_fd_sc_hd__decap_3
XFILLER_81_281 VGND VGND VPWR VPWR sky130_fd_sc_hd__decap_3
XFILLER_25_76 VGND VGND VPWR VPWR sky130_fd_sc_hd__decap_3
XFILLER_10_510 VGND VGND VPWR VPWR sky130_fd_sc_hd__decap_3
XFILLER_41_167 VGND VGND VPWR VPWR sky130_fd_sc_hd__fill_1
XFILLER_41_53 VGND VGND VPWR VPWR sky130_fd_sc_hd__decap_3
XFILLER_6_525 VGND VGND VPWR VPWR sky130_fd_sc_hd__decap_3
XFILLER_108_431 VGND VGND VPWR VPWR sky130_fd_sc_hd__decap_3
XFILLER_108_464 VGND VGND VPWR VPWR sky130_fd_sc_hd__decap_3
XFILLER_108_486 VGND VGND VPWR VPWR sky130_fd_sc_hd__decap_3
XTAP_TAPCELL_ROW_75_1234 VGND VPWR sky130_fd_sc_hd__tapvpwrvgnd_1
XFILLER_2_731 VGND VGND VPWR VPWR sky130_fd_sc_hd__fill_2
XTAP_TAPCELL_ROW_9_374 VGND VPWR sky130_fd_sc_hd__tapvpwrvgnd_1
XFILLER_110_139 VGND VGND VPWR VPWR sky130_fd_sc_hd__fill_1
XFILLER_49_245 VGND VGND VPWR VPWR sky130_fd_sc_hd__decap_3
Xclone825 _7796_/A VGND VGND VPWR VPWR _6380_/S sky130_fd_sc_hd__clkbuf_16
XFILLER_64_215 VGND VGND VPWR VPWR sky130_fd_sc_hd__decap_3
XFILLER_92_502 VGND VGND VPWR VPWR sky130_fd_sc_hd__decap_3
XFILLER_18_643 VGND VGND VPWR VPWR sky130_fd_sc_hd__fill_1
XFILLER_66_94 VGND VGND VPWR VPWR sky130_fd_sc_hd__decap_3
XFILLER_17_142 VGND VGND VPWR VPWR sky130_fd_sc_hd__decap_3
XFILLER_17_175 VGND VGND VPWR VPWR sky130_fd_sc_hd__decap_3
XFILLER_45_484 VGND VGND VPWR VPWR sky130_fd_sc_hd__fill_1
XFILLER_60_421 VGND VGND VPWR VPWR sky130_fd_sc_hd__decap_3
XTAP_TAPCELL_ROW_86_1374 VGND VPWR sky130_fd_sc_hd__tapvpwrvgnd_1
XTAP_TAPCELL_ROW_56_991 VGND VPWR sky130_fd_sc_hd__tapvpwrvgnd_1
XFILLER_33_668 VGND VGND VPWR VPWR sky130_fd_sc_hd__decap_3
XFILLER_60_465 VGND VGND VPWR VPWR sky130_fd_sc_hd__fill_1
XANTENNA_19 _6175_/X VGND VGND VPWR VPWR sky130_fd_sc_hd__diode_2
XFILLER_20_318 VGND VGND VPWR VPWR sky130_fd_sc_hd__decap_3
XFILLER_119_707 VGND VGND VPWR VPWR sky130_fd_sc_hd__decap_3
XFILLER_119_729 VGND VGND VPWR VPWR sky130_fd_sc_hd__decap_3
XFILLER_9_385 VGND VGND VPWR VPWR sky130_fd_sc_hd__decap_3
XFILLER_9_396 VGND VGND VPWR VPWR sky130_fd_sc_hd__decap_3
X_6390_ _6390_/A _6390_/B _6390_/C VGND VGND VPWR VPWR _6390_/X sky130_fd_sc_hd__and3_2
X_5410_ _7264_/A VGND VGND VPWR VPWR _6099_/A sky130_fd_sc_hd__clkbuf_2
XFILLER_99_101 VGND VGND VPWR VPWR sky130_fd_sc_hd__decap_3
X_5341_ _5341_/A VGND VGND VPWR VPWR _5618_/A sky130_fd_sc_hd__buf_1
XFILLER_114_434 VGND VGND VPWR VPWR sky130_fd_sc_hd__decap_3
X_8060_ _8396_/CLK _8060_/D VGND VGND VPWR VPWR _8060_/Q sky130_fd_sc_hd__dfxtp_2
Xoutput159 _7986_/Q VGND VGND VPWR VPWR result[28] sky130_fd_sc_hd__clkdlybuf4s25_1
Xoutput148 _7976_/Q VGND VGND VPWR VPWR result[18] sky130_fd_sc_hd__clkdlybuf4s25_1
Xoutput137 _8403_/A VGND VGND VPWR VPWR negative_flag sky130_fd_sc_hd__clkdlybuf4s25_1
XFILLER_102_607 VGND VGND VPWR VPWR sky130_fd_sc_hd__fill_2
XFILLER_114_456 VGND VGND VPWR VPWR sky130_fd_sc_hd__decap_3
XFILLER_87_318 VGND VGND VPWR VPWR sky130_fd_sc_hd__decap_3
XFILLER_99_167 VGND VGND VPWR VPWR sky130_fd_sc_hd__fill_1
X_7011_ _5615_/A _6988_/X _7010_/X _7474_/A VGND VGND VPWR VPWR _7012_/B sky130_fd_sc_hd__o2bb2a_4
X_5272_ _5430_/A _5346_/A _4968_/A VGND VGND VPWR VPWR _5745_/B sky130_fd_sc_hd__a21o_2
XFILLER_101_128 VGND VGND VPWR VPWR sky130_fd_sc_hd__fill_1
XFILLER_114_489 VGND VGND VPWR VPWR sky130_fd_sc_hd__fill_1
X_4223_ _4223_/A VGND VGND VPWR VPWR _8049_/D sky130_fd_sc_hd__buf_1
XFILLER_110_651 VGND VGND VPWR VPWR sky130_fd_sc_hd__decap_3
XFILLER_68_554 VGND VGND VPWR VPWR sky130_fd_sc_hd__decap_3
XFILLER_95_340 VGND VGND VPWR VPWR sky130_fd_sc_hd__decap_3
X_4154_ _7930_/B _7947_/Q VGND VGND VPWR VPWR _4155_/A sky130_fd_sc_hd__and2_2
XFILLER_110_684 VGND VGND VPWR VPWR sky130_fd_sc_hd__decap_3
XFILLER_28_407 VGND VGND VPWR VPWR sky130_fd_sc_hd__fill_1
XFILLER_55_204 VGND VGND VPWR VPWR sky130_fd_sc_hd__decap_3
XFILLER_68_587 VGND VGND VPWR VPWR sky130_fd_sc_hd__fill_1
XFILLER_95_373 VGND VGND VPWR VPWR sky130_fd_sc_hd__decap_3
X_4085_ _4085_/A VGND VGND VPWR VPWR _7980_/D sky130_fd_sc_hd__buf_1
XFILLER_83_557 VGND VGND VPWR VPWR sky130_fd_sc_hd__decap_3
X_7913_ _7913_/A VGND VGND VPWR VPWR _8393_/D sky130_fd_sc_hd__buf_1
XFILLER_36_451 VGND VGND VPWR VPWR sky130_fd_sc_hd__decap_3
XFILLER_70_218 VGND VGND VPWR VPWR sky130_fd_sc_hd__decap_3
XFILLER_102_59 VGND VGND VPWR VPWR sky130_fd_sc_hd__fill_1
XFILLER_24_613 VGND VGND VPWR VPWR sky130_fd_sc_hd__decap_3
XFILLER_63_281 VGND VGND VPWR VPWR sky130_fd_sc_hd__decap_3
X_7844_ _7844_/A _7844_/B _7844_/C _7844_/D VGND VGND VPWR VPWR _7844_/Y sky130_fd_sc_hd__nor4_2
XFILLER_23_156 VGND VGND VPWR VPWR sky130_fd_sc_hd__decap_3
XFILLER_51_432 VGND VGND VPWR VPWR sky130_fd_sc_hd__decap_3
X_7775_ _7653_/X _8172_/Q _7655_/X _7773_/Y _7774_/X VGND VGND VPWR VPWR _7785_/B
+ sky130_fd_sc_hd__a311o_2
XFILLER_11_329 VGND VGND VPWR VPWR sky130_fd_sc_hd__decap_3
XFILLER_23_178 VGND VGND VPWR VPWR sky130_fd_sc_hd__fill_1
XFILLER_51_476 VGND VGND VPWR VPWR sky130_fd_sc_hd__decap_3
X_6726_ _6726_/A _6726_/B _6726_/C VGND VGND VPWR VPWR _6726_/X sky130_fd_sc_hd__and3_2
X_4987_ _4741_/B _4986_/X _4744_/B VGND VGND VPWR VPWR _4987_/Y sky130_fd_sc_hd__a21oi_2
XFILLER_32_690 VGND VGND VPWR VPWR sky130_fd_sc_hd__decap_3
XTAP_TAPCELL_ROW_34_696 VGND VPWR sky130_fd_sc_hd__tapvpwrvgnd_1
XFILLER_109_217 VGND VGND VPWR VPWR sky130_fd_sc_hd__decap_3
XFILLER_109_228 VGND VGND VPWR VPWR sky130_fd_sc_hd__decap_3
X_6657_ _8192_/Q _6578_/X _8193_/Q VGND VGND VPWR VPWR _6657_/X sky130_fd_sc_hd__o21a_2
X_6588_ _5732_/X _6570_/Y _6577_/X _6587_/X _6580_/Y VGND VGND VPWR VPWR _6588_/X
+ sky130_fd_sc_hd__a2111o_2
X_5608_ _6277_/A _5607_/Y _5581_/X VGND VGND VPWR VPWR _5609_/B sky130_fd_sc_hd__a21boi_2
X_8327_ _8392_/CLK _8327_/D VGND VGND VPWR VPWR _8327_/Q sky130_fd_sc_hd__dfxtp_2
X_5539_ _6623_/A _5092_/A _5397_/A _8165_/Q _7619_/A VGND VGND VPWR VPWR _5542_/A
+ sky130_fd_sc_hd__o221a_2
XFILLER_78_318 VGND VGND VPWR VPWR sky130_fd_sc_hd__decap_3
X_8258_ _8392_/CLK _8258_/D VGND VGND VPWR VPWR _8258_/Q sky130_fd_sc_hd__dfxtp_2
X_8189_ _8389_/CLK _8189_/D VGND VGND VPWR VPWR _8189_/Q sky130_fd_sc_hd__dfxtp_4
X_7209_ _7209_/A _7209_/B VGND VGND VPWR VPWR _7209_/Y sky130_fd_sc_hd__nand2_2
XTAP_TAPCELL_ROW_6_333 VGND VPWR sky130_fd_sc_hd__tapvpwrvgnd_1
XFILLER_101_651 VGND VGND VPWR VPWR sky130_fd_sc_hd__decap_3
XFILLER_59_532 VGND VGND VPWR VPWR sky130_fd_sc_hd__decap_3
XTAP_TAPCELL_ROW_70_1164 VGND VPWR sky130_fd_sc_hd__tapvpwrvgnd_1
XFILLER_101_673 VGND VGND VPWR VPWR sky130_fd_sc_hd__fill_1
XFILLER_19_429 VGND VGND VPWR VPWR sky130_fd_sc_hd__fill_1
XFILLER_74_502 VGND VGND VPWR VPWR sky130_fd_sc_hd__decap_3
XFILLER_86_362 VGND VGND VPWR VPWR sky130_fd_sc_hd__fill_2
XTAP_TAPCELL_ROW_70_1175 VGND VPWR sky130_fd_sc_hd__tapvpwrvgnd_1
XFILLER_100_194 VGND VGND VPWR VPWR sky130_fd_sc_hd__fill_2
XFILLER_86_395 VGND VGND VPWR VPWR sky130_fd_sc_hd__decap_3
XFILLER_36_42 VGND VGND VPWR VPWR sky130_fd_sc_hd__decap_3
XFILLER_74_568 VGND VGND VPWR VPWR sky130_fd_sc_hd__decap_3
XFILLER_27_473 VGND VGND VPWR VPWR sky130_fd_sc_hd__decap_3
XFILLER_36_75 VGND VGND VPWR VPWR sky130_fd_sc_hd__decap_3
XFILLER_42_421 VGND VGND VPWR VPWR sky130_fd_sc_hd__decap_3
XFILLER_14_123 VGND VGND VPWR VPWR sky130_fd_sc_hd__decap_3
XFILLER_15_657 VGND VGND VPWR VPWR sky130_fd_sc_hd__decap_3
XFILLER_15_679 VGND VGND VPWR VPWR sky130_fd_sc_hd__fill_1
XTAP_TAPCELL_ROW_53_950 VGND VPWR sky130_fd_sc_hd__tapvpwrvgnd_1
XFILLER_14_156 VGND VGND VPWR VPWR sky130_fd_sc_hd__decap_3
XFILLER_30_627 VGND VGND VPWR VPWR sky130_fd_sc_hd__decap_3
XFILLER_52_85 VGND VGND VPWR VPWR sky130_fd_sc_hd__decap_3
XFILLER_10_362 VGND VGND VPWR VPWR sky130_fd_sc_hd__fill_2
Xinput28 operand_a[2] VGND VGND VPWR VPWR _4180_/B sky130_fd_sc_hd__clkdlybuf4s25_1
Xinput17 operand_a[1] VGND VGND VPWR VPWR _4178_/B sky130_fd_sc_hd__clkdlybuf4s25_1
XFILLER_6_344 VGND VGND VPWR VPWR sky130_fd_sc_hd__decap_3
Xinput39 operand_a[3] VGND VGND VPWR VPWR _4182_/B sky130_fd_sc_hd__clkdlybuf4s25_1
XFILLER_6_377 VGND VGND VPWR VPWR sky130_fd_sc_hd__decap_3
XFILLER_2_550 VGND VGND VPWR VPWR sky130_fd_sc_hd__fill_1
XFILLER_111_415 VGND VGND VPWR VPWR sky130_fd_sc_hd__decap_3
XFILLER_97_638 VGND VGND VPWR VPWR sky130_fd_sc_hd__decap_3
XFILLER_77_340 VGND VGND VPWR VPWR sky130_fd_sc_hd__decap_3
XFILLER_77_60 VGND VGND VPWR VPWR sky130_fd_sc_hd__decap_3
XFILLER_65_502 VGND VGND VPWR VPWR sky130_fd_sc_hd__fill_2
XFILLER_77_384 VGND VGND VPWR VPWR sky130_fd_sc_hd__decap_3
XTAP_TAPCELL_ROW_88_1403 VGND VPWR sky130_fd_sc_hd__tapvpwrvgnd_1
XFILLER_37_237 VGND VGND VPWR VPWR sky130_fd_sc_hd__decap_3
XFILLER_92_343 VGND VGND VPWR VPWR sky130_fd_sc_hd__fill_1
XFILLER_52_207 VGND VGND VPWR VPWR sky130_fd_sc_hd__decap_3
XFILLER_53_719 VGND VGND VPWR VPWR sky130_fd_sc_hd__fill_1
XFILLER_92_365 VGND VGND VPWR VPWR sky130_fd_sc_hd__decap_3
XFILLER_45_270 VGND VGND VPWR VPWR sky130_fd_sc_hd__decap_3
XFILLER_45_281 VGND VGND VPWR VPWR sky130_fd_sc_hd__decap_3
XFILLER_52_218 VGND VGND VPWR VPWR sky130_fd_sc_hd__decap_3
XFILLER_80_527 VGND VGND VPWR VPWR sky130_fd_sc_hd__decap_3
XFILLER_92_398 VGND VGND VPWR VPWR sky130_fd_sc_hd__decap_3
XFILLER_93_81 VGND VGND VPWR VPWR sky130_fd_sc_hd__decap_3
X_5890_ _5887_/X _4927_/A _5888_/X _5889_/X VGND VGND VPWR VPWR _5890_/X sky130_fd_sc_hd__a211o_4
X_4910_ _8178_/Q _4910_/B VGND VGND VPWR VPWR _6138_/B sky130_fd_sc_hd__nand2_2
XFILLER_33_432 VGND VGND VPWR VPWR sky130_fd_sc_hd__decap_3
X_4841_ _8192_/Q _8256_/Q VGND VGND VPWR VPWR _4842_/B sky130_fd_sc_hd__and2b_2
XFILLER_33_476 VGND VGND VPWR VPWR sky130_fd_sc_hd__decap_3
XFILLER_60_262 VGND VGND VPWR VPWR sky130_fd_sc_hd__fill_1
XFILLER_20_126 VGND VGND VPWR VPWR sky130_fd_sc_hd__decap_3
XFILLER_60_295 VGND VGND VPWR VPWR sky130_fd_sc_hd__decap_3
X_7560_ _7560_/A _7560_/B VGND VGND VPWR VPWR _7563_/A sky130_fd_sc_hd__nand2_2
X_4772_ _7398_/A _7398_/B _7398_/C _7398_/D VGND VGND VPWR VPWR _4791_/C sky130_fd_sc_hd__or4_2
XFILLER_20_159 VGND VGND VPWR VPWR sky130_fd_sc_hd__decap_3
X_7491_ _8218_/Q _8282_/Q _8281_/Q _8217_/Q VGND VGND VPWR VPWR _7491_/X sky130_fd_sc_hd__o211a_2
X_6511_ _5528_/A _6510_/X _5857_/A VGND VGND VPWR VPWR _6511_/X sky130_fd_sc_hd__o21a_2
XTAP_TAPCELL_ROW_99_1543 VGND VPWR sky130_fd_sc_hd__tapvpwrvgnd_1
XTAP_TAPCELL_ROW_31_666 VGND VPWR sky130_fd_sc_hd__tapvpwrvgnd_1
X_6442_ _4886_/B _6564_/C _6403_/B _6441_/X VGND VGND VPWR VPWR _6443_/A sky130_fd_sc_hd__a31o_2
XFILLER_106_209 VGND VGND VPWR VPWR sky130_fd_sc_hd__decap_3
XFILLER_114_220 VGND VGND VPWR VPWR sky130_fd_sc_hd__decap_3
XFILLER_115_732 VGND VGND VPWR VPWR sky130_fd_sc_hd__fill_1
X_8112_ _8377_/CLK _8112_/D VGND VGND VPWR VPWR _8112_/Q sky130_fd_sc_hd__dfxtp_2
X_6373_ _8186_/Q _8250_/Q _6086_/A VGND VGND VPWR VPWR _6373_/Y sky130_fd_sc_hd__a21oi_2
XFILLER_114_253 VGND VGND VPWR VPWR sky130_fd_sc_hd__decap_3
X_5324_ _6706_/S _5411_/B _7631_/B VGND VGND VPWR VPWR _5325_/B sky130_fd_sc_hd__o21ai_2
XFILLER_102_404 VGND VGND VPWR VPWR sky130_fd_sc_hd__decap_3
X_8043_ _8360_/CLK _8043_/D VGND VGND VPWR VPWR _8043_/Q sky130_fd_sc_hd__dfxtp_2
X_5255_ _5251_/X _5252_/X _5253_/X _5254_/X _7783_/A _5684_/S VGND VGND VPWR VPWR
+ _5255_/X sky130_fd_sc_hd__mux4_2
XFILLER_102_459 VGND VGND VPWR VPWR sky130_fd_sc_hd__decap_3
X_4206_ _7898_/B _4206_/B VGND VGND VPWR VPWR _4207_/A sky130_fd_sc_hd__and2_2
XFILLER_29_705 VGND VGND VPWR VPWR sky130_fd_sc_hd__decap_3
XFILLER_3_90 VGND VGND VPWR VPWR sky130_fd_sc_hd__decap_3
XFILLER_56_502 VGND VGND VPWR VPWR sky130_fd_sc_hd__decap_3
XFILLER_68_362 VGND VGND VPWR VPWR sky130_fd_sc_hd__fill_2
XFILLER_96_660 VGND VGND VPWR VPWR sky130_fd_sc_hd__decap_3
X_5186_ _5186_/A _5186_/B VGND VGND VPWR VPWR _5186_/Y sky130_fd_sc_hd__nand2_2
XTAP_TAPCELL_ROW_3_303 VGND VPWR sky130_fd_sc_hd__tapvpwrvgnd_1
XFILLER_113_36 VGND VGND VPWR VPWR sky130_fd_sc_hd__decap_3
XFILLER_28_237 VGND VGND VPWR VPWR sky130_fd_sc_hd__decap_3
XFILLER_56_524 VGND VGND VPWR VPWR sky130_fd_sc_hd__decap_3
X_4137_ _4137_/A VGND VGND VPWR VPWR _8006_/D sky130_fd_sc_hd__buf_1
XFILLER_71_505 VGND VGND VPWR VPWR sky130_fd_sc_hd__decap_3
XFILLER_83_376 VGND VGND VPWR VPWR sky130_fd_sc_hd__fill_2
X_4068_ _7898_/B _8375_/Q VGND VGND VPWR VPWR _4069_/A sky130_fd_sc_hd__and2_2
XTAP_TAPCELL_ROW_39_766 VGND VPWR sky130_fd_sc_hd__tapvpwrvgnd_1
XFILLER_24_421 VGND VGND VPWR VPWR sky130_fd_sc_hd__decap_3
XFILLER_36_270 VGND VGND VPWR VPWR sky130_fd_sc_hd__decap_3
XTAP_TAPCELL_ROW_108_1661 VGND VPWR sky130_fd_sc_hd__tapvpwrvgnd_1
X_7827_ _7827_/A _7827_/B _7827_/C VGND VGND VPWR VPWR _7828_/B sky130_fd_sc_hd__and3_2
XFILLER_51_251 VGND VGND VPWR VPWR sky130_fd_sc_hd__decap_3
XFILLER_24_498 VGND VGND VPWR VPWR sky130_fd_sc_hd__decap_3
XFILLER_51_284 VGND VGND VPWR VPWR sky130_fd_sc_hd__decap_3
X_7758_ _7796_/A _8206_/Q VGND VGND VPWR VPWR _7758_/Y sky130_fd_sc_hd__nand2_2
XFILLER_11_148 VGND VGND VPWR VPWR sky130_fd_sc_hd__decap_3
XFILLER_7_119 VGND VGND VPWR VPWR sky130_fd_sc_hd__decap_3
X_7689_ _7670_/A _5121_/A _7687_/Y _7688_/Y VGND VGND VPWR VPWR _7689_/X sky130_fd_sc_hd__a31o_2
X_6709_ _7825_/A _6707_/X _6708_/X _6623_/A VGND VGND VPWR VPWR _6709_/X sky130_fd_sc_hd__o211a_2
XFILLER_20_693 VGND VGND VPWR VPWR sky130_fd_sc_hd__decap_3
XTAP_TAPCELL_ROW_59_1026 VGND VPWR sky130_fd_sc_hd__tapvpwrvgnd_1
XFILLER_105_220 VGND VGND VPWR VPWR sky130_fd_sc_hd__decap_3
XFILLER_3_303 VGND VGND VPWR VPWR sky130_fd_sc_hd__decap_3
XFILLER_3_369 VGND VGND VPWR VPWR sky130_fd_sc_hd__fill_1
XFILLER_105_275 VGND VGND VPWR VPWR sky130_fd_sc_hd__decap_3
XFILLER_59_340 VGND VGND VPWR VPWR sky130_fd_sc_hd__fill_2
XFILLER_19_204 VGND VGND VPWR VPWR sky130_fd_sc_hd__decap_3
XFILLER_59_362 VGND VGND VPWR VPWR sky130_fd_sc_hd__decap_3
XFILLER_87_660 VGND VGND VPWR VPWR sky130_fd_sc_hd__decap_3
XFILLER_87_682 VGND VGND VPWR VPWR sky130_fd_sc_hd__decap_3
XFILLER_101_481 VGND VGND VPWR VPWR sky130_fd_sc_hd__decap_3
XFILLER_19_215 VGND VGND VPWR VPWR sky130_fd_sc_hd__decap_3
XFILLER_47_52 VGND VGND VPWR VPWR sky130_fd_sc_hd__decap_3
XFILLER_47_524 VGND VGND VPWR VPWR sky130_fd_sc_hd__decap_3
XFILLER_47_546 VGND VGND VPWR VPWR sky130_fd_sc_hd__fill_2
XFILLER_74_321 VGND VGND VPWR VPWR sky130_fd_sc_hd__decap_3
XFILLER_47_579 VGND VGND VPWR VPWR sky130_fd_sc_hd__decap_3
XFILLER_47_96 VGND VGND VPWR VPWR sky130_fd_sc_hd__decap_3
XFILLER_74_354 VGND VGND VPWR VPWR sky130_fd_sc_hd__decap_3
XFILLER_74_365 VGND VGND VPWR VPWR sky130_fd_sc_hd__decap_3
XFILLER_74_398 VGND VGND VPWR VPWR sky130_fd_sc_hd__decap_3
XFILLER_103_91 VGND VGND VPWR VPWR sky130_fd_sc_hd__fill_2
XFILLER_27_281 VGND VGND VPWR VPWR sky130_fd_sc_hd__decap_3
XTAP_TAPCELL_ROW_83_1344 VGND VPWR sky130_fd_sc_hd__tapvpwrvgnd_1
XTAP_TAPCELL_ROW_83_1333 VGND VPWR sky130_fd_sc_hd__tapvpwrvgnd_1
XFILLER_30_402 VGND VGND VPWR VPWR sky130_fd_sc_hd__decap_3
XFILLER_63_84 VGND VGND VPWR VPWR sky130_fd_sc_hd__fill_2
XFILLER_70_560 VGND VGND VPWR VPWR sky130_fd_sc_hd__decap_3
XFILLER_30_424 VGND VGND VPWR VPWR sky130_fd_sc_hd__decap_3
XFILLER_63_95 VGND VGND VPWR VPWR sky130_fd_sc_hd__decap_3
XFILLER_11_682 VGND VGND VPWR VPWR sky130_fd_sc_hd__decap_3
XFILLER_6_141 VGND VGND VPWR VPWR sky130_fd_sc_hd__decap_3
XFILLER_109_592 VGND VGND VPWR VPWR sky130_fd_sc_hd__decap_3
XTAP_TAPCELL_ROW_94_1484 VGND VPWR sky130_fd_sc_hd__tapvpwrvgnd_1
XFILLER_97_435 VGND VGND VPWR VPWR sky130_fd_sc_hd__fill_2
XFILLER_111_234 VGND VGND VPWR VPWR sky130_fd_sc_hd__decap_3
XFILLER_69_159 VGND VGND VPWR VPWR sky130_fd_sc_hd__decap_3
X_5040_ _8243_/Q _5038_/X _5039_/X VGND VGND VPWR VPWR _5040_/X sky130_fd_sc_hd__o21a_2
XFILLER_26_3 VGND VGND VPWR VPWR sky130_fd_sc_hd__fill_2
XFILLER_97_479 VGND VGND VPWR VPWR sky130_fd_sc_hd__decap_3
XFILLER_65_332 VGND VGND VPWR VPWR sky130_fd_sc_hd__decap_3
XFILLER_77_181 VGND VGND VPWR VPWR sky130_fd_sc_hd__decap_3
XFILLER_93_630 VGND VGND VPWR VPWR sky130_fd_sc_hd__decap_3
XFILLER_38_557 VGND VGND VPWR VPWR sky130_fd_sc_hd__decap_3
XFILLER_38_579 VGND VGND VPWR VPWR sky130_fd_sc_hd__decap_3
XFILLER_53_505 VGND VGND VPWR VPWR sky130_fd_sc_hd__decap_3
XFILLER_65_343 VGND VGND VPWR VPWR sky130_fd_sc_hd__decap_3
XFILLER_92_151 VGND VGND VPWR VPWR sky130_fd_sc_hd__decap_3
X_6991_ _6973_/X _6987_/X _6990_/Y _7930_/B VGND VGND VPWR VPWR _8337_/D sky130_fd_sc_hd__o31a_4
X_5942_ _6023_/A _6022_/C VGND VGND VPWR VPWR _5942_/Y sky130_fd_sc_hd__nor2_2
XTAP_TAPCELL_ROW_36_725 VGND VPWR sky130_fd_sc_hd__tapvpwrvgnd_1
XFILLER_18_292 VGND VGND VPWR VPWR sky130_fd_sc_hd__decap_3
XFILLER_80_357 VGND VGND VPWR VPWR sky130_fd_sc_hd__decap_3
XFILLER_80_368 VGND VGND VPWR VPWR sky130_fd_sc_hd__fill_1
XFILLER_21_402 VGND VGND VPWR VPWR sky130_fd_sc_hd__fill_2
XFILLER_21_413 VGND VGND VPWR VPWR sky130_fd_sc_hd__decap_3
X_5873_ _8235_/Q _5873_/B VGND VGND VPWR VPWR _5873_/X sky130_fd_sc_hd__or2_4
X_7612_ _7612_/A _7612_/B _7612_/C _7612_/D VGND VGND VPWR VPWR _7646_/B sky130_fd_sc_hd__or4_2
X_4824_ _4824_/A _4824_/B _7076_/B _7167_/B VGND VGND VPWR VPWR _4855_/A sky130_fd_sc_hd__or4_2
XTAP_TAPCELL_ROW_16_471 VGND VPWR sky130_fd_sc_hd__tapvpwrvgnd_1
XFILLER_119_312 VGND VGND VPWR VPWR sky130_fd_sc_hd__decap_3
XFILLER_21_468 VGND VGND VPWR VPWR sky130_fd_sc_hd__decap_3
X_7543_ _8284_/Q _7517_/B _7542_/X VGND VGND VPWR VPWR _7544_/B sky130_fd_sc_hd__a21o_2
X_4755_ _7844_/B _7630_/B VGND VGND VPWR VPWR _7649_/B sky130_fd_sc_hd__nand2_2
XFILLER_119_323 VGND VGND VPWR VPWR sky130_fd_sc_hd__decap_3
Xrebuffer728 _6218_/X VGND VGND VPWR VPWR _6255_/A2 sky130_fd_sc_hd__buf_4
X_7474_ _7474_/A _7612_/B VGND VGND VPWR VPWR _7476_/B sky130_fd_sc_hd__nor2_2
X_4686_ _7930_/B _8147_/Q VGND VGND VPWR VPWR _4687_/A sky130_fd_sc_hd__and2_2
X_6425_ _6109_/A _6424_/X _5186_/A VGND VGND VPWR VPWR _6425_/Y sky130_fd_sc_hd__o21ai_2
X_6356_ _6272_/Y _6354_/Y _6355_/X _5740_/A VGND VGND VPWR VPWR _6356_/X sky130_fd_sc_hd__o2bb2a_2
XFILLER_102_212 VGND VGND VPWR VPWR sky130_fd_sc_hd__decap_3
XFILLER_88_402 VGND VGND VPWR VPWR sky130_fd_sc_hd__decap_3
X_5307_ _5245_/Y _5271_/X _5273_/Y _5276_/Y _5306_/X VGND VGND VPWR VPWR _5307_/Y
+ sky130_fd_sc_hd__a221oi_2
XFILLER_76_608 VGND VGND VPWR VPWR sky130_fd_sc_hd__decap_3
XFILLER_88_435 VGND VGND VPWR VPWR sky130_fd_sc_hd__decap_3
X_8026_ _8187_/CLK _8026_/D VGND VGND VPWR VPWR _8026_/Q sky130_fd_sc_hd__dfxtp_2
X_6287_ _6097_/A _8240_/Q _6053_/X VGND VGND VPWR VPWR _6287_/X sky130_fd_sc_hd__a21o_2
XFILLER_102_278 VGND VGND VPWR VPWR sky130_fd_sc_hd__decap_3
XFILLER_69_660 VGND VGND VPWR VPWR sky130_fd_sc_hd__decap_3
X_5238_ _7617_/A _6775_/B VGND VGND VPWR VPWR _6070_/B sky130_fd_sc_hd__nor2_2
XFILLER_29_535 VGND VGND VPWR VPWR sky130_fd_sc_hd__decap_3
XFILLER_69_682 VGND VGND VPWR VPWR sky130_fd_sc_hd__decap_3
XFILLER_84_17 VGND VGND VPWR VPWR sky130_fd_sc_hd__decap_3
X_5169_ _5167_/X _5168_/X _7653_/A VGND VGND VPWR VPWR _5169_/X sky130_fd_sc_hd__mux2_2
XFILLER_56_365 VGND VGND VPWR VPWR sky130_fd_sc_hd__decap_3
XFILLER_16_218 VGND VGND VPWR VPWR sky130_fd_sc_hd__decap_3
XFILLER_44_516 VGND VGND VPWR VPWR sky130_fd_sc_hd__fill_1
XFILLER_44_527 VGND VGND VPWR VPWR sky130_fd_sc_hd__decap_3
XFILLER_56_398 VGND VGND VPWR VPWR sky130_fd_sc_hd__decap_3
XFILLER_71_302 VGND VGND VPWR VPWR sky130_fd_sc_hd__fill_1
XFILLER_83_162 VGND VGND VPWR VPWR sky130_fd_sc_hd__decap_3
XFILLER_17_77 VGND VGND VPWR VPWR sky130_fd_sc_hd__fill_2
XFILLER_44_549 VGND VGND VPWR VPWR sky130_fd_sc_hd__fill_2
XFILLER_24_251 VGND VGND VPWR VPWR sky130_fd_sc_hd__fill_1
XFILLER_33_10 VGND VGND VPWR VPWR sky130_fd_sc_hd__decap_3
XFILLER_52_560 VGND VGND VPWR VPWR sky130_fd_sc_hd__decap_3
XFILLER_71_379 VGND VGND VPWR VPWR sky130_fd_sc_hd__decap_3
XFILLER_12_413 VGND VGND VPWR VPWR sky130_fd_sc_hd__decap_3
XFILLER_12_424 VGND VGND VPWR VPWR sky130_fd_sc_hd__decap_3
XFILLER_33_43 VGND VGND VPWR VPWR sky130_fd_sc_hd__decap_3
XFILLER_40_722 VGND VGND VPWR VPWR sky130_fd_sc_hd__decap_3
XFILLER_52_582 VGND VGND VPWR VPWR sky130_fd_sc_hd__decap_3
XFILLER_12_457 VGND VGND VPWR VPWR sky130_fd_sc_hd__decap_3
XFILLER_8_439 VGND VGND VPWR VPWR sky130_fd_sc_hd__decap_3
XFILLER_3_111 VGND VGND VPWR VPWR sky130_fd_sc_hd__fill_1
XFILLER_106_551 VGND VGND VPWR VPWR sky130_fd_sc_hd__decap_3
XFILLER_106_584 VGND VGND VPWR VPWR sky130_fd_sc_hd__decap_3
XFILLER_3_155 VGND VGND VPWR VPWR sky130_fd_sc_hd__fill_1
XFILLER_79_413 VGND VGND VPWR VPWR sky130_fd_sc_hd__decap_3
XFILLER_3_199 VGND VGND VPWR VPWR sky130_fd_sc_hd__decap_3
XFILLER_79_468 VGND VGND VPWR VPWR sky130_fd_sc_hd__decap_3
XFILLER_94_416 VGND VGND VPWR VPWR sky130_fd_sc_hd__decap_3
XFILLER_94_427 VGND VGND VPWR VPWR sky130_fd_sc_hd__decap_3
Xsplit326 _6353_/A VGND VGND VPWR VPWR _6277_/A sky130_fd_sc_hd__clkbuf_8
XFILLER_47_321 VGND VGND VPWR VPWR sky130_fd_sc_hd__decap_3
XFILLER_75_630 VGND VGND VPWR VPWR sky130_fd_sc_hd__fill_2
XFILLER_35_505 VGND VGND VPWR VPWR sky130_fd_sc_hd__decap_3
XFILLER_47_343 VGND VGND VPWR VPWR sky130_fd_sc_hd__decap_3
XFILLER_47_354 VGND VGND VPWR VPWR sky130_fd_sc_hd__decap_3
XFILLER_59_192 VGND VGND VPWR VPWR sky130_fd_sc_hd__decap_3
XFILLER_47_387 VGND VGND VPWR VPWR sky130_fd_sc_hd__decap_3
XFILLER_62_324 VGND VGND VPWR VPWR sky130_fd_sc_hd__decap_3
XFILLER_75_685 VGND VGND VPWR VPWR sky130_fd_sc_hd__decap_3
XFILLER_90_622 VGND VGND VPWR VPWR sky130_fd_sc_hd__decap_3
XFILLER_16_730 VGND VGND VPWR VPWR sky130_fd_sc_hd__decap_3
XFILLER_74_195 VGND VGND VPWR VPWR sky130_fd_sc_hd__fill_1
XFILLER_74_72 VGND VGND VPWR VPWR sky130_fd_sc_hd__decap_3
XFILLER_90_655 VGND VGND VPWR VPWR sky130_fd_sc_hd__decap_3
XFILLER_15_240 VGND VGND VPWR VPWR sky130_fd_sc_hd__decap_3
XFILLER_31_711 VGND VGND VPWR VPWR sky130_fd_sc_hd__decap_3
XFILLER_50_508 VGND VGND VPWR VPWR sky130_fd_sc_hd__decap_3
XFILLER_62_368 VGND VGND VPWR VPWR sky130_fd_sc_hd__fill_2
XFILLER_62_379 VGND VGND VPWR VPWR sky130_fd_sc_hd__decap_3
XFILLER_90_677 VGND VGND VPWR VPWR sky130_fd_sc_hd__decap_3
XFILLER_90_699 VGND VGND VPWR VPWR sky130_fd_sc_hd__fill_1
XFILLER_15_284 VGND VGND VPWR VPWR sky130_fd_sc_hd__decap_3
XFILLER_70_390 VGND VGND VPWR VPWR sky130_fd_sc_hd__decap_3
XFILLER_90_82 VGND VGND VPWR VPWR sky130_fd_sc_hd__fill_2
XTAP_TAPCELL_ROW_13_430 VGND VPWR sky130_fd_sc_hd__tapvpwrvgnd_1
XFILLER_30_265 VGND VGND VPWR VPWR sky130_fd_sc_hd__decap_3
XTAP_TAPCELL_ROW_96_1502 VGND VPWR sky130_fd_sc_hd__tapvpwrvgnd_1
XTAP_TAPCELL_ROW_41_794 VGND VPWR sky130_fd_sc_hd__tapvpwrvgnd_1
XFILLER_116_304 VGND VGND VPWR VPWR sky130_fd_sc_hd__decap_3
XFILLER_11_490 VGND VGND VPWR VPWR sky130_fd_sc_hd__fill_2
Xclkbuf_leaf_10_clk clkload1/A VGND VGND VPWR VPWR _8287_/CLK sky130_fd_sc_hd__clkbuf_8
X_4540_ _7843_/A _8074_/Q VGND VGND VPWR VPWR _4541_/A sky130_fd_sc_hd__and2_2
XTAP_TAPCELL_ROW_96_1513 VGND VPWR sky130_fd_sc_hd__tapvpwrvgnd_1
XFILLER_116_315 VGND VGND VPWR VPWR sky130_fd_sc_hd__decap_3
XFILLER_7_472 VGND VGND VPWR VPWR sky130_fd_sc_hd__decap_3
X_4471_ _4471_/A VGND VGND VPWR VPWR _8173_/D sky130_fd_sc_hd__buf_1
XFILLER_116_348 VGND VGND VPWR VPWR sky130_fd_sc_hd__decap_3
X_7190_ _7195_/A _7221_/B VGND VGND VPWR VPWR _7190_/Y sky130_fd_sc_hd__nor2_2
X_6210_ _6181_/X _6394_/A _4897_/A VGND VGND VPWR VPWR _6210_/X sky130_fd_sc_hd__o21a_4
X_6141_ _8242_/Q _6079_/A _6079_/B _8178_/Q VGND VGND VPWR VPWR _6141_/X sky130_fd_sc_hd__a31o_4
XFILLER_97_221 VGND VGND VPWR VPWR sky130_fd_sc_hd__decap_3
XFILLER_97_243 VGND VGND VPWR VPWR sky130_fd_sc_hd__fill_1
XFILLER_85_405 VGND VGND VPWR VPWR sky130_fd_sc_hd__decap_3
XFILLER_97_265 VGND VGND VPWR VPWR sky130_fd_sc_hd__decap_3
X_6072_ _6072_/A _6072_/B VGND VGND VPWR VPWR _6072_/X sky130_fd_sc_hd__and2_2
XFILLER_112_598 VGND VGND VPWR VPWR sky130_fd_sc_hd__decap_3
XFILLER_38_321 VGND VGND VPWR VPWR sky130_fd_sc_hd__fill_1
XFILLER_85_449 VGND VGND VPWR VPWR sky130_fd_sc_hd__decap_3
X_5023_ _8232_/Q _5702_/A VGND VGND VPWR VPWR _5888_/A sky130_fd_sc_hd__or2b_2
XFILLER_26_505 VGND VGND VPWR VPWR sky130_fd_sc_hd__decap_3
XFILLER_38_354 VGND VGND VPWR VPWR sky130_fd_sc_hd__decap_3
XFILLER_66_641 VGND VGND VPWR VPWR sky130_fd_sc_hd__decap_3
XFILLER_38_365 VGND VGND VPWR VPWR sky130_fd_sc_hd__decap_3
XFILLER_38_398 VGND VGND VPWR VPWR sky130_fd_sc_hd__fill_2
XFILLER_66_674 VGND VGND VPWR VPWR sky130_fd_sc_hd__decap_3
XFILLER_66_696 VGND VGND VPWR VPWR sky130_fd_sc_hd__decap_3
XFILLER_81_611 VGND VGND VPWR VPWR sky130_fd_sc_hd__decap_3
XFILLER_81_633 VGND VGND VPWR VPWR sky130_fd_sc_hd__decap_3
XFILLER_93_482 VGND VGND VPWR VPWR sky130_fd_sc_hd__decap_3
XTAP_TAPCELL_ROW_49_894 VGND VPWR sky130_fd_sc_hd__tapvpwrvgnd_1
XFILLER_26_549 VGND VGND VPWR VPWR sky130_fd_sc_hd__decap_3
XFILLER_53_335 VGND VGND VPWR VPWR sky130_fd_sc_hd__fill_1
XFILLER_53_357 VGND VGND VPWR VPWR sky130_fd_sc_hd__decap_3
XFILLER_65_184 VGND VGND VPWR VPWR sky130_fd_sc_hd__decap_3
XFILLER_80_132 VGND VGND VPWR VPWR sky130_fd_sc_hd__decap_3
XTAP_TAPCELL_ROW_105_1620 VGND VPWR sky130_fd_sc_hd__tapvpwrvgnd_1
X_6974_ _8267_/Q _5292_/X _5111_/X VGND VGND VPWR VPWR _6974_/X sky130_fd_sc_hd__a21o_2
XFILLER_0_91 VGND VGND VPWR VPWR sky130_fd_sc_hd__decap_3
XFILLER_34_560 VGND VGND VPWR VPWR sky130_fd_sc_hd__fill_1
XFILLER_41_508 VGND VGND VPWR VPWR sky130_fd_sc_hd__decap_3
X_5925_ _5928_/A _5925_/B _5925_/C VGND VGND VPWR VPWR _5925_/X sky130_fd_sc_hd__and3_2
XFILLER_110_59 VGND VGND VPWR VPWR sky130_fd_sc_hd__decap_3
X_5856_ _5853_/X _5855_/X _6620_/A VGND VGND VPWR VPWR _5857_/B sky130_fd_sc_hd__mux2_2
XFILLER_21_243 VGND VGND VPWR VPWR sky130_fd_sc_hd__decap_3
XPHY_EDGE_ROW_3_Right_3 VGND VGND VPWR VPWR sky130_fd_sc_hd__decap_3
X_4807_ _7166_/A _7166_/B _7166_/C _7166_/D VGND VGND VPWR VPWR _4824_/A sky130_fd_sc_hd__or4_2
XFILLER_21_276 VGND VGND VPWR VPWR sky130_fd_sc_hd__decap_3
X_5787_ _5528_/A _5778_/X _5779_/X _5786_/X VGND VGND VPWR VPWR _5787_/X sky130_fd_sc_hd__a31o_2
XFILLER_119_35 VGND VGND VPWR VPWR sky130_fd_sc_hd__decap_3
X_7526_ _8284_/Q _5422_/X _7525_/X _8290_/Q _6687_/X VGND VGND VPWR VPWR _7526_/X
+ sky130_fd_sc_hd__a221o_2
X_4738_ _4738_/A _7522_/A _7497_/A VGND VGND VPWR VPWR _4973_/A sky130_fd_sc_hd__or3b_2
XFILLER_107_315 VGND VGND VPWR VPWR sky130_fd_sc_hd__decap_3
XFILLER_107_337 VGND VGND VPWR VPWR sky130_fd_sc_hd__fill_2
XFILLER_119_57 VGND VGND VPWR VPWR sky130_fd_sc_hd__decap_3
XFILLER_79_17 VGND VGND VPWR VPWR sky130_fd_sc_hd__decap_3
X_7457_ _7457_/A VGND VGND VPWR VPWR _8351_/D sky130_fd_sc_hd__buf_1
X_4669_ _4669_/A VGND VGND VPWR VPWR _8272_/D sky130_fd_sc_hd__buf_1
X_6408_ _8185_/Q _8249_/Q _6312_/X VGND VGND VPWR VPWR _6408_/X sky130_fd_sc_hd__a21o_2
XFILLER_0_103 VGND VGND VPWR VPWR sky130_fd_sc_hd__decap_3
XTAP_TAPCELL_ROW_116_1771 VGND VPWR sky130_fd_sc_hd__tapvpwrvgnd_1
X_7388_ _8215_/Q _8214_/Q _8213_/Q _8212_/Q _7796_/A _7765_/A VGND VGND VPWR VPWR
+ _7388_/X sky130_fd_sc_hd__mux4_2
XFILLER_0_125 VGND VGND VPWR VPWR sky130_fd_sc_hd__decap_3
XFILLER_103_543 VGND VGND VPWR VPWR sky130_fd_sc_hd__decap_3
X_6339_ _8185_/Q _6334_/Y _6433_/C _6338_/Y VGND VGND VPWR VPWR _6339_/X sky130_fd_sc_hd__o31a_2
XFILLER_0_169 VGND VGND VPWR VPWR sky130_fd_sc_hd__decap_3
XFILLER_76_416 VGND VGND VPWR VPWR sky130_fd_sc_hd__decap_3
XFILLER_88_265 VGND VGND VPWR VPWR sky130_fd_sc_hd__decap_3
XFILLER_95_27 VGND VGND VPWR VPWR sky130_fd_sc_hd__decap_3
XFILLER_28_32 VGND VGND VPWR VPWR sky130_fd_sc_hd__decap_3
XFILLER_48_129 VGND VGND VPWR VPWR sky130_fd_sc_hd__decap_3
XFILLER_57_630 VGND VGND VPWR VPWR sky130_fd_sc_hd__decap_3
XFILLER_76_427 VGND VGND VPWR VPWR sky130_fd_sc_hd__decap_3
XFILLER_88_287 VGND VGND VPWR VPWR sky130_fd_sc_hd__decap_3
X_8009_ _8355_/CLK _8009_/D VGND VGND VPWR VPWR _8009_/Q sky130_fd_sc_hd__dfxtp_2
XFILLER_28_65 VGND VGND VPWR VPWR sky130_fd_sc_hd__decap_3
XFILLER_57_652 VGND VGND VPWR VPWR sky130_fd_sc_hd__fill_2
XFILLER_57_663 VGND VGND VPWR VPWR sky130_fd_sc_hd__decap_3
XFILLER_91_408 VGND VGND VPWR VPWR sky130_fd_sc_hd__decap_3
XFILLER_17_538 VGND VGND VPWR VPWR sky130_fd_sc_hd__decap_3
XFILLER_29_365 VGND VGND VPWR VPWR sky130_fd_sc_hd__fill_1
XFILLER_29_387 VGND VGND VPWR VPWR sky130_fd_sc_hd__decap_3
XFILLER_44_302 VGND VGND VPWR VPWR sky130_fd_sc_hd__decap_3
XFILLER_56_162 VGND VGND VPWR VPWR sky130_fd_sc_hd__decap_3
XFILLER_72_611 VGND VGND VPWR VPWR sky130_fd_sc_hd__decap_3
XTAP_TAPCELL_ROW_67_1125 VGND VPWR sky130_fd_sc_hd__tapvpwrvgnd_1
XFILLER_44_324 VGND VGND VPWR VPWR sky130_fd_sc_hd__decap_3
XFILLER_56_195 VGND VGND VPWR VPWR sky130_fd_sc_hd__fill_1
XFILLER_72_633 VGND VGND VPWR VPWR sky130_fd_sc_hd__decap_3
XTAP_TAPCELL_ROW_67_1136 VGND VPWR sky130_fd_sc_hd__tapvpwrvgnd_1
XFILLER_44_368 VGND VGND VPWR VPWR sky130_fd_sc_hd__decap_3
XTAP_TAPCELL_ROW_80_1303 VGND VPWR sky130_fd_sc_hd__tapvpwrvgnd_1
XFILLER_100_70 VGND VGND VPWR VPWR sky130_fd_sc_hd__decap_3
XFILLER_12_265 VGND VGND VPWR VPWR sky130_fd_sc_hd__decap_3
XFILLER_12_287 VGND VGND VPWR VPWR sky130_fd_sc_hd__decap_3
XFILLER_40_585 VGND VGND VPWR VPWR sky130_fd_sc_hd__decap_3
XFILLER_60_74 VGND VGND VPWR VPWR sky130_fd_sc_hd__decap_3
XFILLER_60_85 VGND VGND VPWR VPWR sky130_fd_sc_hd__decap_3
XFILLER_4_431 VGND VGND VPWR VPWR sky130_fd_sc_hd__decap_3
XFILLER_99_508 VGND VGND VPWR VPWR sky130_fd_sc_hd__decap_3
XTAP_TAPCELL_ROW_78_1276 VGND VPWR sky130_fd_sc_hd__tapvpwrvgnd_1
XFILLER_113_318 VGND VGND VPWR VPWR sky130_fd_sc_hd__decap_3
XFILLER_4_453 VGND VGND VPWR VPWR sky130_fd_sc_hd__decap_3
XFILLER_4_486 VGND VGND VPWR VPWR sky130_fd_sc_hd__decap_3
XTAP_TAPCELL_ROW_91_1443 VGND VPWR sky130_fd_sc_hd__tapvpwrvgnd_1
XFILLER_67_405 VGND VGND VPWR VPWR sky130_fd_sc_hd__decap_3
XFILLER_79_265 VGND VGND VPWR VPWR sky130_fd_sc_hd__decap_3
XFILLER_0_681 VGND VGND VPWR VPWR sky130_fd_sc_hd__fill_2
XFILLER_48_630 VGND VGND VPWR VPWR sky130_fd_sc_hd__decap_3
XFILLER_67_438 VGND VGND VPWR VPWR sky130_fd_sc_hd__decap_3
XFILLER_67_449 VGND VGND VPWR VPWR sky130_fd_sc_hd__decap_3
XFILLER_79_287 VGND VGND VPWR VPWR sky130_fd_sc_hd__decap_3
XFILLER_94_213 VGND VGND VPWR VPWR sky130_fd_sc_hd__decap_3
XFILLER_47_140 VGND VGND VPWR VPWR sky130_fd_sc_hd__fill_2
XFILLER_48_663 VGND VGND VPWR VPWR sky130_fd_sc_hd__decap_3
XFILLER_85_60 VGND VGND VPWR VPWR sky130_fd_sc_hd__decap_3
XFILLER_94_268 VGND VGND VPWR VPWR sky130_fd_sc_hd__decap_3
XFILLER_35_302 VGND VGND VPWR VPWR sky130_fd_sc_hd__fill_2
XFILLER_48_696 VGND VGND VPWR VPWR sky130_fd_sc_hd__decap_3
XFILLER_82_419 VGND VGND VPWR VPWR sky130_fd_sc_hd__fill_1
XFILLER_85_93 VGND VGND VPWR VPWR sky130_fd_sc_hd__decap_3
XFILLER_62_121 VGND VGND VPWR VPWR sky130_fd_sc_hd__decap_3
XFILLER_75_493 VGND VGND VPWR VPWR sky130_fd_sc_hd__decap_3
XFILLER_16_560 VGND VGND VPWR VPWR sky130_fd_sc_hd__decap_3
XFILLER_35_379 VGND VGND VPWR VPWR sky130_fd_sc_hd__decap_3
XFILLER_62_165 VGND VGND VPWR VPWR sky130_fd_sc_hd__decap_3
X_3971_ _3971_/A VGND VGND VPWR VPWR _7934_/D sky130_fd_sc_hd__buf_1
XTAP_TAPCELL_ROW_46_853 VGND VPWR sky130_fd_sc_hd__tapvpwrvgnd_1
XFILLER_50_327 VGND VGND VPWR VPWR sky130_fd_sc_hd__decap_3
XFILLER_90_496 VGND VGND VPWR VPWR sky130_fd_sc_hd__decap_3
X_5710_ _5687_/X _5695_/X _5706_/X _5709_/X _4716_/X VGND VGND VPWR VPWR _5710_/X
+ sky130_fd_sc_hd__a32o_2
X_6690_ _6671_/Y _6672_/X _6675_/Y _6964_/A _6689_/X VGND VGND VPWR VPWR _6690_/X
+ sky130_fd_sc_hd__a221o_2
XTAP_TAPCELL_ROW_100_1561 VGND VPWR sky130_fd_sc_hd__tapvpwrvgnd_1
X_5641_ _5444_/X _5822_/B _7555_/S VGND VGND VPWR VPWR _5641_/X sky130_fd_sc_hd__mux2_2
X_8360_ _8360_/CLK _8360_/D VGND VGND VPWR VPWR _8360_/Q sky130_fd_sc_hd__dfxtp_2
X_5572_ _6721_/A _5572_/B VGND VGND VPWR VPWR _5572_/Y sky130_fd_sc_hd__nand2_2
X_8291_ _8359_/CLK _8291_/D VGND VGND VPWR VPWR _8291_/Q sky130_fd_sc_hd__dfxtp_2
X_7311_ _4764_/B _7289_/A _7289_/B _8212_/Q VGND VGND VPWR VPWR _7312_/B sky130_fd_sc_hd__a31o_2
X_4523_ _4523_/A VGND VGND VPWR VPWR _8199_/D sky130_fd_sc_hd__buf_1
XFILLER_116_134 VGND VGND VPWR VPWR sky130_fd_sc_hd__decap_3
XFILLER_117_679 VGND VGND VPWR VPWR sky130_fd_sc_hd__fill_1
XFILLER_7_291 VGND VGND VPWR VPWR sky130_fd_sc_hd__decap_3
X_7242_ _7193_/A _7241_/X _6533_/A VGND VGND VPWR VPWR _7243_/B sky130_fd_sc_hd__o21ai_2
XFILLER_116_189 VGND VGND VPWR VPWR sky130_fd_sc_hd__decap_3
X_4454_ _7898_/B _8031_/Q VGND VGND VPWR VPWR _4455_/A sky130_fd_sc_hd__and2_2
XFILLER_98_530 VGND VGND VPWR VPWR sky130_fd_sc_hd__fill_2
X_7173_ _8201_/Q _8265_/Q _7078_/B VGND VGND VPWR VPWR _7173_/X sky130_fd_sc_hd__a21o_2
X_4385_ _4385_/A VGND VGND VPWR VPWR _8130_/D sky130_fd_sc_hd__buf_1
XFILLER_112_340 VGND VGND VPWR VPWR sky130_fd_sc_hd__decap_3
XFILLER_58_416 VGND VGND VPWR VPWR sky130_fd_sc_hd__decap_3
X_6124_ _8179_/Q _8243_/Q _6123_/X VGND VGND VPWR VPWR _6124_/X sky130_fd_sc_hd__a21o_2
XFILLER_112_395 VGND VGND VPWR VPWR sky130_fd_sc_hd__decap_3
XFILLER_58_427 VGND VGND VPWR VPWR sky130_fd_sc_hd__decap_3
XFILLER_98_585 VGND VGND VPWR VPWR sky130_fd_sc_hd__decap_3
X_6055_ _8290_/Q _6051_/X _6054_/X _5627_/A VGND VGND VPWR VPWR _6055_/X sky130_fd_sc_hd__a22o_2
XFILLER_39_641 VGND VGND VPWR VPWR sky130_fd_sc_hd__decap_3
XFILLER_85_246 VGND VGND VPWR VPWR sky130_fd_sc_hd__fill_1
X_5006_ _8263_/Q _5005_/X _8199_/Q VGND VGND VPWR VPWR _5006_/X sky130_fd_sc_hd__o21ba_2
XFILLER_100_579 VGND VGND VPWR VPWR sky130_fd_sc_hd__decap_3
XFILLER_39_685 VGND VGND VPWR VPWR sky130_fd_sc_hd__decap_3
XFILLER_66_471 VGND VGND VPWR VPWR sky130_fd_sc_hd__decap_3
XFILLER_81_441 VGND VGND VPWR VPWR sky130_fd_sc_hd__decap_3
XFILLER_93_290 VGND VGND VPWR VPWR sky130_fd_sc_hd__fill_2
XFILLER_54_666 VGND VGND VPWR VPWR sky130_fd_sc_hd__fill_1
XFILLER_81_452 VGND VGND VPWR VPWR sky130_fd_sc_hd__fill_2
XFILLER_81_463 VGND VGND VPWR VPWR sky130_fd_sc_hd__decap_3
X_6957_ _8198_/Q _4834_/B _6814_/Y VGND VGND VPWR VPWR _6957_/Y sky130_fd_sc_hd__a21oi_2
XFILLER_53_187 VGND VGND VPWR VPWR sky130_fd_sc_hd__decap_3
XFILLER_81_29 VGND VGND VPWR VPWR sky130_fd_sc_hd__fill_2
X_6888_ _6903_/S _8264_/Q _7551_/B _6886_/Y _6887_/X VGND VGND VPWR VPWR _6888_/X
+ sky130_fd_sc_hd__o32a_2
X_5908_ _8290_/Q _5904_/Y _5907_/X _5812_/A VGND VGND VPWR VPWR _5908_/Y sky130_fd_sc_hd__a22oi_2
XTAP_TAPCELL_ROW_24_569 VGND VPWR sky130_fd_sc_hd__tapvpwrvgnd_1
XFILLER_22_574 VGND VGND VPWR VPWR sky130_fd_sc_hd__decap_3
X_5839_ _8235_/Q _5804_/B _5897_/A VGND VGND VPWR VPWR _5839_/X sky130_fd_sc_hd__a21bo_2
XTAP_TAPCELL_ROW_62_1066 VGND VPWR sky130_fd_sc_hd__tapvpwrvgnd_1
XFILLER_6_718 VGND VGND VPWR VPWR sky130_fd_sc_hd__decap_3
Xrebuffer311 _7308_/A VGND VGND VPWR VPWR _7307_/B sky130_fd_sc_hd__buf_2
XFILLER_108_635 VGND VGND VPWR VPWR sky130_fd_sc_hd__decap_3
X_7509_ _7476_/C _7476_/B _5319_/A _5615_/A _8218_/Q _8219_/Q VGND VGND VPWR VPWR
+ _7509_/X sky130_fd_sc_hd__mux4_2
XFILLER_107_134 VGND VGND VPWR VPWR sky130_fd_sc_hd__decap_3
XFILLER_108_657 VGND VGND VPWR VPWR sky130_fd_sc_hd__decap_3
XFILLER_5_239 VGND VGND VPWR VPWR sky130_fd_sc_hd__decap_3
XFILLER_107_178 VGND VGND VPWR VPWR sky130_fd_sc_hd__decap_3
XFILLER_30_66 VGND VGND VPWR VPWR sky130_fd_sc_hd__fill_1
XFILLER_30_88 VGND VGND VPWR VPWR sky130_fd_sc_hd__decap_3
XFILLER_89_530 VGND VGND VPWR VPWR sky130_fd_sc_hd__fill_2
XFILLER_103_340 VGND VGND VPWR VPWR sky130_fd_sc_hd__decap_3
XFILLER_39_20 VGND VGND VPWR VPWR sky130_fd_sc_hd__decap_3
XFILLER_39_53 VGND VGND VPWR VPWR sky130_fd_sc_hd__decap_3
XFILLER_49_438 VGND VGND VPWR VPWR sky130_fd_sc_hd__decap_3
XFILLER_49_449 VGND VGND VPWR VPWR sky130_fd_sc_hd__decap_3
XFILLER_76_224 VGND VGND VPWR VPWR sky130_fd_sc_hd__decap_3
XFILLER_64_408 VGND VGND VPWR VPWR sky130_fd_sc_hd__decap_3
XFILLER_92_706 VGND VGND VPWR VPWR sky130_fd_sc_hd__decap_3
XFILLER_17_313 VGND VGND VPWR VPWR sky130_fd_sc_hd__decap_3
XFILLER_45_622 VGND VGND VPWR VPWR sky130_fd_sc_hd__decap_3
XFILLER_91_205 VGND VGND VPWR VPWR sky130_fd_sc_hd__decap_3
XFILLER_17_335 VGND VGND VPWR VPWR sky130_fd_sc_hd__fill_1
XFILLER_17_346 VGND VGND VPWR VPWR sky130_fd_sc_hd__decap_3
XFILLER_44_121 VGND VGND VPWR VPWR sky130_fd_sc_hd__decap_3
XFILLER_17_368 VGND VGND VPWR VPWR sky130_fd_sc_hd__decap_3
XFILLER_45_666 VGND VGND VPWR VPWR sky130_fd_sc_hd__fill_1
XFILLER_72_452 VGND VGND VPWR VPWR sky130_fd_sc_hd__decap_3
XFILLER_44_187 VGND VGND VPWR VPWR sky130_fd_sc_hd__decap_3
XTAP_TAPCELL_ROW_43_823 VGND VPWR sky130_fd_sc_hd__tapvpwrvgnd_1
XTAP_TAPCELL_ROW_43_812 VGND VPWR sky130_fd_sc_hd__tapvpwrvgnd_1
XFILLER_71_40 VGND VGND VPWR VPWR sky130_fd_sc_hd__decap_3
XFILLER_71_84 VGND VGND VPWR VPWR sky130_fd_sc_hd__decap_3
XFILLER_9_589 VGND VGND VPWR VPWR sky130_fd_sc_hd__decap_3
XFILLER_58_6 VGND VGND VPWR VPWR sky130_fd_sc_hd__decap_3
XFILLER_95_500 VGND VGND VPWR VPWR sky130_fd_sc_hd__decap_3
X_4170_ _7930_/B _7955_/Q VGND VGND VPWR VPWR _4171_/A sky130_fd_sc_hd__and2_2
XFILLER_67_213 VGND VGND VPWR VPWR sky130_fd_sc_hd__decap_3
XFILLER_95_511 VGND VGND VPWR VPWR sky130_fd_sc_hd__decap_3
XFILLER_67_246 VGND VGND VPWR VPWR sky130_fd_sc_hd__decap_3
XFILLER_83_706 VGND VGND VPWR VPWR sky130_fd_sc_hd__decap_3
XFILLER_55_408 VGND VGND VPWR VPWR sky130_fd_sc_hd__decap_3
XFILLER_95_599 VGND VGND VPWR VPWR sky130_fd_sc_hd__decap_3
XFILLER_75_290 VGND VGND VPWR VPWR sky130_fd_sc_hd__decap_3
XFILLER_82_227 VGND VGND VPWR VPWR sky130_fd_sc_hd__decap_3
X_7860_ _8300_/Q _7930_/B VGND VGND VPWR VPWR _7861_/A sky130_fd_sc_hd__and2_2
XFILLER_23_305 VGND VGND VPWR VPWR sky130_fd_sc_hd__decap_3
XFILLER_51_614 VGND VGND VPWR VPWR sky130_fd_sc_hd__fill_2
X_6811_ _8261_/Q _6811_/B VGND VGND VPWR VPWR _6811_/X sky130_fd_sc_hd__and2_2
XFILLER_35_187 VGND VGND VPWR VPWR sky130_fd_sc_hd__fill_1
X_7791_ _8195_/Q _7660_/X _7664_/X VGND VGND VPWR VPWR _7791_/Y sky130_fd_sc_hd__o21ai_2
XFILLER_23_349 VGND VGND VPWR VPWR sky130_fd_sc_hd__fill_1
X_6742_ _6741_/X _6676_/X _6616_/X _6530_/X _7812_/A _7670_/A VGND VGND VPWR VPWR
+ _6742_/X sky130_fd_sc_hd__mux4_2
XFILLER_31_360 VGND VGND VPWR VPWR sky130_fd_sc_hd__decap_3
XFILLER_50_168 VGND VGND VPWR VPWR sky130_fd_sc_hd__decap_3
X_6673_ _8257_/Q _6636_/B _8193_/Q VGND VGND VPWR VPWR _6673_/X sky130_fd_sc_hd__a21bo_4
XTAP_TAPCELL_ROW_21_528 VGND VPWR sky130_fd_sc_hd__tapvpwrvgnd_1
XFILLER_31_382 VGND VGND VPWR VPWR sky130_fd_sc_hd__decap_3
XFILLER_31_393 VGND VGND VPWR VPWR sky130_fd_sc_hd__fill_1
X_5624_ _8167_/Q _8231_/Q VGND VGND VPWR VPWR _5624_/X sky130_fd_sc_hd__and2_2
X_8343_ _8353_/CLK _8343_/D VGND VGND VPWR VPWR _8343_/Q sky130_fd_sc_hd__dfxtp_2
X_5555_ _5433_/A _5548_/Y _5554_/X _5245_/Y VGND VGND VPWR VPWR _5556_/C sky130_fd_sc_hd__a22o_2
X_8274_ _8349_/CLK _8274_/D VGND VGND VPWR VPWR _8274_/Q sky130_fd_sc_hd__dfxtp_2
X_5486_ _7670_/A _5486_/B VGND VGND VPWR VPWR _5486_/X sky130_fd_sc_hd__and2b_2
X_4506_ _7898_/B _8057_/Q VGND VGND VPWR VPWR _4507_/A sky130_fd_sc_hd__and2_2
XFILLER_105_638 VGND VGND VPWR VPWR sky130_fd_sc_hd__decap_3
XTAP_TAPCELL_ROW_113_1730 VGND VPWR sky130_fd_sc_hd__tapvpwrvgnd_1
X_7225_ _7225_/A _7225_/B VGND VGND VPWR VPWR _7226_/B sky130_fd_sc_hd__nor2_2
X_4437_ _4437_/A VGND VGND VPWR VPWR _8156_/D sky130_fd_sc_hd__buf_1
X_7156_ _7156_/A _7156_/B VGND VGND VPWR VPWR _7163_/A sky130_fd_sc_hd__nor2_2
XFILLER_113_682 VGND VGND VPWR VPWR sky130_fd_sc_hd__decap_3
XFILLER_76_18 VGND VGND VPWR VPWR sky130_fd_sc_hd__decap_3
XFILLER_76_29 VGND VGND VPWR VPWR sky130_fd_sc_hd__decap_3
XFILLER_86_533 VGND VGND VPWR VPWR sky130_fd_sc_hd__decap_3
XFILLER_98_371 VGND VGND VPWR VPWR sky130_fd_sc_hd__fill_1
XFILLER_98_393 VGND VGND VPWR VPWR sky130_fd_sc_hd__decap_3
X_6107_ _5270_/X _6106_/X _6062_/Y _5350_/A VGND VGND VPWR VPWR _6107_/X sky130_fd_sc_hd__o2bb2a_2
X_4368_ _7930_/B _4368_/B VGND VGND VPWR VPWR _4369_/A sky130_fd_sc_hd__and2_2
XFILLER_112_192 VGND VGND VPWR VPWR sky130_fd_sc_hd__decap_3
XFILLER_86_566 VGND VGND VPWR VPWR sky130_fd_sc_hd__decap_3
X_7087_ _8268_/Q _7085_/X _7086_/X VGND VGND VPWR VPWR _7087_/Y sky130_fd_sc_hd__o21ai_2
X_4299_ _4299_/A VGND VGND VPWR VPWR _8087_/D sky130_fd_sc_hd__buf_1
XFILLER_100_365 VGND VGND VPWR VPWR sky130_fd_sc_hd__decap_3
XFILLER_46_408 VGND VGND VPWR VPWR sky130_fd_sc_hd__decap_3
XFILLER_58_268 VGND VGND VPWR VPWR sky130_fd_sc_hd__decap_3
XFILLER_73_216 VGND VGND VPWR VPWR sky130_fd_sc_hd__decap_3
X_6038_ _5966_/X _6003_/X _6004_/Y _6037_/X _7898_/B VGND VGND VPWR VPWR _8310_/D
+ sky130_fd_sc_hd__o311a_2
XFILLER_100_398 VGND VGND VPWR VPWR sky130_fd_sc_hd__decap_3
XFILLER_27_644 VGND VGND VPWR VPWR sky130_fd_sc_hd__decap_3
XTAP_TAPCELL_ROW_29_639 VGND VPWR sky130_fd_sc_hd__tapvpwrvgnd_1
XFILLER_54_452 VGND VGND VPWR VPWR sky130_fd_sc_hd__decap_3
XTAP_TAPCELL_ROW_1_275 VGND VPWR sky130_fd_sc_hd__tapvpwrvgnd_1
XFILLER_14_305 VGND VGND VPWR VPWR sky130_fd_sc_hd__decap_3
XFILLER_26_165 VGND VGND VPWR VPWR sky130_fd_sc_hd__decap_3
XFILLER_41_113 VGND VGND VPWR VPWR sky130_fd_sc_hd__fill_1
X_7989_ _8396_/CLK _7989_/D VGND VGND VPWR VPWR _7989_/Q sky130_fd_sc_hd__dfxtp_2
XFILLER_14_349 VGND VGND VPWR VPWR sky130_fd_sc_hd__decap_3
XFILLER_25_88 VGND VGND VPWR VPWR sky130_fd_sc_hd__fill_2
XFILLER_41_135 VGND VGND VPWR VPWR sky130_fd_sc_hd__decap_3
XFILLER_22_371 VGND VGND VPWR VPWR sky130_fd_sc_hd__decap_3
XFILLER_10_522 VGND VGND VPWR VPWR sky130_fd_sc_hd__decap_3
XFILLER_10_533 VGND VGND VPWR VPWR sky130_fd_sc_hd__fill_2
XFILLER_50_691 VGND VGND VPWR VPWR sky130_fd_sc_hd__decap_3
XFILLER_6_504 VGND VGND VPWR VPWR sky130_fd_sc_hd__decap_3
XFILLER_108_443 VGND VGND VPWR VPWR sky130_fd_sc_hd__decap_3
XFILLER_10_599 VGND VGND VPWR VPWR sky130_fd_sc_hd__decap_3
XFILLER_41_87 VGND VGND VPWR VPWR sky130_fd_sc_hd__decap_3
XTAP_TAPCELL_ROW_75_1235 VGND VPWR sky130_fd_sc_hd__tapvpwrvgnd_1
XFILLER_2_710 VGND VGND VPWR VPWR sky130_fd_sc_hd__decap_3
XFILLER_104_660 VGND VGND VPWR VPWR sky130_fd_sc_hd__decap_3
XFILLER_1_242 VGND VGND VPWR VPWR sky130_fd_sc_hd__fill_2
XFILLER_96_319 VGND VGND VPWR VPWR sky130_fd_sc_hd__decap_3
XTAP_TAPCELL_ROW_9_375 VGND VPWR sky130_fd_sc_hd__tapvpwrvgnd_1
XFILLER_110_107 VGND VGND VPWR VPWR sky130_fd_sc_hd__decap_3
XFILLER_49_202 VGND VGND VPWR VPWR sky130_fd_sc_hd__decap_3
XFILLER_49_213 VGND VGND VPWR VPWR sky130_fd_sc_hd__decap_3
XFILLER_77_522 VGND VGND VPWR VPWR sky130_fd_sc_hd__decap_3
XFILLER_103_181 VGND VGND VPWR VPWR sky130_fd_sc_hd__decap_3
XFILLER_2_37 VGND VGND VPWR VPWR sky130_fd_sc_hd__fill_2
XFILLER_2_59 VGND VGND VPWR VPWR sky130_fd_sc_hd__decap_3
XFILLER_49_257 VGND VGND VPWR VPWR sky130_fd_sc_hd__fill_1
XFILLER_89_393 VGND VGND VPWR VPWR sky130_fd_sc_hd__fill_1
XFILLER_106_91 VGND VGND VPWR VPWR sky130_fd_sc_hd__fill_2
XFILLER_37_408 VGND VGND VPWR VPWR sky130_fd_sc_hd__decap_3
XFILLER_49_268 VGND VGND VPWR VPWR sky130_fd_sc_hd__decap_3
XFILLER_66_40 VGND VGND VPWR VPWR sky130_fd_sc_hd__decap_3
XFILLER_77_577 VGND VGND VPWR VPWR sky130_fd_sc_hd__decap_3
Xclone837 _6507_/S VGND VGND VPWR VPWR _6421_/S sky130_fd_sc_hd__clkbuf_16
XFILLER_18_622 VGND VGND VPWR VPWR sky130_fd_sc_hd__decap_3
XFILLER_57_290 VGND VGND VPWR VPWR sky130_fd_sc_hd__decap_3
XFILLER_66_73 VGND VGND VPWR VPWR sky130_fd_sc_hd__decap_3
XFILLER_17_154 VGND VGND VPWR VPWR sky130_fd_sc_hd__decap_3
XFILLER_33_603 VGND VGND VPWR VPWR sky130_fd_sc_hd__decap_3
XFILLER_45_441 VGND VGND VPWR VPWR sky130_fd_sc_hd__decap_3
XFILLER_45_452 VGND VGND VPWR VPWR sky130_fd_sc_hd__decap_3
XFILLER_18_699 VGND VGND VPWR VPWR sky130_fd_sc_hd__fill_1
XFILLER_33_614 VGND VGND VPWR VPWR sky130_fd_sc_hd__fill_2
XFILLER_60_400 VGND VGND VPWR VPWR sky130_fd_sc_hd__decap_3
XFILLER_72_271 VGND VGND VPWR VPWR sky130_fd_sc_hd__decap_3
XTAP_TAPCELL_ROW_86_1375 VGND VPWR sky130_fd_sc_hd__tapvpwrvgnd_1
XTAP_TAPCELL_ROW_56_992 VGND VPWR sky130_fd_sc_hd__tapvpwrvgnd_1
XTAP_TAPCELL_ROW_56_981 VGND VPWR sky130_fd_sc_hd__tapvpwrvgnd_1
XFILLER_33_647 VGND VGND VPWR VPWR sky130_fd_sc_hd__decap_3
XFILLER_60_477 VGND VGND VPWR VPWR sky130_fd_sc_hd__decap_3
XFILLER_60_499 VGND VGND VPWR VPWR sky130_fd_sc_hd__decap_3
XFILLER_82_94 VGND VGND VPWR VPWR sky130_fd_sc_hd__decap_3
XFILLER_119_719 VGND VGND VPWR VPWR sky130_fd_sc_hd__decap_3
XFILLER_13_382 VGND VGND VPWR VPWR sky130_fd_sc_hd__fill_2
XFILLER_9_320 VGND VGND VPWR VPWR sky130_fd_sc_hd__decap_3
XFILLER_9_331 VGND VGND VPWR VPWR sky130_fd_sc_hd__decap_3
XFILLER_9_342 VGND VGND VPWR VPWR sky130_fd_sc_hd__decap_3
X_5340_ _6767_/A _6686_/A VGND VGND VPWR VPWR _5341_/A sky130_fd_sc_hd__nor2_2
XFILLER_114_413 VGND VGND VPWR VPWR sky130_fd_sc_hd__decap_3
XFILLER_5_592 VGND VGND VPWR VPWR sky130_fd_sc_hd__fill_1
XFILLER_99_113 VGND VGND VPWR VPWR sky130_fd_sc_hd__decap_3
Xoutput149 _7977_/Q VGND VGND VPWR VPWR result[19] sky130_fd_sc_hd__clkdlybuf4s25_1
Xoutput138 _8024_/Q VGND VGND VPWR VPWR overflow_flag sky130_fd_sc_hd__clkdlybuf4s25_1
X_5271_ _5250_/X _5255_/X _5262_/X _5267_/X _5270_/X _6648_/A VGND VGND VPWR VPWR
+ _5271_/X sky130_fd_sc_hd__mux4_2
XFILLER_99_146 VGND VGND VPWR VPWR sky130_fd_sc_hd__decap_3
X_7010_ _8173_/Q _7010_/B _7010_/C _7068_/D VGND VGND VPWR VPWR _7010_/X sky130_fd_sc_hd__and4_2
X_4222_ _7898_/B _4222_/B VGND VGND VPWR VPWR _4223_/A sky130_fd_sc_hd__and2_2
XFILLER_101_107 VGND VGND VPWR VPWR sky130_fd_sc_hd__decap_3
XFILLER_68_566 VGND VGND VPWR VPWR sky130_fd_sc_hd__decap_3
X_4153_ _4153_/A VGND VGND VPWR VPWR _8014_/D sky130_fd_sc_hd__buf_1
XFILLER_83_514 VGND VGND VPWR VPWR sky130_fd_sc_hd__decap_3
XFILLER_95_352 VGND VGND VPWR VPWR sky130_fd_sc_hd__decap_3
XFILLER_95_385 VGND VGND VPWR VPWR sky130_fd_sc_hd__decap_3
X_4084_ _7898_/B _8383_/Q VGND VGND VPWR VPWR _4085_/A sky130_fd_sc_hd__and2_2
XFILLER_55_238 VGND VGND VPWR VPWR sky130_fd_sc_hd__fill_2
XFILLER_95_396 VGND VGND VPWR VPWR sky130_fd_sc_hd__decap_3
X_7912_ _8326_/Q _7930_/B VGND VGND VPWR VPWR _7913_/A sky130_fd_sc_hd__and2_2
XFILLER_36_430 VGND VGND VPWR VPWR sky130_fd_sc_hd__decap_3
XFILLER_36_463 VGND VGND VPWR VPWR sky130_fd_sc_hd__decap_3
XFILLER_102_38 VGND VGND VPWR VPWR sky130_fd_sc_hd__decap_3
XFILLER_23_113 VGND VGND VPWR VPWR sky130_fd_sc_hd__decap_3
XFILLER_51_411 VGND VGND VPWR VPWR sky130_fd_sc_hd__decap_3
X_7843_ _7843_/A _7843_/B _7843_/C _7844_/D VGND VGND VPWR VPWR _7843_/X sky130_fd_sc_hd__and4_2
X_7774_ _7812_/A _8173_/Q _7812_/C VGND VGND VPWR VPWR _7774_/X sky130_fd_sc_hd__and3_2
X_4986_ _8217_/Q _8281_/Q VGND VGND VPWR VPWR _4986_/X sky130_fd_sc_hd__or2b_2
XFILLER_11_308 VGND VGND VPWR VPWR sky130_fd_sc_hd__decap_3
XFILLER_51_488 VGND VGND VPWR VPWR sky130_fd_sc_hd__decap_3
X_6725_ _8192_/Q _8256_/Q _8258_/Q _6725_/D VGND VGND VPWR VPWR _6726_/C sky130_fd_sc_hd__or4_2
XTAP_TAPCELL_ROW_34_697 VGND VPWR sky130_fd_sc_hd__tapvpwrvgnd_1
X_6656_ _6656_/A _6711_/C VGND VGND VPWR VPWR _6656_/Y sky130_fd_sc_hd__nor2_2
X_6587_ _8290_/Q _6584_/X _6586_/X _5627_/A VGND VGND VPWR VPWR _6587_/X sky130_fd_sc_hd__a22o_2
X_5607_ _6353_/B _5606_/X _5576_/X VGND VGND VPWR VPWR _5607_/Y sky130_fd_sc_hd__a21oi_2
XFILLER_117_251 VGND VGND VPWR VPWR sky130_fd_sc_hd__decap_3
XFILLER_11_57 VGND VGND VPWR VPWR sky130_fd_sc_hd__decap_3
X_8326_ _8392_/CLK _8326_/D VGND VGND VPWR VPWR _8326_/Q sky130_fd_sc_hd__dfxtp_2
X_5538_ _5626_/A _5531_/X _5533_/Y _5299_/X _5537_/Y VGND VGND VPWR VPWR _5556_/A
+ sky130_fd_sc_hd__a221o_2
X_8257_ _8396_/CLK _8257_/D VGND VGND VPWR VPWR _8257_/Q sky130_fd_sc_hd__dfxtp_2
XFILLER_105_468 VGND VGND VPWR VPWR sky130_fd_sc_hd__decap_3
XFILLER_87_39 VGND VGND VPWR VPWR sky130_fd_sc_hd__decap_3
X_7208_ _7213_/A _7208_/B VGND VGND VPWR VPWR _7209_/B sky130_fd_sc_hd__xnor2_2
X_5469_ _7193_/A _5469_/B VGND VGND VPWR VPWR _5475_/A sky130_fd_sc_hd__and2_2
XFILLER_59_511 VGND VGND VPWR VPWR sky130_fd_sc_hd__decap_3
X_8188_ clkload4/A _8188_/D VGND VGND VPWR VPWR _8188_/Q sky130_fd_sc_hd__dfxtp_2
XTAP_TAPCELL_ROW_6_334 VGND VPWR sky130_fd_sc_hd__tapvpwrvgnd_1
XFILLER_113_490 VGND VGND VPWR VPWR sky130_fd_sc_hd__decap_3
XFILLER_86_341 VGND VGND VPWR VPWR sky130_fd_sc_hd__decap_3
XFILLER_98_190 VGND VGND VPWR VPWR sky130_fd_sc_hd__decap_3
X_7139_ _7619_/A _7137_/X _7138_/Y _5332_/A VGND VGND VPWR VPWR _7139_/X sky130_fd_sc_hd__a22o_2
XTAP_TAPCELL_ROW_70_1165 VGND VPWR sky130_fd_sc_hd__tapvpwrvgnd_1
XFILLER_86_374 VGND VGND VPWR VPWR sky130_fd_sc_hd__decap_3
XFILLER_100_173 VGND VGND VPWR VPWR sky130_fd_sc_hd__decap_3
XFILLER_46_227 VGND VGND VPWR VPWR sky130_fd_sc_hd__decap_3
XFILLER_27_430 VGND VGND VPWR VPWR sky130_fd_sc_hd__fill_2
XFILLER_27_441 VGND VGND VPWR VPWR sky130_fd_sc_hd__decap_3
XFILLER_27_452 VGND VGND VPWR VPWR sky130_fd_sc_hd__decap_3
XFILLER_39_290 VGND VGND VPWR VPWR sky130_fd_sc_hd__decap_3
XFILLER_15_625 VGND VGND VPWR VPWR sky130_fd_sc_hd__decap_3
XFILLER_42_400 VGND VGND VPWR VPWR sky130_fd_sc_hd__decap_3
XFILLER_54_271 VGND VGND VPWR VPWR sky130_fd_sc_hd__decap_3
XFILLER_61_219 VGND VGND VPWR VPWR sky130_fd_sc_hd__decap_3
XFILLER_14_135 VGND VGND VPWR VPWR sky130_fd_sc_hd__decap_3
XFILLER_15_669 VGND VGND VPWR VPWR sky130_fd_sc_hd__decap_3
XFILLER_42_433 VGND VGND VPWR VPWR sky130_fd_sc_hd__decap_3
XTAP_TAPCELL_ROW_53_951 VGND VPWR sky130_fd_sc_hd__tapvpwrvgnd_1
XFILLER_14_168 VGND VGND VPWR VPWR sky130_fd_sc_hd__fill_1
XFILLER_30_606 VGND VGND VPWR VPWR sky130_fd_sc_hd__fill_2
XFILLER_42_477 VGND VGND VPWR VPWR sky130_fd_sc_hd__decap_3
XFILLER_52_20 VGND VGND VPWR VPWR sky130_fd_sc_hd__decap_3
XFILLER_52_42 VGND VGND VPWR VPWR sky130_fd_sc_hd__decap_3
XFILLER_23_691 VGND VGND VPWR VPWR sky130_fd_sc_hd__decap_3
XFILLER_52_64 VGND VGND VPWR VPWR sky130_fd_sc_hd__fill_2
XFILLER_10_330 VGND VGND VPWR VPWR sky130_fd_sc_hd__decap_3
XFILLER_22_190 VGND VGND VPWR VPWR sky130_fd_sc_hd__decap_3
XFILLER_52_97 VGND VGND VPWR VPWR sky130_fd_sc_hd__decap_3
Xinput18 operand_a[20] VGND VGND VPWR VPWR _4216_/B sky130_fd_sc_hd__clkdlybuf4s25_1
XFILLER_10_385 VGND VGND VPWR VPWR sky130_fd_sc_hd__decap_3
XFILLER_6_312 VGND VGND VPWR VPWR sky130_fd_sc_hd__decap_3
Xinput29 operand_a[30] VGND VGND VPWR VPWR _4236_/B sky130_fd_sc_hd__clkdlybuf4s25_1
XFILLER_108_251 VGND VGND VPWR VPWR sky130_fd_sc_hd__fill_1
XFILLER_108_262 VGND VGND VPWR VPWR sky130_fd_sc_hd__decap_3
XFILLER_10_396 VGND VGND VPWR VPWR sky130_fd_sc_hd__decap_3
XFILLER_6_356 VGND VGND VPWR VPWR sky130_fd_sc_hd__decap_3
XFILLER_69_308 VGND VGND VPWR VPWR sky130_fd_sc_hd__decap_3
XFILLER_97_617 VGND VGND VPWR VPWR sky130_fd_sc_hd__decap_3
XFILLER_77_50 VGND VGND VPWR VPWR sky130_fd_sc_hd__decap_3
XFILLER_77_72 VGND VGND VPWR VPWR sky130_fd_sc_hd__decap_3
XFILLER_89_190 VGND VGND VPWR VPWR sky130_fd_sc_hd__decap_3
XFILLER_65_514 VGND VGND VPWR VPWR sky130_fd_sc_hd__decap_3
XTAP_TAPCELL_ROW_88_1404 VGND VPWR sky130_fd_sc_hd__tapvpwrvgnd_1
XFILLER_37_216 VGND VGND VPWR VPWR sky130_fd_sc_hd__decap_3
XFILLER_92_322 VGND VGND VPWR VPWR sky130_fd_sc_hd__decap_3
XFILLER_65_558 VGND VGND VPWR VPWR sky130_fd_sc_hd__fill_2
XFILLER_18_485 VGND VGND VPWR VPWR sky130_fd_sc_hd__decap_3
XFILLER_33_411 VGND VGND VPWR VPWR sky130_fd_sc_hd__decap_3
XFILLER_92_377 VGND VGND VPWR VPWR sky130_fd_sc_hd__decap_3
XFILLER_93_93 VGND VGND VPWR VPWR sky130_fd_sc_hd__decap_3
XFILLER_33_444 VGND VGND VPWR VPWR sky130_fd_sc_hd__decap_3
XFILLER_33_455 VGND VGND VPWR VPWR sky130_fd_sc_hd__decap_3
XFILLER_45_293 VGND VGND VPWR VPWR sky130_fd_sc_hd__decap_3
XFILLER_60_230 VGND VGND VPWR VPWR sky130_fd_sc_hd__decap_3
X_4840_ _8256_/Q _8192_/Q VGND VGND VPWR VPWR _4842_/A sky130_fd_sc_hd__and2b_2
XFILLER_33_488 VGND VGND VPWR VPWR sky130_fd_sc_hd__decap_3
XFILLER_60_274 VGND VGND VPWR VPWR sky130_fd_sc_hd__decap_3
XFILLER_14_691 VGND VGND VPWR VPWR sky130_fd_sc_hd__decap_3
XFILLER_20_138 VGND VGND VPWR VPWR sky130_fd_sc_hd__fill_2
X_6510_ _5552_/X _5521_/X _5520_/X _5515_/B _6620_/A _6421_/S VGND VGND VPWR VPWR
+ _6510_/X sky130_fd_sc_hd__mux4_2
X_4771_ _8214_/Q _8278_/Q VGND VGND VPWR VPWR _7398_/D sky130_fd_sc_hd__xor2_2
XFILLER_119_505 VGND VGND VPWR VPWR sky130_fd_sc_hd__decap_3
XFILLER_13_190 VGND VGND VPWR VPWR sky130_fd_sc_hd__fill_2
X_7490_ _7486_/Y _7490_/B _7490_/C _7490_/D VGND VGND VPWR VPWR _7573_/B sky130_fd_sc_hd__and4b_2
XTAP_TAPCELL_ROW_99_1544 VGND VPWR sky130_fd_sc_hd__tapvpwrvgnd_1
XTAP_TAPCELL_ROW_31_667 VGND VPWR sky130_fd_sc_hd__tapvpwrvgnd_1
XTAP_TAPCELL_ROW_31_656 VGND VPWR sky130_fd_sc_hd__tapvpwrvgnd_1
XFILLER_9_172 VGND VGND VPWR VPWR sky130_fd_sc_hd__decap_3
X_6441_ _6440_/Y _8186_/Q VGND VGND VPWR VPWR _6441_/X sky130_fd_sc_hd__and2b_2
X_6372_ _5587_/X _6370_/X _6371_/X _5108_/X VGND VGND VPWR VPWR _6372_/X sky130_fd_sc_hd__a22o_2
X_8111_ _8382_/CLK _8111_/D VGND VGND VPWR VPWR _8111_/Q sky130_fd_sc_hd__dfxtp_2
X_5323_ _8290_/Q _6769_/B VGND VGND VPWR VPWR _5323_/Y sky130_fd_sc_hd__nor2_2
XFILLER_114_243 VGND VGND VPWR VPWR sky130_fd_sc_hd__decap_3
XFILLER_102_416 VGND VGND VPWR VPWR sky130_fd_sc_hd__decap_3
XFILLER_102_427 VGND VGND VPWR VPWR sky130_fd_sc_hd__decap_3
XFILLER_114_265 VGND VGND VPWR VPWR sky130_fd_sc_hd__decap_3
XFILLER_87_116 VGND VGND VPWR VPWR sky130_fd_sc_hd__decap_3
XFILLER_88_628 VGND VGND VPWR VPWR sky130_fd_sc_hd__decap_3
X_8042_ clkload9/A _8042_/D VGND VGND VPWR VPWR _8042_/Q sky130_fd_sc_hd__dfxtp_2
X_5254_ _7809_/A1 _6095_/A _7805_/A VGND VGND VPWR VPWR _5254_/X sky130_fd_sc_hd__mux2_2
XFILLER_68_330 VGND VGND VPWR VPWR sky130_fd_sc_hd__fill_2
X_5185_ _6008_/A _5159_/X _5174_/X _5179_/X _6784_/A _5464_/A VGND VGND VPWR VPWR
+ _5186_/B sky130_fd_sc_hd__mux4_2
X_4205_ _4205_/A VGND VGND VPWR VPWR _8040_/D sky130_fd_sc_hd__buf_1
XFILLER_56_514 VGND VGND VPWR VPWR sky130_fd_sc_hd__fill_1
XFILLER_83_300 VGND VGND VPWR VPWR sky130_fd_sc_hd__decap_3
X_4136_ _7930_/B _7938_/Q VGND VGND VPWR VPWR _4137_/A sky130_fd_sc_hd__and2_2
XTAP_TAPCELL_ROW_3_304 VGND VPWR sky130_fd_sc_hd__tapvpwrvgnd_1
XFILLER_113_15 VGND VGND VPWR VPWR sky130_fd_sc_hd__decap_3
XFILLER_28_216 VGND VGND VPWR VPWR sky130_fd_sc_hd__decap_3
XFILLER_56_536 VGND VGND VPWR VPWR sky130_fd_sc_hd__decap_3
XFILLER_83_333 VGND VGND VPWR VPWR sky130_fd_sc_hd__decap_3
XFILLER_95_160 VGND VGND VPWR VPWR sky130_fd_sc_hd__decap_3
XFILLER_96_694 VGND VGND VPWR VPWR sky130_fd_sc_hd__decap_3
XFILLER_28_249 VGND VGND VPWR VPWR sky130_fd_sc_hd__decap_3
XFILLER_56_558 VGND VGND VPWR VPWR sky130_fd_sc_hd__fill_2
X_4067_ _4067_/A VGND VGND VPWR VPWR _7971_/D sky130_fd_sc_hd__buf_1
XTAP_TAPCELL_ROW_39_767 VGND VPWR sky130_fd_sc_hd__tapvpwrvgnd_1
XFILLER_43_219 VGND VGND VPWR VPWR sky130_fd_sc_hd__decap_3
XFILLER_64_580 VGND VGND VPWR VPWR sky130_fd_sc_hd__fill_1
XFILLER_71_517 VGND VGND VPWR VPWR sky130_fd_sc_hd__decap_3
XFILLER_83_388 VGND VGND VPWR VPWR sky130_fd_sc_hd__decap_3
XTAP_TAPCELL_ROW_108_1662 VGND VPWR sky130_fd_sc_hd__tapvpwrvgnd_1
XFILLER_36_293 VGND VGND VPWR VPWR sky130_fd_sc_hd__fill_1
X_7826_ _7827_/B _7827_/C _7827_/A VGND VGND VPWR VPWR _7828_/A sky130_fd_sc_hd__a21oi_2
XFILLER_12_617 VGND VGND VPWR VPWR sky130_fd_sc_hd__decap_3
XFILLER_51_263 VGND VGND VPWR VPWR sky130_fd_sc_hd__decap_3
XTAP_TAPCELL_ROW_50_910 VGND VPWR sky130_fd_sc_hd__tapvpwrvgnd_1
XFILLER_51_296 VGND VGND VPWR VPWR sky130_fd_sc_hd__decap_3
X_7757_ _7653_/X _8200_/Q _7655_/X _7755_/X _7756_/X VGND VGND VPWR VPWR _7757_/X
+ sky130_fd_sc_hd__a311o_2
X_4969_ _4969_/A _5194_/A _5194_/B _4969_/D VGND VGND VPWR VPWR _4970_/C sky130_fd_sc_hd__or4_2
XFILLER_20_661 VGND VGND VPWR VPWR sky130_fd_sc_hd__decap_3
X_7688_ _7776_/A _8190_/Q _5121_/A _7670_/A VGND VGND VPWR VPWR _7688_/Y sky130_fd_sc_hd__a211oi_2
X_6708_ _6708_/A _6708_/B VGND VGND VPWR VPWR _6708_/X sky130_fd_sc_hd__or2_2
X_6639_ _8288_/Q _4845_/B _4998_/A VGND VGND VPWR VPWR _6639_/Y sky130_fd_sc_hd__o21ai_2
XTAP_TAPCELL_ROW_59_1027 VGND VPWR sky130_fd_sc_hd__tapvpwrvgnd_1
XFILLER_105_243 VGND VGND VPWR VPWR sky130_fd_sc_hd__decap_3
XFILLER_3_337 VGND VGND VPWR VPWR sky130_fd_sc_hd__decap_3
X_8309_ _8379_/CLK _8309_/D VGND VGND VPWR VPWR _8309_/Q sky130_fd_sc_hd__dfxtp_2
XFILLER_105_287 VGND VGND VPWR VPWR sky130_fd_sc_hd__decap_3
XFILLER_79_617 VGND VGND VPWR VPWR sky130_fd_sc_hd__decap_3
XFILLER_79_628 VGND VGND VPWR VPWR sky130_fd_sc_hd__fill_2
XPHY_EDGE_ROW_110_Right_110 VGND VGND VPWR VPWR sky130_fd_sc_hd__decap_3
XFILLER_101_460 VGND VGND VPWR VPWR sky130_fd_sc_hd__decap_3
XFILLER_59_352 VGND VGND VPWR VPWR sky130_fd_sc_hd__decap_3
XFILLER_93_119 VGND VGND VPWR VPWR sky130_fd_sc_hd__decap_3
XFILLER_59_385 VGND VGND VPWR VPWR sky130_fd_sc_hd__decap_3
XFILLER_59_396 VGND VGND VPWR VPWR sky130_fd_sc_hd__decap_3
XFILLER_74_300 VGND VGND VPWR VPWR sky130_fd_sc_hd__decap_3
XFILLER_74_333 VGND VGND VPWR VPWR sky130_fd_sc_hd__decap_3
XFILLER_86_171 VGND VGND VPWR VPWR sky130_fd_sc_hd__decap_3
XFILLER_47_558 VGND VGND VPWR VPWR sky130_fd_sc_hd__fill_2
XFILLER_47_75 VGND VGND VPWR VPWR sky130_fd_sc_hd__decap_3
XFILLER_62_506 VGND VGND VPWR VPWR sky130_fd_sc_hd__decap_3
XFILLER_15_400 VGND VGND VPWR VPWR sky130_fd_sc_hd__decap_3
XFILLER_27_260 VGND VGND VPWR VPWR sky130_fd_sc_hd__decap_3
XFILLER_62_528 VGND VGND VPWR VPWR sky130_fd_sc_hd__decap_3
XFILLER_74_377 VGND VGND VPWR VPWR sky130_fd_sc_hd__decap_3
XFILLER_15_422 VGND VGND VPWR VPWR sky130_fd_sc_hd__decap_3
XFILLER_27_293 VGND VGND VPWR VPWR sky130_fd_sc_hd__decap_3
XFILLER_42_230 VGND VGND VPWR VPWR sky130_fd_sc_hd__decap_3
XTAP_TAPCELL_ROW_83_1334 VGND VPWR sky130_fd_sc_hd__tapvpwrvgnd_1
XFILLER_15_466 VGND VGND VPWR VPWR sky130_fd_sc_hd__decap_3
XFILLER_63_52 VGND VGND VPWR VPWR sky130_fd_sc_hd__decap_3
XFILLER_63_63 VGND VGND VPWR VPWR sky130_fd_sc_hd__decap_3
XFILLER_70_550 VGND VGND VPWR VPWR sky130_fd_sc_hd__fill_2
XFILLER_15_488 VGND VGND VPWR VPWR sky130_fd_sc_hd__decap_3
XFILLER_30_414 VGND VGND VPWR VPWR sky130_fd_sc_hd__decap_3
XFILLER_42_285 VGND VGND VPWR VPWR sky130_fd_sc_hd__decap_3
XFILLER_70_583 VGND VGND VPWR VPWR sky130_fd_sc_hd__decap_3
XFILLER_11_661 VGND VGND VPWR VPWR sky130_fd_sc_hd__decap_3
XFILLER_11_694 VGND VGND VPWR VPWR sky130_fd_sc_hd__fill_2
XFILLER_7_643 VGND VGND VPWR VPWR sky130_fd_sc_hd__fill_1
XFILLER_10_193 VGND VGND VPWR VPWR sky130_fd_sc_hd__decap_3
XFILLER_116_508 VGND VGND VPWR VPWR sky130_fd_sc_hd__fill_2
XFILLER_116_519 VGND VGND VPWR VPWR sky130_fd_sc_hd__decap_3
XFILLER_7_665 VGND VGND VPWR VPWR sky130_fd_sc_hd__decap_3
XFILLER_7_676 VGND VGND VPWR VPWR sky130_fd_sc_hd__fill_1
XFILLER_6_164 VGND VGND VPWR VPWR sky130_fd_sc_hd__fill_2
XFILLER_6_186 VGND VGND VPWR VPWR sky130_fd_sc_hd__decap_3
XFILLER_6_197 VGND VGND VPWR VPWR sky130_fd_sc_hd__decap_3
XFILLER_69_116 VGND VGND VPWR VPWR sky130_fd_sc_hd__decap_3
XFILLER_88_60 VGND VGND VPWR VPWR sky130_fd_sc_hd__decap_3
XFILLER_97_403 VGND VGND VPWR VPWR sky130_fd_sc_hd__decap_3
XTAP_TAPCELL_ROW_94_1485 VGND VPWR sky130_fd_sc_hd__tapvpwrvgnd_1
XFILLER_111_246 VGND VGND VPWR VPWR sky130_fd_sc_hd__fill_2
XFILLER_85_609 VGND VGND VPWR VPWR sky130_fd_sc_hd__decap_3
XFILLER_97_447 VGND VGND VPWR VPWR sky130_fd_sc_hd__fill_1
XFILLER_97_458 VGND VGND VPWR VPWR sky130_fd_sc_hd__decap_3
XFILLER_111_268 VGND VGND VPWR VPWR sky130_fd_sc_hd__decap_3
XFILLER_84_108 VGND VGND VPWR VPWR sky130_fd_sc_hd__fill_2
XFILLER_84_119 VGND VGND VPWR VPWR sky130_fd_sc_hd__decap_3
XFILLER_65_311 VGND VGND VPWR VPWR sky130_fd_sc_hd__decap_3
XFILLER_78_694 VGND VGND VPWR VPWR sky130_fd_sc_hd__decap_3
XFILLER_65_355 VGND VGND VPWR VPWR sky130_fd_sc_hd__decap_3
XFILLER_93_642 VGND VGND VPWR VPWR sky130_fd_sc_hd__fill_1
XFILLER_93_653 VGND VGND VPWR VPWR sky130_fd_sc_hd__decap_3
X_6990_ _7005_/B _6989_/Y _6334_/A VGND VGND VPWR VPWR _6990_/Y sky130_fd_sc_hd__a21oi_4
XFILLER_53_517 VGND VGND VPWR VPWR sky130_fd_sc_hd__decap_3
XFILLER_65_388 VGND VGND VPWR VPWR sky130_fd_sc_hd__decap_3
XFILLER_65_399 VGND VGND VPWR VPWR sky130_fd_sc_hd__decap_3
XFILLER_80_325 VGND VGND VPWR VPWR sky130_fd_sc_hd__decap_3
XFILLER_92_185 VGND VGND VPWR VPWR sky130_fd_sc_hd__fill_2
X_5941_ _8173_/Q _5941_/B VGND VGND VPWR VPWR _6022_/C sky130_fd_sc_hd__or2_2
XTAP_TAPCELL_ROW_36_726 VGND VPWR sky130_fd_sc_hd__tapvpwrvgnd_1
XFILLER_18_271 VGND VGND VPWR VPWR sky130_fd_sc_hd__decap_3
XFILLER_33_241 VGND VGND VPWR VPWR sky130_fd_sc_hd__decap_3
XFILLER_33_263 VGND VGND VPWR VPWR sky130_fd_sc_hd__decap_3
XFILLER_61_561 VGND VGND VPWR VPWR sky130_fd_sc_hd__decap_3
X_5872_ _8235_/Q _5873_/B _5022_/A VGND VGND VPWR VPWR _5872_/X sky130_fd_sc_hd__a21o_2
XFILLER_21_425 VGND VGND VPWR VPWR sky130_fd_sc_hd__decap_3
XFILLER_33_274 VGND VGND VPWR VPWR sky130_fd_sc_hd__decap_3
XFILLER_61_583 VGND VGND VPWR VPWR sky130_fd_sc_hd__decap_3
XTAP_TAPCELL_ROW_16_461 VGND VPWR sky130_fd_sc_hd__tapvpwrvgnd_1
X_7611_ _8223_/Q _7231_/A _7608_/X _7610_/Y _5951_/A VGND VGND VPWR VPWR _7611_/X
+ sky130_fd_sc_hd__o311a_4
X_4823_ _6956_/B _4823_/B VGND VGND VPWR VPWR _7167_/B sky130_fd_sc_hd__or2_2
XTAP_TAPCELL_ROW_16_472 VGND VPWR sky130_fd_sc_hd__tapvpwrvgnd_1
XTAP_TAPCELL_ROW_103_1592 VGND VPWR sky130_fd_sc_hd__tapvpwrvgnd_1
X_7542_ _8284_/Q _7517_/B _8220_/Q VGND VGND VPWR VPWR _7542_/X sky130_fd_sc_hd__o21a_2
X_4754_ _7843_/B VGND VGND VPWR VPWR _7630_/B sky130_fd_sc_hd__inv_2
XFILLER_119_335 VGND VGND VPWR VPWR sky130_fd_sc_hd__fill_1
X_7473_ _5407_/X _7473_/A2 _7612_/B _6368_/B VGND VGND VPWR VPWR _7473_/X sky130_fd_sc_hd__a22o_4
Xrebuffer729 _5511_/B VGND VGND VPWR VPWR _5506_/B sky130_fd_sc_hd__buf_2
XFILLER_107_508 VGND VGND VPWR VPWR sky130_fd_sc_hd__fill_2
XFILLER_107_519 VGND VGND VPWR VPWR sky130_fd_sc_hd__decap_3
XFILLER_119_368 VGND VGND VPWR VPWR sky130_fd_sc_hd__decap_3
XFILLER_119_379 VGND VGND VPWR VPWR sky130_fd_sc_hd__decap_3
X_4685_ _4685_/A VGND VGND VPWR VPWR _8280_/D sky130_fd_sc_hd__buf_1
X_6424_ _5393_/X _5453_/X _5450_/X _5445_/X _6620_/A _6648_/A VGND VGND VPWR VPWR
+ _6424_/X sky130_fd_sc_hd__mux4_2
X_6355_ _6355_/A _6355_/B VGND VGND VPWR VPWR _6355_/X sky130_fd_sc_hd__or2_2
X_6286_ _6286_/A VGND VGND VPWR VPWR _6307_/A sky130_fd_sc_hd__inv_2
X_5306_ _6686_/A _5285_/X _5289_/X _5433_/A _5305_/X VGND VGND VPWR VPWR _5306_/X
+ sky130_fd_sc_hd__a221o_2
XFILLER_0_329 VGND VGND VPWR VPWR sky130_fd_sc_hd__fill_2
XFILLER_102_224 VGND VGND VPWR VPWR sky130_fd_sc_hd__decap_3
XFILLER_88_458 VGND VGND VPWR VPWR sky130_fd_sc_hd__fill_2
X_8025_ clkload8/A _8025_/D VGND VGND VPWR VPWR _8025_/Q sky130_fd_sc_hd__dfxtp_2
X_5237_ _7825_/A _5237_/B VGND VGND VPWR VPWR _5237_/Y sky130_fd_sc_hd__nor2_2
XFILLER_88_469 VGND VGND VPWR VPWR sky130_fd_sc_hd__decap_3
XFILLER_29_514 VGND VGND VPWR VPWR sky130_fd_sc_hd__decap_3
XFILLER_68_171 VGND VGND VPWR VPWR sky130_fd_sc_hd__fill_2
XFILLER_68_182 VGND VGND VPWR VPWR sky130_fd_sc_hd__decap_3
XFILLER_84_29 VGND VGND VPWR VPWR sky130_fd_sc_hd__decap_3
XFILLER_96_480 VGND VGND VPWR VPWR sky130_fd_sc_hd__decap_3
X_5168_ _8184_/Q _8185_/Q _5484_/S VGND VGND VPWR VPWR _5168_/X sky130_fd_sc_hd__mux2_2
XFILLER_29_547 VGND VGND VPWR VPWR sky130_fd_sc_hd__decap_3
XFILLER_29_558 VGND VGND VPWR VPWR sky130_fd_sc_hd__fill_2
XFILLER_56_333 VGND VGND VPWR VPWR sky130_fd_sc_hd__decap_3
X_5099_ _6620_/A VGND VGND VPWR VPWR _5100_/A sky130_fd_sc_hd__inv_2
X_4119_ _4119_/A VGND VGND VPWR VPWR _7997_/D sky130_fd_sc_hd__buf_1
XFILLER_17_45 VGND VGND VPWR VPWR sky130_fd_sc_hd__decap_3
XFILLER_56_377 VGND VGND VPWR VPWR sky130_fd_sc_hd__decap_3
XFILLER_84_675 VGND VGND VPWR VPWR sky130_fd_sc_hd__decap_3
XFILLER_37_580 VGND VGND VPWR VPWR sky130_fd_sc_hd__decap_3
XFILLER_71_358 VGND VGND VPWR VPWR sky130_fd_sc_hd__decap_3
XFILLER_83_185 VGND VGND VPWR VPWR sky130_fd_sc_hd__fill_2
XFILLER_83_196 VGND VGND VPWR VPWR sky130_fd_sc_hd__decap_3
XFILLER_24_230 VGND VGND VPWR VPWR sky130_fd_sc_hd__decap_3
XFILLER_40_701 VGND VGND VPWR VPWR sky130_fd_sc_hd__decap_3
XFILLER_12_436 VGND VGND VPWR VPWR sky130_fd_sc_hd__decap_3
X_7809_ _7809_/A1 _7672_/A _7681_/X VGND VGND VPWR VPWR _7809_/Y sky130_fd_sc_hd__o21ai_2
XFILLER_12_469 VGND VGND VPWR VPWR sky130_fd_sc_hd__decap_3
XFILLER_8_418 VGND VGND VPWR VPWR sky130_fd_sc_hd__fill_2
XFILLER_4_635 VGND VGND VPWR VPWR sky130_fd_sc_hd__decap_3
XFILLER_4_657 VGND VGND VPWR VPWR sky130_fd_sc_hd__decap_3
XFILLER_106_563 VGND VGND VPWR VPWR sky130_fd_sc_hd__decap_3
XFILLER_3_178 VGND VGND VPWR VPWR sky130_fd_sc_hd__fill_1
XFILLER_79_425 VGND VGND VPWR VPWR sky130_fd_sc_hd__decap_3
XFILLER_106_596 VGND VGND VPWR VPWR sky130_fd_sc_hd__fill_2
XFILLER_79_447 VGND VGND VPWR VPWR sky130_fd_sc_hd__fill_1
XFILLER_58_74 VGND VGND VPWR VPWR sky130_fd_sc_hd__decap_3
XFILLER_58_85 VGND VGND VPWR VPWR sky130_fd_sc_hd__decap_3
XFILLER_59_160 VGND VGND VPWR VPWR sky130_fd_sc_hd__decap_3
XFILLER_94_439 VGND VGND VPWR VPWR sky130_fd_sc_hd__decap_3
XFILLER_47_333 VGND VGND VPWR VPWR sky130_fd_sc_hd__decap_3
XFILLER_74_141 VGND VGND VPWR VPWR sky130_fd_sc_hd__decap_3
XFILLER_75_642 VGND VGND VPWR VPWR sky130_fd_sc_hd__decap_3
XFILLER_35_539 VGND VGND VPWR VPWR sky130_fd_sc_hd__decap_3
XFILLER_47_366 VGND VGND VPWR VPWR sky130_fd_sc_hd__fill_2
XFILLER_90_601 VGND VGND VPWR VPWR sky130_fd_sc_hd__decap_3
XFILLER_47_399 VGND VGND VPWR VPWR sky130_fd_sc_hd__decap_3
XFILLER_62_336 VGND VGND VPWR VPWR sky130_fd_sc_hd__decap_3
XFILLER_62_347 VGND VGND VPWR VPWR sky130_fd_sc_hd__decap_3
XFILLER_74_95 VGND VGND VPWR VPWR sky130_fd_sc_hd__decap_3
XFILLER_90_645 VGND VGND VPWR VPWR sky130_fd_sc_hd__decap_3
XFILLER_15_252 VGND VGND VPWR VPWR sky130_fd_sc_hd__decap_3
XFILLER_43_561 VGND VGND VPWR VPWR sky130_fd_sc_hd__decap_3
XFILLER_30_200 VGND VGND VPWR VPWR sky130_fd_sc_hd__decap_3
XFILLER_90_50 VGND VGND VPWR VPWR sky130_fd_sc_hd__decap_3
XTAP_TAPCELL_ROW_13_431 VGND VPWR sky130_fd_sc_hd__tapvpwrvgnd_1
XFILLER_30_288 VGND VGND VPWR VPWR sky130_fd_sc_hd__decap_3
XTAP_TAPCELL_ROW_96_1503 VGND VPWR sky130_fd_sc_hd__tapvpwrvgnd_1
XTAP_TAPCELL_ROW_41_795 VGND VPWR sky130_fd_sc_hd__tapvpwrvgnd_1
XFILLER_7_462 VGND VGND VPWR VPWR sky130_fd_sc_hd__fill_2
XFILLER_7_484 VGND VGND VPWR VPWR sky130_fd_sc_hd__decap_3
X_4470_ _7898_/B _8039_/Q VGND VGND VPWR VPWR _4471_/A sky130_fd_sc_hd__and2_2
XFILLER_99_92 VGND VGND VPWR VPWR sky130_fd_sc_hd__decap_3
X_6140_ _6140_/A _6140_/B VGND VGND VPWR VPWR _6140_/Y sky130_fd_sc_hd__nand2_2
XFILLER_97_277 VGND VGND VPWR VPWR sky130_fd_sc_hd__decap_3
X_6071_ _6321_/B _5740_/A _5220_/Y _6355_/B VGND VGND VPWR VPWR _6072_/B sky130_fd_sc_hd__a211o_2
XFILLER_57_119 VGND VGND VPWR VPWR sky130_fd_sc_hd__decap_3
XFILLER_66_620 VGND VGND VPWR VPWR sky130_fd_sc_hd__decap_3
XFILLER_85_428 VGND VGND VPWR VPWR sky130_fd_sc_hd__decap_3
X_5022_ _5022_/A _8235_/Q VGND VGND VPWR VPWR _5884_/B sky130_fd_sc_hd__nor2b_2
XFILLER_66_653 VGND VGND VPWR VPWR sky130_fd_sc_hd__decap_3
XFILLER_26_517 VGND VGND VPWR VPWR sky130_fd_sc_hd__decap_3
XFILLER_38_377 VGND VGND VPWR VPWR sky130_fd_sc_hd__decap_3
XFILLER_53_303 VGND VGND VPWR VPWR sky130_fd_sc_hd__fill_2
XFILLER_65_152 VGND VGND VPWR VPWR sky130_fd_sc_hd__decap_3
XFILLER_66_686 VGND VGND VPWR VPWR sky130_fd_sc_hd__decap_3
XFILLER_80_100 VGND VGND VPWR VPWR sky130_fd_sc_hd__fill_2
XFILLER_93_461 VGND VGND VPWR VPWR sky130_fd_sc_hd__decap_3
XFILLER_26_539 VGND VGND VPWR VPWR sky130_fd_sc_hd__fill_1
XFILLER_65_196 VGND VGND VPWR VPWR sky130_fd_sc_hd__decap_3
XFILLER_93_494 VGND VGND VPWR VPWR sky130_fd_sc_hd__fill_1
XTAP_TAPCELL_ROW_105_1621 VGND VPWR sky130_fd_sc_hd__tapvpwrvgnd_1
X_6973_ _6971_/X _6972_/X _7076_/A VGND VGND VPWR VPWR _6973_/X sky130_fd_sc_hd__mux2_2
XTAP_TAPCELL_ROW_49_895 VGND VPWR sky130_fd_sc_hd__tapvpwrvgnd_1
XFILLER_22_701 VGND VGND VPWR VPWR sky130_fd_sc_hd__fill_2
XFILLER_53_369 VGND VGND VPWR VPWR sky130_fd_sc_hd__decap_3
XFILLER_80_144 VGND VGND VPWR VPWR sky130_fd_sc_hd__fill_1
X_5924_ _6076_/A _5924_/B VGND VGND VPWR VPWR _8307_/D sky130_fd_sc_hd__nor2_2
XFILLER_110_49 VGND VGND VPWR VPWR sky130_fd_sc_hd__decap_3
XFILLER_21_200 VGND VGND VPWR VPWR sky130_fd_sc_hd__decap_3
XFILLER_34_583 VGND VGND VPWR VPWR sky130_fd_sc_hd__decap_3
X_5855_ _5142_/X _6172_/A _5855_/S VGND VGND VPWR VPWR _5855_/X sky130_fd_sc_hd__mux2_2
XFILLER_21_255 VGND VGND VPWR VPWR sky130_fd_sc_hd__fill_1
XFILLER_61_391 VGND VGND VPWR VPWR sky130_fd_sc_hd__fill_1
X_4806_ _4806_/A _4806_/B VGND VGND VPWR VPWR _7166_/D sky130_fd_sc_hd__nand2_2
X_5786_ _5832_/A _5783_/X _5785_/Y _6623_/A VGND VGND VPWR VPWR _5786_/X sky130_fd_sc_hd__o211a_2
XFILLER_21_299 VGND VGND VPWR VPWR sky130_fd_sc_hd__decap_3
X_7525_ _7619_/A _7523_/X _7524_/Y _5332_/X VGND VGND VPWR VPWR _7525_/X sky130_fd_sc_hd__a22o_2
X_4737_ _4737_/A _4736_/Y VGND VGND VPWR VPWR _7497_/A sky130_fd_sc_hd__nor2b_2
XFILLER_107_327 VGND VGND VPWR VPWR sky130_fd_sc_hd__decap_3
XFILLER_119_47 VGND VGND VPWR VPWR sky130_fd_sc_hd__decap_3
X_7456_ _7930_/B _7456_/B VGND VGND VPWR VPWR _7457_/A sky130_fd_sc_hd__and2_4
X_4668_ _7930_/B _8138_/Q VGND VGND VPWR VPWR _4669_/A sky130_fd_sc_hd__and2_2
XTAP_TAPCELL_ROW_116_1761 VGND VPWR sky130_fd_sc_hd__tapvpwrvgnd_1
X_6407_ _8184_/Q _8248_/Q _8249_/Q _8185_/Q VGND VGND VPWR VPWR _6599_/A sky130_fd_sc_hd__a22o_2
XFILLER_103_500 VGND VGND VPWR VPWR sky130_fd_sc_hd__decap_3
XFILLER_89_701 VGND VGND VPWR VPWR sky130_fd_sc_hd__decap_3
XTAP_TAPCELL_ROW_116_1772 VGND VPWR sky130_fd_sc_hd__tapvpwrvgnd_1
X_7387_ _8215_/Q _7385_/X _7386_/X VGND VGND VPWR VPWR _7396_/A sky130_fd_sc_hd__o21ba_2
X_4599_ _4599_/A VGND VGND VPWR VPWR _8237_/D sky130_fd_sc_hd__buf_1
XFILLER_103_511 VGND VGND VPWR VPWR sky130_fd_sc_hd__decap_3
XFILLER_115_393 VGND VGND VPWR VPWR sky130_fd_sc_hd__decap_3
X_6338_ _8185_/Q _6338_/B VGND VGND VPWR VPWR _6338_/Y sky130_fd_sc_hd__nand2_2
XFILLER_0_137 VGND VGND VPWR VPWR sky130_fd_sc_hd__decap_3
XFILLER_103_555 VGND VGND VPWR VPWR sky130_fd_sc_hd__decap_3
XFILLER_95_39 VGND VGND VPWR VPWR sky130_fd_sc_hd__decap_3
X_6269_ _7745_/B _6269_/B VGND VGND VPWR VPWR _6269_/X sky130_fd_sc_hd__or2_2
XFILLER_29_311 VGND VGND VPWR VPWR sky130_fd_sc_hd__decap_3
XFILLER_57_620 VGND VGND VPWR VPWR sky130_fd_sc_hd__decap_3
XFILLER_88_299 VGND VGND VPWR VPWR sky130_fd_sc_hd__decap_3
X_8008_ _8388_/CLK _8008_/D VGND VGND VPWR VPWR _8008_/Q sky130_fd_sc_hd__dfxtp_2
XFILLER_28_44 VGND VGND VPWR VPWR sky130_fd_sc_hd__decap_3
XFILLER_29_322 VGND VGND VPWR VPWR sky130_fd_sc_hd__decap_3
XFILLER_57_642 VGND VGND VPWR VPWR sky130_fd_sc_hd__decap_3
XFILLER_69_491 VGND VGND VPWR VPWR sky130_fd_sc_hd__decap_3
XFILLER_28_88 VGND VGND VPWR VPWR sky130_fd_sc_hd__decap_3
XFILLER_56_141 VGND VGND VPWR VPWR sky130_fd_sc_hd__decap_3
XFILLER_84_472 VGND VGND VPWR VPWR sky130_fd_sc_hd__decap_3
XFILLER_29_399 VGND VGND VPWR VPWR sky130_fd_sc_hd__decap_3
XFILLER_72_656 VGND VGND VPWR VPWR sky130_fd_sc_hd__decap_3
XFILLER_84_494 VGND VGND VPWR VPWR sky130_fd_sc_hd__fill_1
XTAP_TAPCELL_ROW_67_1126 VGND VPWR sky130_fd_sc_hd__tapvpwrvgnd_1
XFILLER_25_561 VGND VGND VPWR VPWR sky130_fd_sc_hd__decap_3
XFILLER_32_509 VGND VGND VPWR VPWR sky130_fd_sc_hd__decap_3
XFILLER_44_43 VGND VGND VPWR VPWR sky130_fd_sc_hd__decap_3
XFILLER_71_155 VGND VGND VPWR VPWR sky130_fd_sc_hd__decap_3
XFILLER_44_76 VGND VGND VPWR VPWR sky130_fd_sc_hd__decap_3
XFILLER_52_380 VGND VGND VPWR VPWR sky130_fd_sc_hd__decap_3
XTAP_TAPCELL_ROW_80_1304 VGND VPWR sky130_fd_sc_hd__tapvpwrvgnd_1
XFILLER_12_233 VGND VGND VPWR VPWR sky130_fd_sc_hd__decap_3
XFILLER_40_542 VGND VGND VPWR VPWR sky130_fd_sc_hd__decap_3
XFILLER_40_553 VGND VGND VPWR VPWR sky130_fd_sc_hd__decap_3
XFILLER_9_705 VGND VGND VPWR VPWR sky130_fd_sc_hd__decap_3
XFILLER_100_60 VGND VGND VPWR VPWR sky130_fd_sc_hd__fill_2
XFILLER_40_575 VGND VGND VPWR VPWR sky130_fd_sc_hd__decap_3
XFILLER_8_215 VGND VGND VPWR VPWR sky130_fd_sc_hd__decap_3
XFILLER_8_237 VGND VGND VPWR VPWR sky130_fd_sc_hd__decap_3
XFILLER_8_259 VGND VGND VPWR VPWR sky130_fd_sc_hd__decap_3
XFILLER_60_97 VGND VGND VPWR VPWR sky130_fd_sc_hd__decap_3
XFILLER_4_410 VGND VGND VPWR VPWR sky130_fd_sc_hd__decap_3
XFILLER_4_421 VGND VGND VPWR VPWR sky130_fd_sc_hd__decap_3
XTAP_TAPCELL_ROW_78_1277 VGND VPWR sky130_fd_sc_hd__tapvpwrvgnd_1
XFILLER_106_371 VGND VGND VPWR VPWR sky130_fd_sc_hd__decap_3
XFILLER_79_211 VGND VGND VPWR VPWR sky130_fd_sc_hd__decap_3
XTAP_TAPCELL_ROW_91_1444 VGND VPWR sky130_fd_sc_hd__tapvpwrvgnd_1
XFILLER_69_95 VGND VGND VPWR VPWR sky130_fd_sc_hd__decap_3
XFILLER_39_108 VGND VGND VPWR VPWR sky130_fd_sc_hd__decap_3
XFILLER_67_417 VGND VGND VPWR VPWR sky130_fd_sc_hd__fill_1
XFILLER_79_299 VGND VGND VPWR VPWR sky130_fd_sc_hd__decap_3
XFILLER_94_203 VGND VGND VPWR VPWR sky130_fd_sc_hd__fill_2
XFILLER_48_642 VGND VGND VPWR VPWR sky130_fd_sc_hd__fill_2
XFILLER_94_247 VGND VGND VPWR VPWR sky130_fd_sc_hd__decap_3
XPHY_EDGE_ROW_13_Right_13 VGND VGND VPWR VPWR sky130_fd_sc_hd__decap_3
XFILLER_47_163 VGND VGND VPWR VPWR sky130_fd_sc_hd__fill_2
XFILLER_48_675 VGND VGND VPWR VPWR sky130_fd_sc_hd__decap_3
XFILLER_63_601 VGND VGND VPWR VPWR sky130_fd_sc_hd__decap_3
XFILLER_75_461 VGND VGND VPWR VPWR sky130_fd_sc_hd__decap_3
XFILLER_85_72 VGND VGND VPWR VPWR sky130_fd_sc_hd__decap_3
XFILLER_62_100 VGND VGND VPWR VPWR sky130_fd_sc_hd__decap_3
XFILLER_62_133 VGND VGND VPWR VPWR sky130_fd_sc_hd__decap_3
XFILLER_63_656 VGND VGND VPWR VPWR sky130_fd_sc_hd__decap_3
XFILLER_35_358 VGND VGND VPWR VPWR sky130_fd_sc_hd__decap_3
XFILLER_62_144 VGND VGND VPWR VPWR sky130_fd_sc_hd__decap_3
XFILLER_90_442 VGND VGND VPWR VPWR sky130_fd_sc_hd__decap_3
XFILLER_90_475 VGND VGND VPWR VPWR sky130_fd_sc_hd__fill_1
X_3970_ _8338_/Q _7930_/B VGND VGND VPWR VPWR _3971_/A sky130_fd_sc_hd__and2_2
XTAP_TAPCELL_ROW_46_854 VGND VPWR sky130_fd_sc_hd__tapvpwrvgnd_1
XFILLER_16_572 VGND VGND VPWR VPWR sky130_fd_sc_hd__fill_2
XFILLER_50_339 VGND VGND VPWR VPWR sky130_fd_sc_hd__decap_3
XFILLER_62_188 VGND VGND VPWR VPWR sky130_fd_sc_hd__decap_3
XFILLER_90_486 VGND VGND VPWR VPWR sky130_fd_sc_hd__decap_3
XFILLER_31_542 VGND VGND VPWR VPWR sky130_fd_sc_hd__decap_3
XFILLER_31_564 VGND VGND VPWR VPWR sky130_fd_sc_hd__fill_1
XFILLER_31_575 VGND VGND VPWR VPWR sky130_fd_sc_hd__decap_3
XTAP_TAPCELL_ROW_100_1562 VGND VPWR sky130_fd_sc_hd__tapvpwrvgnd_1
X_5640_ _7193_/A _5639_/X _5186_/A VGND VGND VPWR VPWR _5640_/Y sky130_fd_sc_hd__o21ai_2
XPHY_EDGE_ROW_22_Right_22 VGND VGND VPWR VPWR sky130_fd_sc_hd__decap_3
X_5571_ _5567_/X _5568_/X _5569_/X _5570_/X _6819_/A _7745_/A VGND VGND VPWR VPWR
+ _5572_/B sky130_fd_sc_hd__mux4_2
XFILLER_117_614 VGND VGND VPWR VPWR sky130_fd_sc_hd__fill_2
X_8290_ _8359_/CLK _8290_/D VGND VGND VPWR VPWR _8290_/Q sky130_fd_sc_hd__dfxtp_4
X_7310_ _7289_/A _7289_/B _4764_/B VGND VGND VPWR VPWR _7312_/A sky130_fd_sc_hd__a21o_2
X_4522_ _7898_/B _8065_/Q VGND VGND VPWR VPWR _4523_/A sky130_fd_sc_hd__and2_2
XFILLER_117_647 VGND VGND VPWR VPWR sky130_fd_sc_hd__decap_3
XFILLER_7_281 VGND VGND VPWR VPWR sky130_fd_sc_hd__fill_2
X_7241_ _6677_/X _7240_/X _6381_/X _6950_/X _5182_/A _7745_/A VGND VGND VPWR VPWR
+ _7241_/X sky130_fd_sc_hd__mux4_2
X_4453_ _4453_/A VGND VGND VPWR VPWR _8164_/D sky130_fd_sc_hd__buf_1
XFILLER_116_168 VGND VGND VPWR VPWR sky130_fd_sc_hd__decap_3
X_7172_ _8271_/Q _7172_/B VGND VGND VPWR VPWR _7172_/X sky130_fd_sc_hd__or2_2
X_4384_ _7930_/B _4384_/B VGND VGND VPWR VPWR _4385_/A sky130_fd_sc_hd__and2_2
XFILLER_112_352 VGND VGND VPWR VPWR sky130_fd_sc_hd__decap_3
XFILLER_98_553 VGND VGND VPWR VPWR sky130_fd_sc_hd__fill_1
X_6123_ _8179_/Q _8243_/Q _6999_/A1 VGND VGND VPWR VPWR _6123_/X sky130_fd_sc_hd__o21a_2
XFILLER_100_525 VGND VGND VPWR VPWR sky130_fd_sc_hd__fill_1
XFILLER_112_374 VGND VGND VPWR VPWR sky130_fd_sc_hd__decap_3
XFILLER_39_620 VGND VGND VPWR VPWR sky130_fd_sc_hd__decap_3
XFILLER_58_439 VGND VGND VPWR VPWR sky130_fd_sc_hd__decap_3
XFILLER_85_203 VGND VGND VPWR VPWR sky130_fd_sc_hd__decap_3
XFILLER_85_225 VGND VGND VPWR VPWR sky130_fd_sc_hd__decap_3
XPHY_EDGE_ROW_31_Right_31 VGND VGND VPWR VPWR sky130_fd_sc_hd__decap_3
X_6054_ _6999_/A1 _6052_/X _6053_/X VGND VGND VPWR VPWR _6054_/X sky130_fd_sc_hd__a21o_2
XFILLER_39_653 VGND VGND VPWR VPWR sky130_fd_sc_hd__fill_2
X_5005_ _6956_/C _4828_/A _5004_/Y _7152_/A VGND VGND VPWR VPWR _5005_/X sky130_fd_sc_hd__o31a_2
XFILLER_26_303 VGND VGND VPWR VPWR sky130_fd_sc_hd__decap_3
XFILLER_38_141 VGND VGND VPWR VPWR sky130_fd_sc_hd__decap_3
XFILLER_54_612 VGND VGND VPWR VPWR sky130_fd_sc_hd__decap_3
XFILLER_73_409 VGND VGND VPWR VPWR sky130_fd_sc_hd__decap_3
XFILLER_85_269 VGND VGND VPWR VPWR sky130_fd_sc_hd__fill_2
XFILLER_26_325 VGND VGND VPWR VPWR sky130_fd_sc_hd__decap_3
XFILLER_39_697 VGND VGND VPWR VPWR sky130_fd_sc_hd__decap_3
XFILLER_53_111 VGND VGND VPWR VPWR sky130_fd_sc_hd__fill_1
XFILLER_54_645 VGND VGND VPWR VPWR sky130_fd_sc_hd__decap_3
XFILLER_66_483 VGND VGND VPWR VPWR sky130_fd_sc_hd__decap_3
XFILLER_53_166 VGND VGND VPWR VPWR sky130_fd_sc_hd__fill_2
XFILLER_54_678 VGND VGND VPWR VPWR sky130_fd_sc_hd__decap_3
XFILLER_81_475 VGND VGND VPWR VPWR sky130_fd_sc_hd__decap_3
X_6956_ _6958_/A _6956_/B _6956_/C _6956_/D VGND VGND VPWR VPWR _7154_/B sky130_fd_sc_hd__or4_2
XFILLER_53_199 VGND VGND VPWR VPWR sky130_fd_sc_hd__decap_3
X_5907_ _6999_/A1 _5905_/X _5906_/X VGND VGND VPWR VPWR _5907_/X sky130_fd_sc_hd__a21o_2
XFILLER_14_35 VGND VGND VPWR VPWR sky130_fd_sc_hd__fill_2
XFILLER_22_531 VGND VGND VPWR VPWR sky130_fd_sc_hd__fill_1
XFILLER_22_542 VGND VGND VPWR VPWR sky130_fd_sc_hd__decap_3
XFILLER_34_391 VGND VGND VPWR VPWR sky130_fd_sc_hd__decap_3
X_6887_ _5076_/Y _6767_/Y _6903_/S VGND VGND VPWR VPWR _6887_/X sky130_fd_sc_hd__mux2_2
XPHY_EDGE_ROW_40_Right_40 VGND VGND VPWR VPWR sky130_fd_sc_hd__decap_3
X_5838_ _6076_/A _5838_/B VGND VGND VPWR VPWR _8305_/D sky130_fd_sc_hd__nor2_2
XTAP_TAPCELL_ROW_62_1067 VGND VPWR sky130_fd_sc_hd__tapvpwrvgnd_1
Xrebuffer312 _5535_/C VGND VGND VPWR VPWR _5490_/A sky130_fd_sc_hd__buf_2
X_5769_ _8170_/Q _8234_/Q VGND VGND VPWR VPWR _5769_/X sky130_fd_sc_hd__or2_4
XFILLER_30_12 VGND VGND VPWR VPWR sky130_fd_sc_hd__decap_3
XFILLER_30_23 VGND VGND VPWR VPWR sky130_fd_sc_hd__fill_2
XFILLER_5_218 VGND VGND VPWR VPWR sky130_fd_sc_hd__decap_3
X_7508_ _8219_/Q _7498_/X _7502_/X _7507_/Y VGND VGND VPWR VPWR _7508_/X sky130_fd_sc_hd__a211o_2
Xrebuffer345 _7608_/C VGND VGND VPWR VPWR rebuffer345/X sky130_fd_sc_hd__buf_2
XFILLER_107_113 VGND VGND VPWR VPWR sky130_fd_sc_hd__decap_3
XPHY_EDGE_ROW_15_Left_135 VGND VGND VPWR VPWR sky130_fd_sc_hd__decap_3
XFILLER_107_157 VGND VGND VPWR VPWR sky130_fd_sc_hd__decap_3
X_7439_ _8216_/Q _7439_/B VGND VGND VPWR VPWR _7471_/B sky130_fd_sc_hd__or2_4
XFILLER_116_691 VGND VGND VPWR VPWR sky130_fd_sc_hd__decap_3
XFILLER_39_32 VGND VGND VPWR VPWR sky130_fd_sc_hd__decap_3
XFILLER_89_542 VGND VGND VPWR VPWR sky130_fd_sc_hd__decap_3
XFILLER_89_564 VGND VGND VPWR VPWR sky130_fd_sc_hd__fill_2
XFILLER_89_575 VGND VGND VPWR VPWR sky130_fd_sc_hd__decap_3
XFILLER_103_374 VGND VGND VPWR VPWR sky130_fd_sc_hd__decap_3
XFILLER_49_417 VGND VGND VPWR VPWR sky130_fd_sc_hd__decap_3
XFILLER_76_203 VGND VGND VPWR VPWR sky130_fd_sc_hd__decap_3
XFILLER_89_586 VGND VGND VPWR VPWR sky130_fd_sc_hd__decap_3
XFILLER_103_396 VGND VGND VPWR VPWR sky130_fd_sc_hd__decap_3
XFILLER_57_461 VGND VGND VPWR VPWR sky130_fd_sc_hd__decap_3
XPHY_EDGE_ROW_24_Left_144 VGND VGND VPWR VPWR sky130_fd_sc_hd__decap_3
XFILLER_45_634 VGND VGND VPWR VPWR sky130_fd_sc_hd__decap_3
XFILLER_45_645 VGND VGND VPWR VPWR sky130_fd_sc_hd__decap_3
XFILLER_57_483 VGND VGND VPWR VPWR sky130_fd_sc_hd__decap_3
XFILLER_84_280 VGND VGND VPWR VPWR sky130_fd_sc_hd__decap_3
XFILLER_17_358 VGND VGND VPWR VPWR sky130_fd_sc_hd__decap_3
XFILLER_44_133 VGND VGND VPWR VPWR sky130_fd_sc_hd__decap_3
XFILLER_44_144 VGND VGND VPWR VPWR sky130_fd_sc_hd__fill_1
XFILLER_60_604 VGND VGND VPWR VPWR sky130_fd_sc_hd__decap_3
XFILLER_72_464 VGND VGND VPWR VPWR sky130_fd_sc_hd__decap_3
XFILLER_32_339 VGND VGND VPWR VPWR sky130_fd_sc_hd__decap_3
XFILLER_44_166 VGND VGND VPWR VPWR sky130_fd_sc_hd__decap_3
XFILLER_55_97 VGND VGND VPWR VPWR sky130_fd_sc_hd__decap_3
XFILLER_60_637 VGND VGND VPWR VPWR sky130_fd_sc_hd__decap_3
XFILLER_60_648 VGND VGND VPWR VPWR sky130_fd_sc_hd__decap_3
XFILLER_72_486 VGND VGND VPWR VPWR sky130_fd_sc_hd__decap_3
XTAP_TAPCELL_ROW_43_824 VGND VPWR sky130_fd_sc_hd__tapvpwrvgnd_1
XTAP_TAPCELL_ROW_43_813 VGND VPWR sky130_fd_sc_hd__tapvpwrvgnd_1
XFILLER_13_520 VGND VGND VPWR VPWR sky130_fd_sc_hd__decap_3
XFILLER_25_380 VGND VGND VPWR VPWR sky130_fd_sc_hd__decap_3
XFILLER_25_391 VGND VGND VPWR VPWR sky130_fd_sc_hd__fill_1
XFILLER_13_575 VGND VGND VPWR VPWR sky130_fd_sc_hd__decap_3
XFILLER_40_361 VGND VGND VPWR VPWR sky130_fd_sc_hd__decap_3
XFILLER_71_52 VGND VGND VPWR VPWR sky130_fd_sc_hd__decap_3
XFILLER_71_63 VGND VGND VPWR VPWR sky130_fd_sc_hd__decap_3
XFILLER_9_524 VGND VGND VPWR VPWR sky130_fd_sc_hd__decap_3
XFILLER_40_394 VGND VGND VPWR VPWR sky130_fd_sc_hd__decap_3
XFILLER_71_96 VGND VGND VPWR VPWR sky130_fd_sc_hd__decap_3
XPHY_EDGE_ROW_33_Left_153 VGND VGND VPWR VPWR sky130_fd_sc_hd__decap_3
XFILLER_114_617 VGND VGND VPWR VPWR sky130_fd_sc_hd__fill_1
XFILLER_113_116 VGND VGND VPWR VPWR sky130_fd_sc_hd__decap_3
XFILLER_4_262 VGND VGND VPWR VPWR sky130_fd_sc_hd__decap_3
XFILLER_4_295 VGND VGND VPWR VPWR sky130_fd_sc_hd__decap_3
XFILLER_67_225 VGND VGND VPWR VPWR sky130_fd_sc_hd__decap_3
XFILLER_96_60 VGND VGND VPWR VPWR sky130_fd_sc_hd__decap_3
XFILLER_67_258 VGND VGND VPWR VPWR sky130_fd_sc_hd__decap_3
XFILLER_95_567 VGND VGND VPWR VPWR sky130_fd_sc_hd__decap_3
XPHY_EDGE_ROW_42_Left_162 VGND VGND VPWR VPWR sky130_fd_sc_hd__decap_3
XFILLER_36_601 VGND VGND VPWR VPWR sky130_fd_sc_hd__fill_2
XFILLER_82_206 VGND VGND VPWR VPWR sky130_fd_sc_hd__decap_3
XFILLER_83_729 VGND VGND VPWR VPWR sky130_fd_sc_hd__decap_3
XFILLER_35_100 VGND VGND VPWR VPWR sky130_fd_sc_hd__decap_3
XFILLER_36_645 VGND VGND VPWR VPWR sky130_fd_sc_hd__decap_3
XFILLER_48_483 VGND VGND VPWR VPWR sky130_fd_sc_hd__decap_3
XFILLER_82_239 VGND VGND VPWR VPWR sky130_fd_sc_hd__decap_3
XFILLER_90_250 VGND VGND VPWR VPWR sky130_fd_sc_hd__fill_2
X_6810_ _6874_/C _6810_/B VGND VGND VPWR VPWR _6810_/X sky130_fd_sc_hd__xor2_2
XFILLER_23_317 VGND VGND VPWR VPWR sky130_fd_sc_hd__decap_3
X_7790_ _8195_/Q _7680_/B _7672_/X VGND VGND VPWR VPWR _7790_/Y sky130_fd_sc_hd__o21ai_2
XFILLER_51_648 VGND VGND VPWR VPWR sky130_fd_sc_hd__decap_3
X_6741_ _8196_/Q _8195_/Q _7796_/A VGND VGND VPWR VPWR _6741_/X sky130_fd_sc_hd__mux2_2
X_6672_ _6148_/X _6656_/Y _6670_/X _7182_/B _8194_/Q VGND VGND VPWR VPWR _6672_/X
+ sky130_fd_sc_hd__a221o_2
XPHY_EDGE_ROW_51_Left_171 VGND VGND VPWR VPWR sky130_fd_sc_hd__decap_3
X_5623_ _8167_/Q _8231_/Q VGND VGND VPWR VPWR _5868_/B sky130_fd_sc_hd__or2_2
XTAP_TAPCELL_ROW_21_529 VGND VPWR sky130_fd_sc_hd__tapvpwrvgnd_1
X_8342_ _8353_/CLK _8342_/D VGND VGND VPWR VPWR _8342_/Q sky130_fd_sc_hd__dfxtp_2
X_5554_ _5550_/X _5551_/X _5552_/X _5553_/X _6708_/A _6421_/S VGND VGND VPWR VPWR
+ _5554_/X sky130_fd_sc_hd__mux4_2
XFILLER_117_455 VGND VGND VPWR VPWR sky130_fd_sc_hd__decap_3
X_8273_ _8355_/CLK _8273_/D VGND VGND VPWR VPWR _8273_/Q sky130_fd_sc_hd__dfxtp_2
X_5485_ _5348_/A _5484_/X _7653_/A VGND VGND VPWR VPWR _5486_/B sky130_fd_sc_hd__mux2_2
X_4505_ _4505_/A VGND VGND VPWR VPWR _8190_/D sky130_fd_sc_hd__buf_1
XFILLER_104_127 VGND VGND VPWR VPWR sky130_fd_sc_hd__decap_3
XFILLER_116_15 VGND VGND VPWR VPWR sky130_fd_sc_hd__decap_3
XFILLER_6_91 VGND VGND VPWR VPWR sky130_fd_sc_hd__decap_3
XTAP_TAPCELL_ROW_113_1731 VGND VPWR sky130_fd_sc_hd__tapvpwrvgnd_1
X_7224_ _7220_/X _7221_/X _7222_/X _7223_/X _7163_/A VGND VGND VPWR VPWR _7225_/B
+ sky130_fd_sc_hd__o41a_2
X_4436_ _7843_/A input4/X VGND VGND VPWR VPWR _4437_/A sky130_fd_sc_hd__and2_2
XFILLER_98_350 VGND VGND VPWR VPWR sky130_fd_sc_hd__decap_3
X_7155_ _6801_/X _6811_/X _7152_/X _7154_/X VGND VGND VPWR VPWR _7156_/B sky130_fd_sc_hd__a31o_2
X_4367_ _4367_/A VGND VGND VPWR VPWR _8121_/D sky130_fd_sc_hd__buf_1
XFILLER_112_160 VGND VGND VPWR VPWR sky130_fd_sc_hd__decap_3
XFILLER_86_501 VGND VGND VPWR VPWR sky130_fd_sc_hd__decap_3
XPHY_EDGE_ROW_60_Left_180 VGND VGND VPWR VPWR sky130_fd_sc_hd__decap_3
X_6106_ _6105_/X _5782_/A _6818_/S VGND VGND VPWR VPWR _6106_/X sky130_fd_sc_hd__mux2_2
XFILLER_100_322 VGND VGND VPWR VPWR sky130_fd_sc_hd__decap_3
XFILLER_58_236 VGND VGND VPWR VPWR sky130_fd_sc_hd__decap_3
XFILLER_74_707 VGND VGND VPWR VPWR sky130_fd_sc_hd__decap_3
X_7086_ _8268_/Q _7085_/X _8204_/Q VGND VGND VPWR VPWR _7086_/X sky130_fd_sc_hd__a21o_2
X_4298_ _7843_/A _4298_/B VGND VGND VPWR VPWR _4299_/A sky130_fd_sc_hd__and2_2
XFILLER_27_601 VGND VGND VPWR VPWR sky130_fd_sc_hd__decap_3
XFILLER_39_461 VGND VGND VPWR VPWR sky130_fd_sc_hd__decap_3
XFILLER_86_578 VGND VGND VPWR VPWR sky130_fd_sc_hd__decap_3
XFILLER_86_589 VGND VGND VPWR VPWR sky130_fd_sc_hd__decap_3
X_6037_ _6589_/B2 _6007_/Y _6021_/Y _6029_/X _6036_/X VGND VGND VPWR VPWR _6037_/X
+ sky130_fd_sc_hd__a2111o_2
XFILLER_27_623 VGND VGND VPWR VPWR sky130_fd_sc_hd__decap_3
XFILLER_66_280 VGND VGND VPWR VPWR sky130_fd_sc_hd__decap_3
XFILLER_73_239 VGND VGND VPWR VPWR sky130_fd_sc_hd__decap_3
XFILLER_54_464 VGND VGND VPWR VPWR sky130_fd_sc_hd__decap_3
XFILLER_92_29 VGND VGND VPWR VPWR sky130_fd_sc_hd__decap_3
XTAP_TAPCELL_ROW_1_276 VGND VPWR sky130_fd_sc_hd__tapvpwrvgnd_1
XFILLER_25_23 VGND VGND VPWR VPWR sky130_fd_sc_hd__fill_1
XFILLER_25_45 VGND VGND VPWR VPWR sky130_fd_sc_hd__decap_3
XFILLER_26_177 VGND VGND VPWR VPWR sky130_fd_sc_hd__fill_1
XFILLER_27_689 VGND VGND VPWR VPWR sky130_fd_sc_hd__decap_3
XFILLER_54_486 VGND VGND VPWR VPWR sky130_fd_sc_hd__decap_3
XFILLER_81_261 VGND VGND VPWR VPWR sky130_fd_sc_hd__decap_3
X_7988_ _8396_/CLK _7988_/D VGND VGND VPWR VPWR _7988_/Q sky130_fd_sc_hd__dfxtp_2
XFILLER_25_67 VGND VGND VPWR VPWR sky130_fd_sc_hd__decap_3
XFILLER_41_147 VGND VGND VPWR VPWR sky130_fd_sc_hd__decap_3
XFILLER_42_648 VGND VGND VPWR VPWR sky130_fd_sc_hd__decap_3
X_6939_ _7631_/A _6936_/X _6938_/X VGND VGND VPWR VPWR _6939_/Y sky130_fd_sc_hd__o21ai_2
XFILLER_22_350 VGND VGND VPWR VPWR sky130_fd_sc_hd__decap_3
XFILLER_41_169 VGND VGND VPWR VPWR sky130_fd_sc_hd__decap_3
XFILLER_22_394 VGND VGND VPWR VPWR sky130_fd_sc_hd__decap_3
XFILLER_41_11 VGND VGND VPWR VPWR sky130_fd_sc_hd__decap_3
XFILLER_41_33 VGND VGND VPWR VPWR sky130_fd_sc_hd__decap_3
XFILLER_108_455 VGND VGND VPWR VPWR sky130_fd_sc_hd__decap_3
XFILLER_108_477 VGND VGND VPWR VPWR sky130_fd_sc_hd__decap_3
XFILLER_2_722 VGND VGND VPWR VPWR sky130_fd_sc_hd__decap_3
XTAP_TAPCELL_ROW_75_1236 VGND VPWR sky130_fd_sc_hd__tapvpwrvgnd_1
XTAP_TAPCELL_ROW_9_376 VGND VPWR sky130_fd_sc_hd__tapvpwrvgnd_1
XFILLER_1_276 VGND VGND VPWR VPWR sky130_fd_sc_hd__fill_1
XFILLER_77_501 VGND VGND VPWR VPWR sky130_fd_sc_hd__decap_3
XFILLER_89_383 VGND VGND VPWR VPWR sky130_fd_sc_hd__decap_3
XFILLER_103_193 VGND VGND VPWR VPWR sky130_fd_sc_hd__decap_3
XFILLER_106_81 VGND VGND VPWR VPWR sky130_fd_sc_hd__decap_3
XFILLER_49_236 VGND VGND VPWR VPWR sky130_fd_sc_hd__decap_3
XFILLER_77_556 VGND VGND VPWR VPWR sky130_fd_sc_hd__decap_3
XFILLER_18_601 VGND VGND VPWR VPWR sky130_fd_sc_hd__decap_3
XFILLER_65_707 VGND VGND VPWR VPWR sky130_fd_sc_hd__decap_3
XFILLER_77_589 VGND VGND VPWR VPWR sky130_fd_sc_hd__fill_1
XFILLER_17_111 VGND VGND VPWR VPWR sky130_fd_sc_hd__fill_1
XFILLER_66_85 VGND VGND VPWR VPWR sky130_fd_sc_hd__decap_3
XFILLER_92_548 VGND VGND VPWR VPWR sky130_fd_sc_hd__decap_3
XFILLER_17_122 VGND VGND VPWR VPWR sky130_fd_sc_hd__decap_3
XFILLER_17_133 VGND VGND VPWR VPWR sky130_fd_sc_hd__decap_3
XFILLER_17_166 VGND VGND VPWR VPWR sky130_fd_sc_hd__fill_2
XFILLER_32_103 VGND VGND VPWR VPWR sky130_fd_sc_hd__decap_3
XFILLER_33_637 VGND VGND VPWR VPWR sky130_fd_sc_hd__fill_2
XFILLER_72_250 VGND VGND VPWR VPWR sky130_fd_sc_hd__fill_2
XTAP_TAPCELL_ROW_86_1376 VGND VPWR sky130_fd_sc_hd__tapvpwrvgnd_1
XTAP_TAPCELL_ROW_56_993 VGND VPWR sky130_fd_sc_hd__tapvpwrvgnd_1
XTAP_TAPCELL_ROW_56_982 VGND VPWR sky130_fd_sc_hd__tapvpwrvgnd_1
XFILLER_33_659 VGND VGND VPWR VPWR sky130_fd_sc_hd__decap_3
XFILLER_60_456 VGND VGND VPWR VPWR sky130_fd_sc_hd__decap_3
XFILLER_72_283 VGND VGND VPWR VPWR sky130_fd_sc_hd__fill_1
XFILLER_72_294 VGND VGND VPWR VPWR sky130_fd_sc_hd__decap_3
XFILLER_20_309 VGND VGND VPWR VPWR sky130_fd_sc_hd__decap_3
XFILLER_32_169 VGND VGND VPWR VPWR sky130_fd_sc_hd__fill_1
XFILLER_9_310 VGND VGND VPWR VPWR sky130_fd_sc_hd__decap_3
XFILLER_118_219 VGND VGND VPWR VPWR sky130_fd_sc_hd__decap_3
XFILLER_9_354 VGND VGND VPWR VPWR sky130_fd_sc_hd__decap_3
XFILLER_9_376 VGND VGND VPWR VPWR sky130_fd_sc_hd__decap_3
XFILLER_99_125 VGND VGND VPWR VPWR sky130_fd_sc_hd__decap_3
Xoutput139 _7958_/Q VGND VGND VPWR VPWR result[0] sky130_fd_sc_hd__clkdlybuf4s25_1
X_5270_ _6819_/A VGND VGND VPWR VPWR _5270_/X sky130_fd_sc_hd__clkbuf_1
XFILLER_49_3 VGND VGND VPWR VPWR sky130_fd_sc_hd__fill_1
X_4221_ _4221_/A VGND VGND VPWR VPWR _8048_/D sky130_fd_sc_hd__buf_1
XFILLER_101_119 VGND VGND VPWR VPWR sky130_fd_sc_hd__decap_3
XFILLER_68_501 VGND VGND VPWR VPWR sky130_fd_sc_hd__decap_3
XFILLER_68_523 VGND VGND VPWR VPWR sky130_fd_sc_hd__decap_3
XFILLER_68_545 VGND VGND VPWR VPWR sky130_fd_sc_hd__decap_3
X_4152_ _7930_/B _7946_/Q VGND VGND VPWR VPWR _4153_/A sky130_fd_sc_hd__and2_2
XFILLER_56_707 VGND VGND VPWR VPWR sky130_fd_sc_hd__decap_3
XFILLER_68_578 VGND VGND VPWR VPWR sky130_fd_sc_hd__fill_2
XFILLER_68_589 VGND VGND VPWR VPWR sky130_fd_sc_hd__decap_3
X_4083_ _4083_/A VGND VGND VPWR VPWR _7979_/D sky130_fd_sc_hd__buf_1
XFILLER_48_280 VGND VGND VPWR VPWR sky130_fd_sc_hd__decap_3
XFILLER_55_228 VGND VGND VPWR VPWR sky130_fd_sc_hd__fill_2
X_7911_ _7911_/A VGND VGND VPWR VPWR _8392_/D sky130_fd_sc_hd__buf_1
XFILLER_36_442 VGND VGND VPWR VPWR sky130_fd_sc_hd__decap_3
XFILLER_70_209 VGND VGND VPWR VPWR sky130_fd_sc_hd__decap_3
XFILLER_24_604 VGND VGND VPWR VPWR sky130_fd_sc_hd__decap_3
XFILLER_24_626 VGND VGND VPWR VPWR sky130_fd_sc_hd__decap_3
XFILLER_36_475 VGND VGND VPWR VPWR sky130_fd_sc_hd__fill_1
XFILLER_63_261 VGND VGND VPWR VPWR sky130_fd_sc_hd__decap_3
X_7842_ _5507_/X _7837_/X _7839_/X _7841_/X VGND VGND VPWR VPWR _7842_/Y sky130_fd_sc_hd__o211ai_2
XFILLER_23_147 VGND VGND VPWR VPWR sky130_fd_sc_hd__decap_3
XFILLER_51_423 VGND VGND VPWR VPWR sky130_fd_sc_hd__decap_3
XFILLER_91_592 VGND VGND VPWR VPWR sky130_fd_sc_hd__fill_2
X_7773_ _7812_/A _7769_/X _7772_/X VGND VGND VPWR VPWR _7773_/Y sky130_fd_sc_hd__a21oi_2
X_4985_ _4791_/C _4979_/Y _4984_/Y _7372_/B VGND VGND VPWR VPWR _4985_/Y sky130_fd_sc_hd__o211ai_2
XFILLER_23_169 VGND VGND VPWR VPWR sky130_fd_sc_hd__decap_3
XFILLER_51_467 VGND VGND VPWR VPWR sky130_fd_sc_hd__decap_3
X_6724_ _8192_/Q _8256_/Q _8258_/Q _6725_/D _6601_/X VGND VGND VPWR VPWR _6726_/B
+ sky130_fd_sc_hd__a2111o_2
XFILLER_32_681 VGND VGND VPWR VPWR sky130_fd_sc_hd__decap_3
XTAP_TAPCELL_ROW_34_698 VGND VPWR sky130_fd_sc_hd__tapvpwrvgnd_1
XFILLER_109_208 VGND VGND VPWR VPWR sky130_fd_sc_hd__decap_3
X_6655_ _6655_/A _6655_/B _6655_/C _6655_/D VGND VGND VPWR VPWR _6711_/C sky130_fd_sc_hd__or4_4
XFILLER_118_731 VGND VGND VPWR VPWR sky130_fd_sc_hd__fill_2
X_6586_ _8191_/Q _8255_/Q _6585_/X VGND VGND VPWR VPWR _6586_/X sky130_fd_sc_hd__a21o_2
X_5606_ _8222_/Q _8223_/Q _7745_/B VGND VGND VPWR VPWR _5606_/X sky130_fd_sc_hd__mux2_2
XFILLER_11_47 VGND VGND VPWR VPWR sky130_fd_sc_hd__decap_3
X_8325_ _8392_/CLK _8325_/D VGND VGND VPWR VPWR _8325_/Q sky130_fd_sc_hd__dfxtp_2
X_5537_ _5534_/Y _5592_/B _6717_/A VGND VGND VPWR VPWR _5537_/Y sky130_fd_sc_hd__a21oi_2
XFILLER_105_425 VGND VGND VPWR VPWR sky130_fd_sc_hd__fill_1
X_8256_ _8396_/CLK _8256_/D VGND VGND VPWR VPWR _8256_/Q sky130_fd_sc_hd__dfxtp_2
XFILLER_105_447 VGND VGND VPWR VPWR sky130_fd_sc_hd__fill_1
XFILLER_78_309 VGND VGND VPWR VPWR sky130_fd_sc_hd__decap_3
X_7207_ _8272_/Q _7164_/B _7206_/X VGND VGND VPWR VPWR _7208_/B sky130_fd_sc_hd__a21boi_2
X_5468_ _7825_/A _5468_/B VGND VGND VPWR VPWR _5469_/B sky130_fd_sc_hd__or2_2
XFILLER_59_501 VGND VGND VPWR VPWR sky130_fd_sc_hd__decap_3
X_8187_ _8187_/CLK _8187_/D VGND VGND VPWR VPWR _8187_/Q sky130_fd_sc_hd__dfxtp_4
X_5399_ _5600_/A VGND VGND VPWR VPWR _5399_/X sky130_fd_sc_hd__buf_1
X_4419_ _4419_/A VGND VGND VPWR VPWR _8147_/D sky130_fd_sc_hd__buf_1
XTAP_TAPCELL_ROW_6_335 VGND VPWR sky130_fd_sc_hd__tapvpwrvgnd_1
XFILLER_101_620 VGND VGND VPWR VPWR sky130_fd_sc_hd__decap_3
XFILLER_101_642 VGND VGND VPWR VPWR sky130_fd_sc_hd__decap_3
XFILLER_59_523 VGND VGND VPWR VPWR sky130_fd_sc_hd__decap_3
XFILLER_98_180 VGND VGND VPWR VPWR sky130_fd_sc_hd__decap_3
X_7138_ _7619_/A _4776_/A _4776_/B VGND VGND VPWR VPWR _7138_/Y sky130_fd_sc_hd__o21ai_2
XFILLER_100_141 VGND VGND VPWR VPWR sky130_fd_sc_hd__decap_3
XFILLER_101_664 VGND VGND VPWR VPWR sky130_fd_sc_hd__decap_3
XFILLER_47_729 VGND VGND VPWR VPWR sky130_fd_sc_hd__decap_3
XFILLER_74_515 VGND VGND VPWR VPWR sky130_fd_sc_hd__decap_3
XFILLER_86_353 VGND VGND VPWR VPWR sky130_fd_sc_hd__decap_3
X_7069_ _7070_/B _7560_/A _7474_/A _7128_/C VGND VGND VPWR VPWR _7069_/X sky130_fd_sc_hd__o2bb2a_2
XTAP_TAPCELL_ROW_70_1166 VGND VPWR sky130_fd_sc_hd__tapvpwrvgnd_1
XFILLER_100_185 VGND VGND VPWR VPWR sky130_fd_sc_hd__decap_3
XFILLER_86_386 VGND VGND VPWR VPWR sky130_fd_sc_hd__decap_3
XFILLER_74_559 VGND VGND VPWR VPWR sky130_fd_sc_hd__decap_3
XFILLER_15_615 VGND VGND VPWR VPWR sky130_fd_sc_hd__fill_1
XFILLER_42_412 VGND VGND VPWR VPWR sky130_fd_sc_hd__fill_1
XFILLER_70_710 VGND VGND VPWR VPWR sky130_fd_sc_hd__fill_1
XFILLER_82_570 VGND VGND VPWR VPWR sky130_fd_sc_hd__fill_2
XFILLER_82_581 VGND VGND VPWR VPWR sky130_fd_sc_hd__decap_3
XFILLER_42_445 VGND VGND VPWR VPWR sky130_fd_sc_hd__decap_3
XFILLER_54_283 VGND VGND VPWR VPWR sky130_fd_sc_hd__decap_3
XFILLER_54_294 VGND VGND VPWR VPWR sky130_fd_sc_hd__decap_3
XTAP_TAPCELL_ROW_53_952 VGND VPWR sky130_fd_sc_hd__tapvpwrvgnd_1
XFILLER_14_147 VGND VGND VPWR VPWR sky130_fd_sc_hd__decap_3
XFILLER_30_618 VGND VGND VPWR VPWR sky130_fd_sc_hd__decap_3
XFILLER_42_456 VGND VGND VPWR VPWR sky130_fd_sc_hd__decap_3
XFILLER_10_353 VGND VGND VPWR VPWR sky130_fd_sc_hd__decap_3
XFILLER_6_302 VGND VGND VPWR VPWR sky130_fd_sc_hd__fill_1
Xinput19 operand_a[21] VGND VGND VPWR VPWR _4218_/B sky130_fd_sc_hd__clkdlybuf4s25_1
XFILLER_6_324 VGND VGND VPWR VPWR sky130_fd_sc_hd__decap_3
XFILLER_108_230 VGND VGND VPWR VPWR sky130_fd_sc_hd__decap_3
XFILLER_6_368 VGND VGND VPWR VPWR sky130_fd_sc_hd__decap_3
XFILLER_2_541 VGND VGND VPWR VPWR sky130_fd_sc_hd__decap_3
XFILLER_96_106 VGND VGND VPWR VPWR sky130_fd_sc_hd__decap_3
XFILLER_97_629 VGND VGND VPWR VPWR sky130_fd_sc_hd__decap_3
XFILLER_104_480 VGND VGND VPWR VPWR sky130_fd_sc_hd__decap_3
XFILLER_77_320 VGND VGND VPWR VPWR sky130_fd_sc_hd__decap_3
XFILLER_96_139 VGND VGND VPWR VPWR sky130_fd_sc_hd__fill_1
XFILLER_38_707 VGND VGND VPWR VPWR sky130_fd_sc_hd__fill_2
XTAP_TAPCELL_ROW_88_1405 VGND VPWR sky130_fd_sc_hd__tapvpwrvgnd_1
XFILLER_77_375 VGND VGND VPWR VPWR sky130_fd_sc_hd__decap_3
XFILLER_92_301 VGND VGND VPWR VPWR sky130_fd_sc_hd__decap_3
XFILLER_92_334 VGND VGND VPWR VPWR sky130_fd_sc_hd__decap_3
XFILLER_93_50 VGND VGND VPWR VPWR sky130_fd_sc_hd__decap_3
XFILLER_18_475 VGND VGND VPWR VPWR sky130_fd_sc_hd__fill_1
XFILLER_73_581 VGND VGND VPWR VPWR sky130_fd_sc_hd__decap_3
XFILLER_92_389 VGND VGND VPWR VPWR sky130_fd_sc_hd__decap_3
XFILLER_93_72 VGND VGND VPWR VPWR sky130_fd_sc_hd__decap_3
XFILLER_33_423 VGND VGND VPWR VPWR sky130_fd_sc_hd__decap_3
XFILLER_61_732 VGND VGND VPWR VPWR sky130_fd_sc_hd__fill_1
XFILLER_60_242 VGND VGND VPWR VPWR sky130_fd_sc_hd__fill_2
XFILLER_60_253 VGND VGND VPWR VPWR sky130_fd_sc_hd__decap_3
XFILLER_60_286 VGND VGND VPWR VPWR sky130_fd_sc_hd__decap_3
X_4770_ _7372_/A _7372_/B VGND VGND VPWR VPWR _7398_/C sky130_fd_sc_hd__nand2_2
XTAP_TAPCELL_ROW_99_1545 VGND VPWR sky130_fd_sc_hd__tapvpwrvgnd_1
XTAP_TAPCELL_ROW_31_668 VGND VPWR sky130_fd_sc_hd__tapvpwrvgnd_1
XTAP_TAPCELL_ROW_31_657 VGND VPWR sky130_fd_sc_hd__tapvpwrvgnd_1
XFILLER_9_184 VGND VGND VPWR VPWR sky130_fd_sc_hd__fill_2
X_6440_ _6564_/C _6564_/B _4886_/B VGND VGND VPWR VPWR _6440_/Y sky130_fd_sc_hd__a21oi_2
X_6371_ _8186_/Q _8250_/Q VGND VGND VPWR VPWR _6371_/X sky130_fd_sc_hd__or2_2
X_8110_ _8377_/CLK _8110_/D VGND VGND VPWR VPWR _8110_/Q sky130_fd_sc_hd__dfxtp_2
X_5322_ _5411_/B _5817_/A _6148_/A _5417_/B _5491_/A VGND VGND VPWR VPWR _5322_/X
+ sky130_fd_sc_hd__a221o_2
XFILLER_114_277 VGND VGND VPWR VPWR sky130_fd_sc_hd__decap_3
X_8041_ _8187_/CLK _8041_/D VGND VGND VPWR VPWR _8041_/Q sky130_fd_sc_hd__dfxtp_2
X_5253_ _8165_/Q _8166_/Q _7805_/A VGND VGND VPWR VPWR _5253_/X sky130_fd_sc_hd__mux2_2
XFILLER_102_439 VGND VGND VPWR VPWR sky130_fd_sc_hd__decap_3
X_5184_ _6623_/A VGND VGND VPWR VPWR _5464_/A sky130_fd_sc_hd__buf_1
X_4204_ _7898_/B _4204_/B VGND VGND VPWR VPWR _4205_/A sky130_fd_sc_hd__and2_2
XFILLER_29_729 VGND VGND VPWR VPWR sky130_fd_sc_hd__decap_3
XFILLER_3_81 VGND VGND VPWR VPWR sky130_fd_sc_hd__decap_3
XFILLER_96_651 VGND VGND VPWR VPWR sky130_fd_sc_hd__fill_1
X_4135_ _4135_/A VGND VGND VPWR VPWR _8005_/D sky130_fd_sc_hd__buf_1
XFILLER_110_461 VGND VGND VPWR VPWR sky130_fd_sc_hd__decap_3
XFILLER_110_494 VGND VGND VPWR VPWR sky130_fd_sc_hd__decap_3
XFILLER_113_27 VGND VGND VPWR VPWR sky130_fd_sc_hd__decap_3
XFILLER_28_206 VGND VGND VPWR VPWR sky130_fd_sc_hd__fill_1
XFILLER_28_228 VGND VGND VPWR VPWR sky130_fd_sc_hd__decap_3
XFILLER_68_397 VGND VGND VPWR VPWR sky130_fd_sc_hd__decap_3
XFILLER_83_312 VGND VGND VPWR VPWR sky130_fd_sc_hd__fill_2
XFILLER_95_172 VGND VGND VPWR VPWR sky130_fd_sc_hd__decap_3
XFILLER_83_367 VGND VGND VPWR VPWR sky130_fd_sc_hd__decap_3
X_4066_ _7930_/B _8374_/Q VGND VGND VPWR VPWR _4067_/A sky130_fd_sc_hd__and2_2
XTAP_TAPCELL_ROW_39_768 VGND VPWR sky130_fd_sc_hd__tapvpwrvgnd_1
XFILLER_71_529 VGND VGND VPWR VPWR sky130_fd_sc_hd__fill_1
XTAP_TAPCELL_ROW_108_1663 VGND VPWR sky130_fd_sc_hd__tapvpwrvgnd_1
XFILLER_51_231 VGND VGND VPWR VPWR sky130_fd_sc_hd__decap_3
X_7825_ _7825_/A _7825_/B VGND VGND VPWR VPWR _7827_/C sky130_fd_sc_hd__nand2_2
XFILLER_24_456 VGND VGND VPWR VPWR sky130_fd_sc_hd__decap_3
XFILLER_12_629 VGND VGND VPWR VPWR sky130_fd_sc_hd__fill_2
XFILLER_24_489 VGND VGND VPWR VPWR sky130_fd_sc_hd__decap_3
XFILLER_51_275 VGND VGND VPWR VPWR sky130_fd_sc_hd__decap_3
X_7756_ _7812_/A _8201_/Q _7820_/B VGND VGND VPWR VPWR _7756_/X sky130_fd_sc_hd__and3_2
X_4968_ _4968_/A _5316_/A _4967_/Y VGND VGND VPWR VPWR _4969_/D sky130_fd_sc_hd__or3b_2
XTAP_TAPCELL_ROW_50_911 VGND VPWR sky130_fd_sc_hd__tapvpwrvgnd_1
XFILLER_11_139 VGND VGND VPWR VPWR sky130_fd_sc_hd__decap_3
X_7687_ _7796_/A _8190_/Q VGND VGND VPWR VPWR _7687_/Y sky130_fd_sc_hd__nand2_2
X_6707_ _6706_/X _6420_/X _6707_/S VGND VGND VPWR VPWR _6707_/X sky130_fd_sc_hd__mux2_2
X_4899_ _8183_/Q _8247_/Q VGND VGND VPWR VPWR _4900_/B sky130_fd_sc_hd__or2b_2
XFILLER_20_673 VGND VGND VPWR VPWR sky130_fd_sc_hd__decap_3
XFILLER_20_684 VGND VGND VPWR VPWR sky130_fd_sc_hd__decap_3
XFILLER_22_35 VGND VGND VPWR VPWR sky130_fd_sc_hd__decap_3
X_6638_ _8193_/Q _5398_/A _5618_/A _8257_/Q VGND VGND VPWR VPWR _6638_/X sky130_fd_sc_hd__a2bb2o_2
XFILLER_106_701 VGND VGND VPWR VPWR sky130_fd_sc_hd__fill_2
XFILLER_22_79 VGND VGND VPWR VPWR sky130_fd_sc_hd__decap_3
XTAP_TAPCELL_ROW_59_1028 VGND VPWR sky130_fd_sc_hd__tapvpwrvgnd_1
X_8308_ _8379_/CLK _8308_/D VGND VGND VPWR VPWR _8308_/Q sky130_fd_sc_hd__dfxtp_2
X_6569_ _8190_/Q _6569_/B VGND VGND VPWR VPWR _6605_/B sky130_fd_sc_hd__nand2_2
XFILLER_0_6 VGND VGND VPWR VPWR sky130_fd_sc_hd__decap_3
XFILLER_3_349 VGND VGND VPWR VPWR sky130_fd_sc_hd__decap_3
XFILLER_105_266 VGND VGND VPWR VPWR sky130_fd_sc_hd__decap_3
XFILLER_78_106 VGND VGND VPWR VPWR sky130_fd_sc_hd__decap_3
X_8239_ clkload5/A _8239_/D VGND VGND VPWR VPWR _8239_/Q sky130_fd_sc_hd__dfxtp_2
XFILLER_59_331 VGND VGND VPWR VPWR sky130_fd_sc_hd__decap_3
XFILLER_78_139 VGND VGND VPWR VPWR sky130_fd_sc_hd__fill_1
XFILLER_87_640 VGND VGND VPWR VPWR sky130_fd_sc_hd__decap_3
XFILLER_47_10 VGND VGND VPWR VPWR sky130_fd_sc_hd__decap_3
XFILLER_87_651 VGND VGND VPWR VPWR sky130_fd_sc_hd__decap_3
XFILLER_87_673 VGND VGND VPWR VPWR sky130_fd_sc_hd__decap_3
XFILLER_101_472 VGND VGND VPWR VPWR sky130_fd_sc_hd__decap_3
XFILLER_47_43 VGND VGND VPWR VPWR sky130_fd_sc_hd__decap_3
XFILLER_74_312 VGND VGND VPWR VPWR sky130_fd_sc_hd__decap_3
XFILLER_86_183 VGND VGND VPWR VPWR sky130_fd_sc_hd__decap_3
XFILLER_101_494 VGND VGND VPWR VPWR sky130_fd_sc_hd__decap_3
XFILLER_74_345 VGND VGND VPWR VPWR sky130_fd_sc_hd__decap_3
XFILLER_34_209 VGND VGND VPWR VPWR sky130_fd_sc_hd__fill_2
XFILLER_74_389 VGND VGND VPWR VPWR sky130_fd_sc_hd__decap_3
XFILLER_27_272 VGND VGND VPWR VPWR sky130_fd_sc_hd__decap_3
XFILLER_43_732 VGND VGND VPWR VPWR sky130_fd_sc_hd__fill_1
XFILLER_55_581 VGND VGND VPWR VPWR sky130_fd_sc_hd__fill_2
XTAP_TAPCELL_ROW_83_1335 VGND VPWR sky130_fd_sc_hd__tapvpwrvgnd_1
XFILLER_42_253 VGND VGND VPWR VPWR sky130_fd_sc_hd__decap_3
XFILLER_63_75 VGND VGND VPWR VPWR sky130_fd_sc_hd__decap_3
XPHY_EDGE_ROW_69_Right_69 VGND VGND VPWR VPWR sky130_fd_sc_hd__decap_3
XFILLER_42_297 VGND VGND VPWR VPWR sky130_fd_sc_hd__fill_1
XFILLER_30_459 VGND VGND VPWR VPWR sky130_fd_sc_hd__decap_3
XFILLER_7_600 VGND VGND VPWR VPWR sky130_fd_sc_hd__decap_3
XFILLER_8_48 VGND VGND VPWR VPWR sky130_fd_sc_hd__fill_2
XPHY_EDGE_ROW_7_Left_127 VGND VGND VPWR VPWR sky130_fd_sc_hd__decap_3
XFILLER_11_673 VGND VGND VPWR VPWR sky130_fd_sc_hd__decap_3
XFILLER_109_550 VGND VGND VPWR VPWR sky130_fd_sc_hd__fill_1
XFILLER_6_132 VGND VGND VPWR VPWR sky130_fd_sc_hd__decap_3
XFILLER_109_561 VGND VGND VPWR VPWR sky130_fd_sc_hd__decap_3
XFILLER_109_583 VGND VGND VPWR VPWR sky130_fd_sc_hd__decap_3
XPHY_EDGE_ROW_78_Right_78 VGND VGND VPWR VPWR sky130_fd_sc_hd__decap_3
XTAP_TAPCELL_ROW_94_1475 VGND VPWR sky130_fd_sc_hd__tapvpwrvgnd_1
XFILLER_112_726 VGND VGND VPWR VPWR sky130_fd_sc_hd__decap_3
XFILLER_97_415 VGND VGND VPWR VPWR sky130_fd_sc_hd__decap_3
XTAP_TAPCELL_ROW_94_1486 VGND VPWR sky130_fd_sc_hd__tapvpwrvgnd_1
XFILLER_111_225 VGND VGND VPWR VPWR sky130_fd_sc_hd__decap_3
XFILLER_2_360 VGND VGND VPWR VPWR sky130_fd_sc_hd__decap_3
XFILLER_33_6 VGND VGND VPWR VPWR sky130_fd_sc_hd__fill_1
XFILLER_88_94 VGND VGND VPWR VPWR sky130_fd_sc_hd__decap_3
XFILLER_38_504 VGND VGND VPWR VPWR sky130_fd_sc_hd__decap_3
XFILLER_78_673 VGND VGND VPWR VPWR sky130_fd_sc_hd__decap_3
XFILLER_65_323 VGND VGND VPWR VPWR sky130_fd_sc_hd__decap_3
XFILLER_77_150 VGND VGND VPWR VPWR sky130_fd_sc_hd__decap_3
XFILLER_38_548 VGND VGND VPWR VPWR sky130_fd_sc_hd__decap_3
XFILLER_92_131 VGND VGND VPWR VPWR sky130_fd_sc_hd__decap_3
XFILLER_93_665 VGND VGND VPWR VPWR sky130_fd_sc_hd__decap_3
XFILLER_46_570 VGND VGND VPWR VPWR sky130_fd_sc_hd__decap_3
XFILLER_65_367 VGND VGND VPWR VPWR sky130_fd_sc_hd__decap_3
XFILLER_93_698 VGND VGND VPWR VPWR sky130_fd_sc_hd__decap_3
X_5940_ _7631_/B _5936_/X _5939_/X _6769_/B VGND VGND VPWR VPWR _5963_/A sky130_fd_sc_hd__o2bb2a_2
XTAP_TAPCELL_ROW_36_727 VGND VPWR sky130_fd_sc_hd__tapvpwrvgnd_1
XFILLER_18_283 VGND VGND VPWR VPWR sky130_fd_sc_hd__decap_3
XFILLER_80_337 VGND VGND VPWR VPWR sky130_fd_sc_hd__decap_3
XFILLER_92_197 VGND VGND VPWR VPWR sky130_fd_sc_hd__decap_3
XPHY_EDGE_ROW_87_Right_87 VGND VGND VPWR VPWR sky130_fd_sc_hd__decap_3
XFILLER_33_231 VGND VGND VPWR VPWR sky130_fd_sc_hd__decap_3
X_7610_ _8223_/Q _7610_/B VGND VGND VPWR VPWR _7610_/Y sky130_fd_sc_hd__nand2_2
X_5871_ _5724_/X _5769_/X _5870_/X _5765_/B VGND VGND VPWR VPWR _5873_/B sky130_fd_sc_hd__a31o_4
XTAP_TAPCELL_ROW_16_462 VGND VPWR sky130_fd_sc_hd__tapvpwrvgnd_1
X_4822_ _8265_/Q _8201_/Q VGND VGND VPWR VPWR _4823_/B sky130_fd_sc_hd__and2b_2
XTAP_TAPCELL_ROW_16_473 VGND VPWR sky130_fd_sc_hd__tapvpwrvgnd_1
XTAP_TAPCELL_ROW_103_1593 VGND VPWR sky130_fd_sc_hd__tapvpwrvgnd_1
X_7541_ _7541_/A _7541_/B VGND VGND VPWR VPWR _7551_/A sky130_fd_sc_hd__nor2_2
X_4753_ _7646_/A _8287_/Q VGND VGND VPWR VPWR _7843_/B sky130_fd_sc_hd__and2_2
X_7472_ _8217_/Q _7472_/B VGND VGND VPWR VPWR _7612_/B sky130_fd_sc_hd__nand2_2
XFILLER_119_358 VGND VGND VPWR VPWR sky130_fd_sc_hd__decap_3
X_6423_ _6130_/A _5832_/B _6422_/Y _6132_/A VGND VGND VPWR VPWR _6423_/X sky130_fd_sc_hd__a211o_2
X_4684_ _7930_/B _8146_/Q VGND VGND VPWR VPWR _4685_/A sky130_fd_sc_hd__and2_2
XFILLER_108_16 VGND VGND VPWR VPWR sky130_fd_sc_hd__decap_3
XPHY_EDGE_ROW_96_Right_96 VGND VGND VPWR VPWR sky130_fd_sc_hd__decap_3
X_6354_ _6354_/A _6354_/B VGND VGND VPWR VPWR _6354_/Y sky130_fd_sc_hd__nand2_2
XFILLER_102_203 VGND VGND VPWR VPWR sky130_fd_sc_hd__decap_3
X_6285_ _6285_/A VGND VGND VPWR VPWR _8317_/D sky130_fd_sc_hd__buf_1
X_5305_ _5491_/A _5294_/X _5296_/X _7783_/A _5304_/X VGND VGND VPWR VPWR _5305_/X
+ sky130_fd_sc_hd__a221o_2
X_8024_ _8285_/CLK _8024_/D VGND VGND VPWR VPWR _8024_/Q sky130_fd_sc_hd__dfxtp_2
X_5236_ _5228_/X _5235_/X _6648_/A VGND VGND VPWR VPWR _5237_/B sky130_fd_sc_hd__mux2_2
XFILLER_102_247 VGND VGND VPWR VPWR sky130_fd_sc_hd__decap_3
XFILLER_102_258 VGND VGND VPWR VPWR sky130_fd_sc_hd__fill_2
XFILLER_102_269 VGND VGND VPWR VPWR sky130_fd_sc_hd__decap_3
XFILLER_69_651 VGND VGND VPWR VPWR sky130_fd_sc_hd__decap_3
XFILLER_29_526 VGND VGND VPWR VPWR sky130_fd_sc_hd__decap_3
XFILLER_56_301 VGND VGND VPWR VPWR sky130_fd_sc_hd__decap_3
XFILLER_56_323 VGND VGND VPWR VPWR sky130_fd_sc_hd__fill_2
XFILLER_69_673 VGND VGND VPWR VPWR sky130_fd_sc_hd__decap_3
XFILLER_84_632 VGND VGND VPWR VPWR sky130_fd_sc_hd__decap_3
X_5167_ _8186_/Q _8187_/Q _5484_/S VGND VGND VPWR VPWR _5167_/X sky130_fd_sc_hd__mux2_2
XFILLER_110_280 VGND VGND VPWR VPWR sky130_fd_sc_hd__decap_3
XFILLER_56_345 VGND VGND VPWR VPWR sky130_fd_sc_hd__decap_3
XFILLER_84_654 VGND VGND VPWR VPWR sky130_fd_sc_hd__decap_3
XFILLER_96_492 VGND VGND VPWR VPWR sky130_fd_sc_hd__decap_3
X_5098_ _6355_/A _7745_/B VGND VGND VPWR VPWR _6571_/B sky130_fd_sc_hd__nor2_2
X_4118_ _7930_/B _8400_/Q VGND VGND VPWR VPWR _4119_/A sky130_fd_sc_hd__and2_2
XFILLER_37_570 VGND VGND VPWR VPWR sky130_fd_sc_hd__fill_1
XFILLER_44_507 VGND VGND VPWR VPWR sky130_fd_sc_hd__decap_3
XFILLER_56_389 VGND VGND VPWR VPWR sky130_fd_sc_hd__decap_3
XFILLER_84_687 VGND VGND VPWR VPWR sky130_fd_sc_hd__decap_3
XFILLER_84_698 VGND VGND VPWR VPWR sky130_fd_sc_hd__fill_2
X_4049_ _4049_/A VGND VGND VPWR VPWR _7962_/D sky130_fd_sc_hd__buf_1
XFILLER_17_57 VGND VGND VPWR VPWR sky130_fd_sc_hd__fill_2
XFILLER_17_68 VGND VGND VPWR VPWR sky130_fd_sc_hd__decap_3
XFILLER_25_732 VGND VGND VPWR VPWR sky130_fd_sc_hd__fill_1
XFILLER_71_337 VGND VGND VPWR VPWR sky130_fd_sc_hd__decap_3
XFILLER_24_242 VGND VGND VPWR VPWR sky130_fd_sc_hd__decap_3
XFILLER_24_253 VGND VGND VPWR VPWR sky130_fd_sc_hd__decap_3
XFILLER_24_275 VGND VGND VPWR VPWR sky130_fd_sc_hd__decap_3
XFILLER_33_34 VGND VGND VPWR VPWR sky130_fd_sc_hd__decap_3
X_7808_ _7809_/A1 _7663_/B _7660_/A VGND VGND VPWR VPWR _7808_/Y sky130_fd_sc_hd__o21ai_2
XTAP_TAPCELL_ROW_65_1098 VGND VPWR sky130_fd_sc_hd__tapvpwrvgnd_1
XFILLER_12_448 VGND VGND VPWR VPWR sky130_fd_sc_hd__decap_3
X_7739_ _5950_/A _7737_/Y _7738_/Y _7796_/A VGND VGND VPWR VPWR _7739_/X sky130_fd_sc_hd__a22o_2
XFILLER_116_3 VGND VGND VPWR VPWR sky130_fd_sc_hd__decap_3
XFILLER_3_102 VGND VGND VPWR VPWR sky130_fd_sc_hd__decap_3
XFILLER_106_542 VGND VGND VPWR VPWR sky130_fd_sc_hd__decap_3
XFILLER_3_113 VGND VGND VPWR VPWR sky130_fd_sc_hd__decap_3
XFILLER_106_575 VGND VGND VPWR VPWR sky130_fd_sc_hd__fill_1
XFILLER_94_407 VGND VGND VPWR VPWR sky130_fd_sc_hd__decap_3
XFILLER_47_312 VGND VGND VPWR VPWR sky130_fd_sc_hd__decap_3
XFILLER_59_172 VGND VGND VPWR VPWR sky130_fd_sc_hd__fill_2
XFILLER_59_183 VGND VGND VPWR VPWR sky130_fd_sc_hd__decap_3
XFILLER_75_654 VGND VGND VPWR VPWR sky130_fd_sc_hd__decap_3
XFILLER_114_92 VGND VGND VPWR VPWR sky130_fd_sc_hd__decap_3
XFILLER_47_378 VGND VGND VPWR VPWR sky130_fd_sc_hd__decap_3
XFILLER_62_304 VGND VGND VPWR VPWR sky130_fd_sc_hd__decap_3
XFILLER_62_315 VGND VGND VPWR VPWR sky130_fd_sc_hd__decap_3
XFILLER_74_164 VGND VGND VPWR VPWR sky130_fd_sc_hd__decap_3
XFILLER_75_676 VGND VGND VPWR VPWR sky130_fd_sc_hd__decap_3
XFILLER_90_613 VGND VGND VPWR VPWR sky130_fd_sc_hd__decap_3
XFILLER_16_721 VGND VGND VPWR VPWR sky130_fd_sc_hd__decap_3
XFILLER_28_570 VGND VGND VPWR VPWR sky130_fd_sc_hd__decap_3
XFILLER_28_592 VGND VGND VPWR VPWR sky130_fd_sc_hd__decap_3
XFILLER_74_186 VGND VGND VPWR VPWR sky130_fd_sc_hd__decap_3
XFILLER_74_197 VGND VGND VPWR VPWR sky130_fd_sc_hd__decap_3
XFILLER_15_231 VGND VGND VPWR VPWR sky130_fd_sc_hd__decap_3
XFILLER_90_668 VGND VGND VPWR VPWR sky130_fd_sc_hd__decap_3
XFILLER_15_264 VGND VGND VPWR VPWR sky130_fd_sc_hd__decap_3
XFILLER_30_212 VGND VGND VPWR VPWR sky130_fd_sc_hd__decap_3
XFILLER_43_573 VGND VGND VPWR VPWR sky130_fd_sc_hd__decap_3
XFILLER_30_234 VGND VGND VPWR VPWR sky130_fd_sc_hd__decap_3
XFILLER_30_245 VGND VGND VPWR VPWR sky130_fd_sc_hd__decap_3
XFILLER_90_62 VGND VGND VPWR VPWR sky130_fd_sc_hd__decap_3
XTAP_TAPCELL_ROW_13_432 VGND VPWR sky130_fd_sc_hd__tapvpwrvgnd_1
XFILLER_30_256 VGND VGND VPWR VPWR sky130_fd_sc_hd__decap_3
XFILLER_11_481 VGND VGND VPWR VPWR sky130_fd_sc_hd__decap_3
XTAP_TAPCELL_ROW_96_1504 VGND VPWR sky130_fd_sc_hd__tapvpwrvgnd_1
XTAP_TAPCELL_ROW_41_796 VGND VPWR sky130_fd_sc_hd__tapvpwrvgnd_1
XFILLER_109_391 VGND VGND VPWR VPWR sky130_fd_sc_hd__fill_1
XFILLER_116_339 VGND VGND VPWR VPWR sky130_fd_sc_hd__fill_2
XFILLER_99_71 VGND VGND VPWR VPWR sky130_fd_sc_hd__decap_3
XFILLER_31_3 VGND VGND VPWR VPWR sky130_fd_sc_hd__fill_2
XFILLER_3_691 VGND VGND VPWR VPWR sky130_fd_sc_hd__fill_2
XFILLER_97_212 VGND VGND VPWR VPWR sky130_fd_sc_hd__decap_3
XFILLER_97_234 VGND VGND VPWR VPWR sky130_fd_sc_hd__decap_3
XFILLER_97_256 VGND VGND VPWR VPWR sky130_fd_sc_hd__fill_1
X_6070_ _6070_/A _6070_/B VGND VGND VPWR VPWR _6355_/B sky130_fd_sc_hd__nand2_2
XFILLER_112_589 VGND VGND VPWR VPWR sky130_fd_sc_hd__decap_3
XFILLER_78_470 VGND VGND VPWR VPWR sky130_fd_sc_hd__decap_3
X_5021_ _4970_/B _5014_/Y _5019_/X _8231_/Q _5020_/X VGND VGND VPWR VPWR _5021_/X
+ sky130_fd_sc_hd__o221a_2
XFILLER_66_632 VGND VGND VPWR VPWR sky130_fd_sc_hd__decap_3
XFILLER_93_440 VGND VGND VPWR VPWR sky130_fd_sc_hd__decap_3
XFILLER_26_529 VGND VGND VPWR VPWR sky130_fd_sc_hd__decap_3
XFILLER_38_389 VGND VGND VPWR VPWR sky130_fd_sc_hd__decap_3
XFILLER_65_164 VGND VGND VPWR VPWR sky130_fd_sc_hd__decap_3
XFILLER_66_665 VGND VGND VPWR VPWR sky130_fd_sc_hd__decap_3
XFILLER_93_473 VGND VGND VPWR VPWR sky130_fd_sc_hd__decap_3
XFILLER_0_60 VGND VGND VPWR VPWR sky130_fd_sc_hd__decap_3
XFILLER_19_570 VGND VGND VPWR VPWR sky130_fd_sc_hd__decap_3
XFILLER_53_326 VGND VGND VPWR VPWR sky130_fd_sc_hd__decap_3
XFILLER_53_337 VGND VGND VPWR VPWR sky130_fd_sc_hd__decap_3
XFILLER_65_175 VGND VGND VPWR VPWR sky130_fd_sc_hd__decap_3
XFILLER_80_123 VGND VGND VPWR VPWR sky130_fd_sc_hd__decap_3
XFILLER_81_657 VGND VGND VPWR VPWR sky130_fd_sc_hd__fill_2
XTAP_TAPCELL_ROW_105_1622 VGND VPWR sky130_fd_sc_hd__tapvpwrvgnd_1
X_6972_ _5435_/A _6970_/X _6624_/A _6968_/Y VGND VGND VPWR VPWR _6972_/X sky130_fd_sc_hd__a2bb2o_2
XTAP_TAPCELL_ROW_49_896 VGND VPWR sky130_fd_sc_hd__tapvpwrvgnd_1
XFILLER_34_551 VGND VGND VPWR VPWR sky130_fd_sc_hd__decap_3
XFILLER_81_679 VGND VGND VPWR VPWR sky130_fd_sc_hd__decap_3
X_5923_ _5508_/A _5882_/Y _5909_/X _5922_/X VGND VGND VPWR VPWR _5924_/B sky130_fd_sc_hd__o211a_2
XFILLER_61_381 VGND VGND VPWR VPWR sky130_fd_sc_hd__decap_3
XFILLER_80_189 VGND VGND VPWR VPWR sky130_fd_sc_hd__decap_3
X_5854_ _7646_/A _5854_/B VGND VGND VPWR VPWR _6172_/A sky130_fd_sc_hd__nor2_2
XFILLER_21_223 VGND VGND VPWR VPWR sky130_fd_sc_hd__fill_1
XFILLER_21_234 VGND VGND VPWR VPWR sky130_fd_sc_hd__decap_3
X_4805_ _4805_/A _8270_/Q VGND VGND VPWR VPWR _4806_/B sky130_fd_sc_hd__or2_2
X_7524_ _7619_/A _7633_/C _4733_/A VGND VGND VPWR VPWR _7524_/Y sky130_fd_sc_hd__o21ai_2
X_5785_ _5785_/A _5785_/B VGND VGND VPWR VPWR _5785_/Y sky130_fd_sc_hd__nand2_2
XFILLER_119_26 VGND VGND VPWR VPWR sky130_fd_sc_hd__fill_2
X_4736_ _8219_/Q _4736_/B VGND VGND VPWR VPWR _4736_/Y sky130_fd_sc_hd__nand2_2
X_7455_ _7640_/A1 _7434_/Y _7437_/Y _6220_/A _7454_/X VGND VGND VPWR VPWR _7456_/B
+ sky130_fd_sc_hd__a221o_2
X_4667_ _4667_/A VGND VGND VPWR VPWR _8271_/D sky130_fd_sc_hd__buf_1
X_7386_ _6717_/A _7383_/Y _7438_/C _7474_/A _8215_/Q VGND VGND VPWR VPWR _7386_/X
+ sky130_fd_sc_hd__o221a_4
X_6406_ _6404_/X _6405_/Y _6184_/B VGND VGND VPWR VPWR _6406_/X sky130_fd_sc_hd__a21o_2
XTAP_TAPCELL_ROW_116_1762 VGND VPWR sky130_fd_sc_hd__tapvpwrvgnd_1
XTAP_TAPCELL_ROW_116_1773 VGND VPWR sky130_fd_sc_hd__tapvpwrvgnd_1
X_6337_ _5615_/A _6431_/C _6336_/X _6099_/A VGND VGND VPWR VPWR _6338_/B sky130_fd_sc_hd__o2bb2a_2
X_4598_ _7898_/B _8103_/Q VGND VGND VPWR VPWR _4599_/A sky130_fd_sc_hd__and2_2
XFILLER_0_116 VGND VGND VPWR VPWR sky130_fd_sc_hd__decap_3
XFILLER_103_534 VGND VGND VPWR VPWR sky130_fd_sc_hd__decap_3
XFILLER_115_372 VGND VGND VPWR VPWR sky130_fd_sc_hd__decap_3
XFILLER_88_212 VGND VGND VPWR VPWR sky130_fd_sc_hd__decap_3
XFILLER_0_149 VGND VGND VPWR VPWR sky130_fd_sc_hd__decap_3
XFILLER_76_407 VGND VGND VPWR VPWR sky130_fd_sc_hd__decap_3
XFILLER_88_245 VGND VGND VPWR VPWR sky130_fd_sc_hd__decap_3
XFILLER_88_256 VGND VGND VPWR VPWR sky130_fd_sc_hd__decap_3
X_6268_ _7562_/A _5407_/A _6236_/A _6236_/B _7725_/B _5041_/Y VGND VGND VPWR VPWR
+ _6282_/B sky130_fd_sc_hd__mux4_2
XFILLER_103_578 VGND VGND VPWR VPWR sky130_fd_sc_hd__fill_2
XFILLER_28_23 VGND VGND VPWR VPWR sky130_fd_sc_hd__decap_3
XFILLER_69_470 VGND VGND VPWR VPWR sky130_fd_sc_hd__decap_3
X_8007_ _8390_/CLK _8007_/D VGND VGND VPWR VPWR _8007_/Q sky130_fd_sc_hd__dfxtp_2
X_6199_ _7732_/B _8180_/Q _8179_/Q _8178_/Q _5780_/S _6199_/S1 VGND VGND VPWR VPWR
+ _6199_/X sky130_fd_sc_hd__mux4_2
X_5219_ _5215_/X _5218_/X _5579_/S VGND VGND VPWR VPWR _5220_/B sky130_fd_sc_hd__mux2_2
XFILLER_28_56 VGND VGND VPWR VPWR sky130_fd_sc_hd__decap_3
XFILLER_29_334 VGND VGND VPWR VPWR sky130_fd_sc_hd__fill_2
XFILLER_84_440 VGND VGND VPWR VPWR sky130_fd_sc_hd__decap_3
XFILLER_29_356 VGND VGND VPWR VPWR sky130_fd_sc_hd__decap_3
XFILLER_29_378 VGND VGND VPWR VPWR sky130_fd_sc_hd__decap_3
XFILLER_56_153 VGND VGND VPWR VPWR sky130_fd_sc_hd__decap_3
XFILLER_72_602 VGND VGND VPWR VPWR sky130_fd_sc_hd__decap_3
XFILLER_44_315 VGND VGND VPWR VPWR sky130_fd_sc_hd__decap_3
XFILLER_56_186 VGND VGND VPWR VPWR sky130_fd_sc_hd__decap_3
XFILLER_56_197 VGND VGND VPWR VPWR sky130_fd_sc_hd__decap_3
XFILLER_72_624 VGND VGND VPWR VPWR sky130_fd_sc_hd__decap_3
XPHY_EDGE_ROW_88_Left_208 VGND VGND VPWR VPWR sky130_fd_sc_hd__decap_3
XTAP_TAPCELL_ROW_67_1127 VGND VPWR sky130_fd_sc_hd__tapvpwrvgnd_1
XFILLER_71_145 VGND VGND VPWR VPWR sky130_fd_sc_hd__decap_3
XFILLER_71_167 VGND VGND VPWR VPWR sky130_fd_sc_hd__fill_1
XTAP_TAPCELL_ROW_80_1305 VGND VPWR sky130_fd_sc_hd__tapvpwrvgnd_1
XFILLER_44_88 VGND VGND VPWR VPWR sky130_fd_sc_hd__decap_3
XFILLER_52_392 VGND VGND VPWR VPWR sky130_fd_sc_hd__decap_3
XFILLER_12_256 VGND VGND VPWR VPWR sky130_fd_sc_hd__decap_3
XFILLER_12_278 VGND VGND VPWR VPWR sky130_fd_sc_hd__decap_3
XFILLER_8_227 VGND VGND VPWR VPWR sky130_fd_sc_hd__fill_2
XFILLER_100_94 VGND VGND VPWR VPWR sky130_fd_sc_hd__decap_3
XFILLER_40_598 VGND VGND VPWR VPWR sky130_fd_sc_hd__decap_3
XFILLER_60_65 VGND VGND VPWR VPWR sky130_fd_sc_hd__decap_3
XFILLER_8_249 VGND VGND VPWR VPWR sky130_fd_sc_hd__decap_3
XPHY_EDGE_ROW_97_Left_217 VGND VGND VPWR VPWR sky130_fd_sc_hd__decap_3
XTAP_TAPCELL_ROW_78_1278 VGND VPWR sky130_fd_sc_hd__tapvpwrvgnd_1
XTAP_TAPCELL_ROW_78_1267 VGND VPWR sky130_fd_sc_hd__tapvpwrvgnd_1
XFILLER_113_309 VGND VGND VPWR VPWR sky130_fd_sc_hd__decap_3
XFILLER_5_38 VGND VGND VPWR VPWR sky130_fd_sc_hd__fill_1
XFILLER_106_361 VGND VGND VPWR VPWR sky130_fd_sc_hd__decap_3
XFILLER_106_383 VGND VGND VPWR VPWR sky130_fd_sc_hd__decap_3
XFILLER_69_52 VGND VGND VPWR VPWR sky130_fd_sc_hd__decap_3
XFILLER_69_63 VGND VGND VPWR VPWR sky130_fd_sc_hd__fill_1
XFILLER_79_223 VGND VGND VPWR VPWR sky130_fd_sc_hd__fill_1
XTAP_TAPCELL_ROW_91_1445 VGND VPWR sky130_fd_sc_hd__tapvpwrvgnd_1
XFILLER_69_85 VGND VGND VPWR VPWR sky130_fd_sc_hd__decap_3
XFILLER_79_234 VGND VGND VPWR VPWR sky130_fd_sc_hd__fill_2
XFILLER_79_256 VGND VGND VPWR VPWR sky130_fd_sc_hd__decap_3
XFILLER_67_429 VGND VGND VPWR VPWR sky130_fd_sc_hd__decap_3
XFILLER_48_654 VGND VGND VPWR VPWR sky130_fd_sc_hd__decap_3
XFILLER_48_687 VGND VGND VPWR VPWR sky130_fd_sc_hd__decap_3
XFILLER_63_613 VGND VGND VPWR VPWR sky130_fd_sc_hd__decap_3
XFILLER_85_84 VGND VGND VPWR VPWR sky130_fd_sc_hd__decap_3
Xclkbuf_2_3__f_clk clkbuf_0_clk/X VGND VGND VPWR VPWR clkload2/A sky130_fd_sc_hd__clkbuf_16
XFILLER_35_337 VGND VGND VPWR VPWR sky130_fd_sc_hd__fill_2
XFILLER_62_112 VGND VGND VPWR VPWR sky130_fd_sc_hd__decap_3
XFILLER_63_635 VGND VGND VPWR VPWR sky130_fd_sc_hd__decap_3
XFILLER_75_484 VGND VGND VPWR VPWR sky130_fd_sc_hd__decap_3
XFILLER_90_410 VGND VGND VPWR VPWR sky130_fd_sc_hd__decap_3
XFILLER_90_421 VGND VGND VPWR VPWR sky130_fd_sc_hd__decap_3
XFILLER_63_679 VGND VGND VPWR VPWR sky130_fd_sc_hd__decap_3
XFILLER_90_454 VGND VGND VPWR VPWR sky130_fd_sc_hd__decap_3
XTAP_TAPCELL_ROW_46_855 VGND VPWR sky130_fd_sc_hd__tapvpwrvgnd_1
XFILLER_16_584 VGND VGND VPWR VPWR sky130_fd_sc_hd__decap_3
XFILLER_50_318 VGND VGND VPWR VPWR sky130_fd_sc_hd__decap_3
XFILLER_31_554 VGND VGND VPWR VPWR sky130_fd_sc_hd__decap_3
XTAP_TAPCELL_ROW_100_1563 VGND VPWR sky130_fd_sc_hd__tapvpwrvgnd_1
X_5570_ _5384_/X _5373_/X _5596_/S VGND VGND VPWR VPWR _5570_/X sky130_fd_sc_hd__mux2_2
XFILLER_117_626 VGND VGND VPWR VPWR sky130_fd_sc_hd__decap_3
X_4521_ _4521_/A VGND VGND VPWR VPWR _8198_/D sky130_fd_sc_hd__buf_1
X_7240_ _7239_/X _7123_/X _7059_/X _7019_/X _7812_/A _7670_/A VGND VGND VPWR VPWR
+ _7240_/X sky130_fd_sc_hd__mux4_2
X_4452_ _7898_/B _8030_/Q VGND VGND VPWR VPWR _4453_/A sky130_fd_sc_hd__and2_2
XFILLER_104_309 VGND VGND VPWR VPWR sky130_fd_sc_hd__decap_3
XFILLER_116_147 VGND VGND VPWR VPWR sky130_fd_sc_hd__decap_3
XFILLER_98_521 VGND VGND VPWR VPWR sky130_fd_sc_hd__decap_3
X_7171_ _8271_/Q _7172_/B _7228_/B VGND VGND VPWR VPWR _7171_/X sky130_fd_sc_hd__a21o_2
X_4383_ _4383_/A VGND VGND VPWR VPWR _8129_/D sky130_fd_sc_hd__buf_1
XFILLER_58_407 VGND VGND VPWR VPWR sky130_fd_sc_hd__decap_3
X_6122_ _6118_/X _6120_/Y _6121_/Y VGND VGND VPWR VPWR _6122_/Y sky130_fd_sc_hd__o21ai_2
XFILLER_112_386 VGND VGND VPWR VPWR sky130_fd_sc_hd__decap_3
XFILLER_85_215 VGND VGND VPWR VPWR sky130_fd_sc_hd__decap_3
XFILLER_86_727 VGND VGND VPWR VPWR sky130_fd_sc_hd__decap_3
XFILLER_98_576 VGND VGND VPWR VPWR sky130_fd_sc_hd__decap_3
XFILLER_98_598 VGND VGND VPWR VPWR sky130_fd_sc_hd__decap_3
X_6053_ _8177_/Q _8241_/Q VGND VGND VPWR VPWR _6053_/X sky130_fd_sc_hd__and2_2
XFILLER_39_632 VGND VGND VPWR VPWR sky130_fd_sc_hd__decap_3
XFILLER_85_237 VGND VGND VPWR VPWR sky130_fd_sc_hd__decap_3
X_5004_ _5004_/A _5004_/B VGND VGND VPWR VPWR _5004_/Y sky130_fd_sc_hd__nor2_2
XFILLER_38_153 VGND VGND VPWR VPWR sky130_fd_sc_hd__decap_3
XFILLER_66_462 VGND VGND VPWR VPWR sky130_fd_sc_hd__decap_3
XFILLER_26_315 VGND VGND VPWR VPWR sky130_fd_sc_hd__fill_1
XFILLER_26_337 VGND VGND VPWR VPWR sky130_fd_sc_hd__decap_3
XFILLER_38_197 VGND VGND VPWR VPWR sky130_fd_sc_hd__decap_3
XFILLER_54_635 VGND VGND VPWR VPWR sky130_fd_sc_hd__decap_3
XFILLER_66_495 VGND VGND VPWR VPWR sky130_fd_sc_hd__decap_3
XFILLER_93_281 VGND VGND VPWR VPWR sky130_fd_sc_hd__decap_3
XFILLER_53_145 VGND VGND VPWR VPWR sky130_fd_sc_hd__decap_3
X_6955_ _6955_/A _6955_/B _6954_/X VGND VGND VPWR VPWR _6955_/X sky130_fd_sc_hd__or3b_4
XFILLER_22_510 VGND VGND VPWR VPWR sky130_fd_sc_hd__decap_3
XFILLER_34_370 VGND VGND VPWR VPWR sky130_fd_sc_hd__decap_3
XFILLER_53_178 VGND VGND VPWR VPWR sky130_fd_sc_hd__decap_3
XFILLER_81_487 VGND VGND VPWR VPWR sky130_fd_sc_hd__decap_3
X_5906_ _8173_/Q _8237_/Q VGND VGND VPWR VPWR _5906_/X sky130_fd_sc_hd__and2_2
X_6886_ _7619_/A _8264_/Q VGND VGND VPWR VPWR _6886_/Y sky130_fd_sc_hd__nor2_2
XFILLER_10_727 VGND VGND VPWR VPWR sky130_fd_sc_hd__decap_3
XFILLER_22_554 VGND VGND VPWR VPWR sky130_fd_sc_hd__decap_3
X_5837_ _5508_/A _5801_/Y _5804_/Y _5805_/X _5836_/X VGND VGND VPWR VPWR _5838_/B
+ sky130_fd_sc_hd__o221a_2
XTAP_TAPCELL_ROW_62_1068 VGND VPWR sky130_fd_sc_hd__tapvpwrvgnd_1
Xrebuffer313 _8171_/Q VGND VGND VPWR VPWR _5943_/C sky130_fd_sc_hd__buf_2
X_5768_ _7776_/B _8234_/Q _8288_/Q VGND VGND VPWR VPWR _5768_/X sky130_fd_sc_hd__mux2_2
X_7507_ _7193_/A _6423_/X _6428_/X _7506_/Y VGND VGND VPWR VPWR _7507_/Y sky130_fd_sc_hd__a22oi_2
Xrebuffer346 _7630_/C VGND VGND VPWR VPWR _7639_/B sky130_fd_sc_hd__buf_2
Xrebuffer324 _7179_/X VGND VGND VPWR VPWR _7180_/B sky130_fd_sc_hd__buf_2
X_4719_ _4719_/A VGND VGND VPWR VPWR _7844_/A sky130_fd_sc_hd__clkbuf_2
XFILLER_107_125 VGND VGND VPWR VPWR sky130_fd_sc_hd__decap_3
XFILLER_108_648 VGND VGND VPWR VPWR sky130_fd_sc_hd__decap_3
X_7438_ _8215_/Q _8216_/Q _7438_/C VGND VGND VPWR VPWR _7472_/B sky130_fd_sc_hd__and3_2
X_5699_ _6769_/A _6462_/B _5696_/Y _5698_/X _5415_/A VGND VGND VPWR VPWR _5699_/X
+ sky130_fd_sc_hd__o32a_2
XFILLER_107_169 VGND VGND VPWR VPWR sky130_fd_sc_hd__decap_3
XFILLER_116_681 VGND VGND VPWR VPWR sky130_fd_sc_hd__decap_3
X_7369_ _7370_/B _7370_/C _7398_/C VGND VGND VPWR VPWR _7369_/Y sky130_fd_sc_hd__a21oi_2
XFILLER_103_320 VGND VGND VPWR VPWR sky130_fd_sc_hd__decap_3
XFILLER_115_191 VGND VGND VPWR VPWR sky130_fd_sc_hd__decap_3
XFILLER_1_447 VGND VGND VPWR VPWR sky130_fd_sc_hd__fill_1
XFILLER_89_554 VGND VGND VPWR VPWR sky130_fd_sc_hd__decap_3
XFILLER_103_386 VGND VGND VPWR VPWR sky130_fd_sc_hd__decap_3
XFILLER_39_44 VGND VGND VPWR VPWR sky130_fd_sc_hd__decap_3
XFILLER_39_66 VGND VGND VPWR VPWR sky130_fd_sc_hd__decap_3
XFILLER_49_407 VGND VGND VPWR VPWR sky130_fd_sc_hd__decap_3
XFILLER_49_429 VGND VGND VPWR VPWR sky130_fd_sc_hd__decap_3
XFILLER_76_215 VGND VGND VPWR VPWR sky130_fd_sc_hd__fill_1
XFILLER_77_716 VGND VGND VPWR VPWR sky130_fd_sc_hd__fill_1
XFILLER_89_598 VGND VGND VPWR VPWR sky130_fd_sc_hd__decap_3
XFILLER_39_99 VGND VGND VPWR VPWR sky130_fd_sc_hd__decap_3
XFILLER_45_602 VGND VGND VPWR VPWR sky130_fd_sc_hd__decap_3
XFILLER_17_337 VGND VGND VPWR VPWR sky130_fd_sc_hd__fill_1
XFILLER_29_175 VGND VGND VPWR VPWR sky130_fd_sc_hd__fill_2
XFILLER_72_421 VGND VGND VPWR VPWR sky130_fd_sc_hd__decap_3
XFILLER_45_657 VGND VGND VPWR VPWR sky130_fd_sc_hd__decap_3
XFILLER_72_443 VGND VGND VPWR VPWR sky130_fd_sc_hd__fill_1
XFILLER_32_318 VGND VGND VPWR VPWR sky130_fd_sc_hd__decap_3
XFILLER_60_616 VGND VGND VPWR VPWR sky130_fd_sc_hd__decap_3
XFILLER_72_498 VGND VGND VPWR VPWR sky130_fd_sc_hd__fill_2
XPHY_EDGE_ROW_105_Right_105 VGND VGND VPWR VPWR sky130_fd_sc_hd__decap_3
XTAP_TAPCELL_ROW_43_814 VGND VPWR sky130_fd_sc_hd__tapvpwrvgnd_1
XFILLER_71_20 VGND VGND VPWR VPWR sky130_fd_sc_hd__fill_2
XFILLER_71_31 VGND VGND VPWR VPWR sky130_fd_sc_hd__decap_3
XFILLER_40_351 VGND VGND VPWR VPWR sky130_fd_sc_hd__decap_3
XFILLER_13_587 VGND VGND VPWR VPWR sky130_fd_sc_hd__decap_3
XFILLER_13_598 VGND VGND VPWR VPWR sky130_fd_sc_hd__decap_3
XFILLER_40_373 VGND VGND VPWR VPWR sky130_fd_sc_hd__decap_3
XFILLER_71_75 VGND VGND VPWR VPWR sky130_fd_sc_hd__decap_3
XFILLER_9_536 VGND VGND VPWR VPWR sky130_fd_sc_hd__decap_3
XFILLER_9_558 VGND VGND VPWR VPWR sky130_fd_sc_hd__fill_2
XTAP_TAPCELL_ROW_23_560 VGND VPWR sky130_fd_sc_hd__tapvpwrvgnd_1
XFILLER_99_307 VGND VGND VPWR VPWR sky130_fd_sc_hd__decap_3
XFILLER_107_681 VGND VGND VPWR VPWR sky130_fd_sc_hd__decap_3
XFILLER_4_274 VGND VGND VPWR VPWR sky130_fd_sc_hd__decap_3
XFILLER_99_329 VGND VGND VPWR VPWR sky130_fd_sc_hd__decap_3
XFILLER_106_180 VGND VGND VPWR VPWR sky130_fd_sc_hd__decap_3
XFILLER_0_491 VGND VGND VPWR VPWR sky130_fd_sc_hd__fill_2
XFILLER_67_237 VGND VGND VPWR VPWR sky130_fd_sc_hd__decap_3
XFILLER_95_557 VGND VGND VPWR VPWR sky130_fd_sc_hd__decap_3
XFILLER_96_72 VGND VGND VPWR VPWR sky130_fd_sc_hd__decap_3
XFILLER_96_83 VGND VGND VPWR VPWR sky130_fd_sc_hd__fill_1
XFILLER_48_451 VGND VGND VPWR VPWR sky130_fd_sc_hd__decap_3
XFILLER_48_473 VGND VGND VPWR VPWR sky130_fd_sc_hd__decap_3
XFILLER_48_495 VGND VGND VPWR VPWR sky130_fd_sc_hd__decap_3
XFILLER_63_410 VGND VGND VPWR VPWR sky130_fd_sc_hd__decap_3
XFILLER_75_270 VGND VGND VPWR VPWR sky130_fd_sc_hd__decap_3
XFILLER_75_281 VGND VGND VPWR VPWR sky130_fd_sc_hd__decap_3
XFILLER_82_218 VGND VGND VPWR VPWR sky130_fd_sc_hd__decap_3
XFILLER_35_123 VGND VGND VPWR VPWR sky130_fd_sc_hd__decap_3
XFILLER_51_605 VGND VGND VPWR VPWR sky130_fd_sc_hd__decap_3
XFILLER_63_443 VGND VGND VPWR VPWR sky130_fd_sc_hd__decap_3
XFILLER_23_329 VGND VGND VPWR VPWR sky130_fd_sc_hd__decap_3
X_6740_ _6070_/B _5475_/B _5478_/X _5477_/X VGND VGND VPWR VPWR _6740_/X sky130_fd_sc_hd__a22o_2
XFILLER_16_381 VGND VGND VPWR VPWR sky130_fd_sc_hd__decap_3
XFILLER_50_137 VGND VGND VPWR VPWR sky130_fd_sc_hd__decap_3
XFILLER_90_284 VGND VGND VPWR VPWR sky130_fd_sc_hd__decap_3
XFILLER_31_340 VGND VGND VPWR VPWR sky130_fd_sc_hd__fill_1
X_6671_ _6334_/A _6656_/Y _6670_/X _5614_/X _8194_/Q VGND VGND VPWR VPWR _6671_/Y
+ sky130_fd_sc_hd__o221ai_2
XFILLER_31_373 VGND VGND VPWR VPWR sky130_fd_sc_hd__decap_3
X_5622_ _7619_/A _5619_/X _5621_/X VGND VGND VPWR VPWR _5622_/X sky130_fd_sc_hd__a21o_2
X_8341_ _8353_/CLK _8341_/D VGND VGND VPWR VPWR _8341_/Q sky130_fd_sc_hd__dfxtp_2
X_5553_ _5265_/X _5266_/X _5246_/X _5247_/X _7783_/A _5596_/S VGND VGND VPWR VPWR
+ _5553_/X sky130_fd_sc_hd__mux4_2
XFILLER_117_412 VGND VGND VPWR VPWR sky130_fd_sc_hd__fill_1
X_4504_ _7898_/B _8056_/Q VGND VGND VPWR VPWR _4505_/A sky130_fd_sc_hd__and2_2
X_8272_ _8355_/CLK _8272_/D VGND VGND VPWR VPWR _8272_/Q sky130_fd_sc_hd__dfxtp_2
X_5484_ _8164_/Q _8163_/Q _5484_/S VGND VGND VPWR VPWR _5484_/X sky130_fd_sc_hd__mux2_2
XFILLER_105_629 VGND VGND VPWR VPWR sky130_fd_sc_hd__decap_3
XTAP_TAPCELL_ROW_113_1732 VGND VPWR sky130_fd_sc_hd__tapvpwrvgnd_1
X_7223_ _8208_/Q _8209_/Q _7223_/C VGND VGND VPWR VPWR _7223_/X sky130_fd_sc_hd__and3_2
X_4435_ _4435_/A VGND VGND VPWR VPWR _8155_/D sky130_fd_sc_hd__buf_1
XFILLER_104_139 VGND VGND VPWR VPWR sky130_fd_sc_hd__fill_1
XFILLER_116_27 VGND VGND VPWR VPWR sky130_fd_sc_hd__fill_1
XFILLER_116_38 VGND VGND VPWR VPWR sky130_fd_sc_hd__fill_2
X_7154_ _7154_/A _7154_/B _7154_/C VGND VGND VPWR VPWR _7154_/X sky130_fd_sc_hd__and3_2
X_4366_ _7930_/B _4366_/B VGND VGND VPWR VPWR _4367_/A sky130_fd_sc_hd__and2_2
XFILLER_112_150 VGND VGND VPWR VPWR sky130_fd_sc_hd__fill_1
XFILLER_113_673 VGND VGND VPWR VPWR sky130_fd_sc_hd__decap_3
XFILLER_59_716 VGND VGND VPWR VPWR sky130_fd_sc_hd__decap_3
XFILLER_86_513 VGND VGND VPWR VPWR sky130_fd_sc_hd__decap_3
XFILLER_98_362 VGND VGND VPWR VPWR sky130_fd_sc_hd__fill_2
XFILLER_98_384 VGND VGND VPWR VPWR sky130_fd_sc_hd__decap_3
X_6105_ _6104_/X _6012_/X _5956_/X _5860_/X _7812_/A _7670_/A VGND VGND VPWR VPWR
+ _6105_/X sky130_fd_sc_hd__mux4_2
XFILLER_112_183 VGND VGND VPWR VPWR sky130_fd_sc_hd__decap_3
XFILLER_86_557 VGND VGND VPWR VPWR sky130_fd_sc_hd__decap_3
X_7085_ _8203_/Q _8267_/Q _7084_/X VGND VGND VPWR VPWR _7085_/X sky130_fd_sc_hd__a21o_2
X_4297_ _4297_/A VGND VGND VPWR VPWR _8086_/D sky130_fd_sc_hd__buf_1
XFILLER_100_345 VGND VGND VPWR VPWR sky130_fd_sc_hd__decap_3
XFILLER_58_259 VGND VGND VPWR VPWR sky130_fd_sc_hd__decap_3
XFILLER_73_207 VGND VGND VPWR VPWR sky130_fd_sc_hd__decap_3
X_6036_ _6769_/B _6032_/X _6035_/X _8289_/Q VGND VGND VPWR VPWR _6036_/X sky130_fd_sc_hd__a2bb2o_2
XFILLER_100_389 VGND VGND VPWR VPWR sky130_fd_sc_hd__decap_3
XFILLER_39_473 VGND VGND VPWR VPWR sky130_fd_sc_hd__fill_1
XFILLER_39_495 VGND VGND VPWR VPWR sky130_fd_sc_hd__fill_2
XFILLER_54_421 VGND VGND VPWR VPWR sky130_fd_sc_hd__decap_3
XFILLER_26_134 VGND VGND VPWR VPWR sky130_fd_sc_hd__decap_3
XFILLER_54_443 VGND VGND VPWR VPWR sky130_fd_sc_hd__decap_3
XFILLER_81_240 VGND VGND VPWR VPWR sky130_fd_sc_hd__decap_3
XTAP_TAPCELL_ROW_1_266 VGND VPWR sky130_fd_sc_hd__tapvpwrvgnd_1
XFILLER_14_318 VGND VGND VPWR VPWR sky130_fd_sc_hd__fill_2
XFILLER_42_627 VGND VGND VPWR VPWR sky130_fd_sc_hd__decap_3
XFILLER_54_498 VGND VGND VPWR VPWR sky130_fd_sc_hd__decap_3
XFILLER_81_273 VGND VGND VPWR VPWR sky130_fd_sc_hd__decap_3
X_7987_ _8390_/CLK _7987_/D VGND VGND VPWR VPWR _7987_/Q sky130_fd_sc_hd__dfxtp_2
XTAP_TAPCELL_ROW_1_277 VGND VPWR sky130_fd_sc_hd__tapvpwrvgnd_1
XFILLER_25_79 VGND VGND VPWR VPWR sky130_fd_sc_hd__decap_3
XFILLER_41_126 VGND VGND VPWR VPWR sky130_fd_sc_hd__decap_3
XFILLER_81_284 VGND VGND VPWR VPWR sky130_fd_sc_hd__decap_3
X_6938_ _8288_/Q _4817_/A _6937_/X _5601_/A _4820_/A VGND VGND VPWR VPWR _6938_/X
+ sky130_fd_sc_hd__o32a_2
X_6869_ _7193_/A _5633_/X _5649_/X _6868_/Y VGND VGND VPWR VPWR _6869_/X sky130_fd_sc_hd__a22o_2
XFILLER_10_513 VGND VGND VPWR VPWR sky130_fd_sc_hd__decap_3
XFILLER_50_682 VGND VGND VPWR VPWR sky130_fd_sc_hd__decap_3
XFILLER_108_401 VGND VGND VPWR VPWR sky130_fd_sc_hd__decap_3
XFILLER_108_434 VGND VGND VPWR VPWR sky130_fd_sc_hd__decap_3
XFILLER_6_528 VGND VGND VPWR VPWR sky130_fd_sc_hd__decap_3
XFILLER_108_467 VGND VGND VPWR VPWR sky130_fd_sc_hd__decap_3
XFILLER_108_489 VGND VGND VPWR VPWR sky130_fd_sc_hd__fill_1
XTAP_TAPCELL_ROW_75_1237 VGND VPWR sky130_fd_sc_hd__tapvpwrvgnd_1
XFILLER_104_651 VGND VGND VPWR VPWR sky130_fd_sc_hd__decap_3
XFILLER_1_222 VGND VGND VPWR VPWR sky130_fd_sc_hd__fill_2
XTAP_TAPCELL_ROW_9_377 VGND VPWR sky130_fd_sc_hd__tapvpwrvgnd_1
XFILLER_103_161 VGND VGND VPWR VPWR sky130_fd_sc_hd__decap_3
XFILLER_103_172 VGND VGND VPWR VPWR sky130_fd_sc_hd__fill_2
XFILLER_49_248 VGND VGND VPWR VPWR sky130_fd_sc_hd__decap_3
XFILLER_66_20 VGND VGND VPWR VPWR sky130_fd_sc_hd__fill_1
XFILLER_92_505 VGND VGND VPWR VPWR sky130_fd_sc_hd__fill_2
XFILLER_92_516 VGND VGND VPWR VPWR sky130_fd_sc_hd__decap_3
XFILLER_57_281 VGND VGND VPWR VPWR sky130_fd_sc_hd__decap_3
XFILLER_64_218 VGND VGND VPWR VPWR sky130_fd_sc_hd__decap_3
XFILLER_66_97 VGND VGND VPWR VPWR sky130_fd_sc_hd__fill_2
XFILLER_17_145 VGND VGND VPWR VPWR sky130_fd_sc_hd__decap_3
XFILLER_17_178 VGND VGND VPWR VPWR sky130_fd_sc_hd__decap_3
XFILLER_60_413 VGND VGND VPWR VPWR sky130_fd_sc_hd__decap_3
XTAP_TAPCELL_ROW_86_1377 VGND VPWR sky130_fd_sc_hd__tapvpwrvgnd_1
XTAP_TAPCELL_ROW_56_983 VGND VPWR sky130_fd_sc_hd__tapvpwrvgnd_1
XFILLER_26_690 VGND VGND VPWR VPWR sky130_fd_sc_hd__decap_3
XFILLER_32_137 VGND VGND VPWR VPWR sky130_fd_sc_hd__decap_3
XFILLER_60_424 VGND VGND VPWR VPWR sky130_fd_sc_hd__decap_3
XFILLER_82_85 VGND VGND VPWR VPWR sky130_fd_sc_hd__decap_3
XFILLER_13_373 VGND VGND VPWR VPWR sky130_fd_sc_hd__decap_3
XFILLER_9_388 VGND VGND VPWR VPWR sky130_fd_sc_hd__decap_3
XFILLER_9_399 VGND VGND VPWR VPWR sky130_fd_sc_hd__decap_3
XFILLER_5_561 VGND VGND VPWR VPWR sky130_fd_sc_hd__fill_2
XFILLER_99_104 VGND VGND VPWR VPWR sky130_fd_sc_hd__decap_3
XFILLER_114_437 VGND VGND VPWR VPWR sky130_fd_sc_hd__fill_2
XFILLER_114_459 VGND VGND VPWR VPWR sky130_fd_sc_hd__decap_3
XFILLER_99_137 VGND VGND VPWR VPWR sky130_fd_sc_hd__decap_3
X_4220_ _7898_/B _4220_/B VGND VGND VPWR VPWR _4221_/A sky130_fd_sc_hd__and2_2
XFILLER_110_621 VGND VGND VPWR VPWR sky130_fd_sc_hd__decap_3
XFILLER_68_557 VGND VGND VPWR VPWR sky130_fd_sc_hd__decap_3
X_4151_ _4151_/A VGND VGND VPWR VPWR _8013_/D sky130_fd_sc_hd__buf_1
XFILLER_110_654 VGND VGND VPWR VPWR sky130_fd_sc_hd__decap_3
XFILLER_110_676 VGND VGND VPWR VPWR sky130_fd_sc_hd__decap_3
XFILLER_55_207 VGND VGND VPWR VPWR sky130_fd_sc_hd__decap_3
XFILLER_95_343 VGND VGND VPWR VPWR sky130_fd_sc_hd__decap_3
XFILLER_95_376 VGND VGND VPWR VPWR sky130_fd_sc_hd__decap_3
X_4082_ _7898_/B _8382_/Q VGND VGND VPWR VPWR _4083_/A sky130_fd_sc_hd__and2_2
XFILLER_110_687 VGND VGND VPWR VPWR sky130_fd_sc_hd__decap_3
X_7910_ _8325_/Q _7930_/B VGND VGND VPWR VPWR _7911_/A sky130_fd_sc_hd__and2_2
XFILLER_36_421 VGND VGND VPWR VPWR sky130_fd_sc_hd__decap_3
XFILLER_36_454 VGND VGND VPWR VPWR sky130_fd_sc_hd__decap_3
XFILLER_48_292 VGND VGND VPWR VPWR sky130_fd_sc_hd__decap_3
X_7841_ _5951_/A _8223_/Q _7646_/B _7840_/X VGND VGND VPWR VPWR _7841_/X sky130_fd_sc_hd__o31a_4
XFILLER_102_29 VGND VGND VPWR VPWR sky130_fd_sc_hd__decap_3
XFILLER_24_616 VGND VGND VPWR VPWR sky130_fd_sc_hd__decap_3
XFILLER_36_487 VGND VGND VPWR VPWR sky130_fd_sc_hd__decap_3
XFILLER_51_402 VGND VGND VPWR VPWR sky130_fd_sc_hd__decap_3
XFILLER_63_240 VGND VGND VPWR VPWR sky130_fd_sc_hd__decap_3
XFILLER_17_690 VGND VGND VPWR VPWR sky130_fd_sc_hd__decap_3
XFILLER_24_638 VGND VGND VPWR VPWR sky130_fd_sc_hd__decap_3
XFILLER_51_435 VGND VGND VPWR VPWR sky130_fd_sc_hd__decap_3
XFILLER_63_284 VGND VGND VPWR VPWR sky130_fd_sc_hd__decap_3
XFILLER_63_295 VGND VGND VPWR VPWR sky130_fd_sc_hd__decap_3
X_7772_ _5950_/A _7770_/Y _7771_/Y _7796_/A VGND VGND VPWR VPWR _7772_/X sky130_fd_sc_hd__a22o_2
X_4984_ _4982_/Y _4983_/Y _7372_/A VGND VGND VPWR VPWR _4984_/Y sky130_fd_sc_hd__o21ai_2
XFILLER_23_159 VGND VGND VPWR VPWR sky130_fd_sc_hd__decap_3
XFILLER_51_479 VGND VGND VPWR VPWR sky130_fd_sc_hd__decap_3
X_6723_ _8258_/Q _6727_/C VGND VGND VPWR VPWR _6726_/A sky130_fd_sc_hd__or2_2
XFILLER_32_693 VGND VGND VPWR VPWR sky130_fd_sc_hd__decap_3
X_6654_ _8191_/Q _8192_/Q _8193_/Q VGND VGND VPWR VPWR _6655_/D sky130_fd_sc_hd__or3_2
XTAP_TAPCELL_ROW_34_699 VGND VPWR sky130_fd_sc_hd__tapvpwrvgnd_1
X_5605_ _5590_/X _5593_/X _5596_/X _5488_/X _5604_/X VGND VGND VPWR VPWR _5605_/X
+ sky130_fd_sc_hd__a221o_2
XFILLER_118_710 VGND VGND VPWR VPWR sky130_fd_sc_hd__decap_3
X_6585_ _8191_/Q _8255_/Q _6999_/A1 VGND VGND VPWR VPWR _6585_/X sky130_fd_sc_hd__o21a_2
XFILLER_117_231 VGND VGND VPWR VPWR sky130_fd_sc_hd__decap_3
XFILLER_11_37 VGND VGND VPWR VPWR sky130_fd_sc_hd__decap_3
X_8324_ _8392_/CLK _8324_/D VGND VGND VPWR VPWR _8324_/Q sky130_fd_sc_hd__dfxtp_2
X_5536_ _7475_/A VGND VGND VPWR VPWR _6717_/A sky130_fd_sc_hd__buf_1
X_8255_ _8389_/CLK _8255_/D VGND VGND VPWR VPWR _8255_/Q sky130_fd_sc_hd__dfxtp_2
X_5467_ _5465_/X _5466_/X _6507_/S VGND VGND VPWR VPWR _5468_/B sky130_fd_sc_hd__mux2_2
XFILLER_105_459 VGND VGND VPWR VPWR sky130_fd_sc_hd__decap_3
X_7206_ _7222_/B _7163_/A _7223_/C _8208_/Q VGND VGND VPWR VPWR _7206_/X sky130_fd_sc_hd__a31o_2
X_4418_ _7843_/A _4418_/B VGND VGND VPWR VPWR _4419_/A sky130_fd_sc_hd__and2_2
XFILLER_99_671 VGND VGND VPWR VPWR sky130_fd_sc_hd__fill_1
X_8186_ _8224_/CLK _8186_/D VGND VGND VPWR VPWR _8186_/Q sky130_fd_sc_hd__dfxtp_2
X_5398_ _5398_/A VGND VGND VPWR VPWR _5600_/A sky130_fd_sc_hd__buf_1
XFILLER_101_610 VGND VGND VPWR VPWR sky130_fd_sc_hd__fill_1
XFILLER_59_535 VGND VGND VPWR VPWR sky130_fd_sc_hd__decap_3
XFILLER_86_321 VGND VGND VPWR VPWR sky130_fd_sc_hd__decap_3
X_7137_ _8208_/Q _5397_/A _5618_/A _8272_/Q VGND VGND VPWR VPWR _7137_/X sky130_fd_sc_hd__a2bb2o_2
X_4349_ _4349_/A VGND VGND VPWR VPWR _8112_/D sky130_fd_sc_hd__buf_1
XTAP_TAPCELL_ROW_6_336 VGND VPWR sky130_fd_sc_hd__tapvpwrvgnd_1
XFILLER_100_120 VGND VGND VPWR VPWR sky130_fd_sc_hd__fill_1
XFILLER_101_654 VGND VGND VPWR VPWR sky130_fd_sc_hd__fill_1
XFILLER_59_568 VGND VGND VPWR VPWR sky130_fd_sc_hd__decap_3
XFILLER_86_365 VGND VGND VPWR VPWR sky130_fd_sc_hd__decap_3
X_7068_ _8204_/Q _8205_/Q _7068_/C _7068_/D VGND VGND VPWR VPWR _7128_/C sky130_fd_sc_hd__and4_2
XTAP_TAPCELL_ROW_70_1167 VGND VPWR sky130_fd_sc_hd__tapvpwrvgnd_1
XFILLER_101_698 VGND VGND VPWR VPWR sky130_fd_sc_hd__fill_2
XFILLER_36_12 VGND VGND VPWR VPWR sky130_fd_sc_hd__decap_3
XFILLER_39_270 VGND VGND VPWR VPWR sky130_fd_sc_hd__decap_3
XFILLER_86_398 VGND VGND VPWR VPWR sky130_fd_sc_hd__decap_3
X_6019_ _6109_/A _6018_/X _5857_/A VGND VGND VPWR VPWR _6019_/Y sky130_fd_sc_hd__o21ai_2
XFILLER_100_197 VGND VGND VPWR VPWR sky130_fd_sc_hd__decap_3
XFILLER_36_45 VGND VGND VPWR VPWR sky130_fd_sc_hd__decap_3
XFILLER_39_281 VGND VGND VPWR VPWR sky130_fd_sc_hd__decap_3
XFILLER_27_487 VGND VGND VPWR VPWR sky130_fd_sc_hd__decap_3
XFILLER_36_78 VGND VGND VPWR VPWR sky130_fd_sc_hd__decap_3
XFILLER_54_262 VGND VGND VPWR VPWR sky130_fd_sc_hd__fill_2
XFILLER_14_126 VGND VGND VPWR VPWR sky130_fd_sc_hd__decap_3
XFILLER_42_424 VGND VGND VPWR VPWR sky130_fd_sc_hd__decap_3
XTAP_TAPCELL_ROW_53_942 VGND VPWR sky130_fd_sc_hd__tapvpwrvgnd_1
XFILLER_14_159 VGND VGND VPWR VPWR sky130_fd_sc_hd__decap_3
XTAP_TAPCELL_ROW_53_953 VGND VPWR sky130_fd_sc_hd__tapvpwrvgnd_1
XFILLER_22_170 VGND VGND VPWR VPWR sky130_fd_sc_hd__decap_3
XFILLER_22_181 VGND VGND VPWR VPWR sky130_fd_sc_hd__decap_3
XFILLER_52_88 VGND VGND VPWR VPWR sky130_fd_sc_hd__decap_3
XFILLER_109_732 VGND VGND VPWR VPWR sky130_fd_sc_hd__fill_1
XFILLER_10_365 VGND VGND VPWR VPWR sky130_fd_sc_hd__decap_3
XFILLER_108_242 VGND VGND VPWR VPWR sky130_fd_sc_hd__decap_3
XFILLER_108_253 VGND VGND VPWR VPWR sky130_fd_sc_hd__fill_1
XFILLER_6_347 VGND VGND VPWR VPWR sky130_fd_sc_hd__decap_3
XFILLER_2_531 VGND VGND VPWR VPWR sky130_fd_sc_hd__fill_1
XFILLER_111_418 VGND VGND VPWR VPWR sky130_fd_sc_hd__fill_1
XFILLER_117_92 VGND VGND VPWR VPWR sky130_fd_sc_hd__decap_3
XFILLER_77_332 VGND VGND VPWR VPWR sky130_fd_sc_hd__decap_3
XFILLER_77_41 VGND VGND VPWR VPWR sky130_fd_sc_hd__decap_3
XFILLER_77_63 VGND VGND VPWR VPWR sky130_fd_sc_hd__decap_3
XFILLER_89_181 VGND VGND VPWR VPWR sky130_fd_sc_hd__decap_3
XFILLER_65_505 VGND VGND VPWR VPWR sky130_fd_sc_hd__decap_3
XFILLER_77_343 VGND VGND VPWR VPWR sky130_fd_sc_hd__decap_3
XTAP_TAPCELL_ROW_88_1406 VGND VPWR sky130_fd_sc_hd__tapvpwrvgnd_1
XFILLER_37_207 VGND VGND VPWR VPWR sky130_fd_sc_hd__decap_3
XFILLER_77_387 VGND VGND VPWR VPWR sky130_fd_sc_hd__decap_3
XFILLER_65_549 VGND VGND VPWR VPWR sky130_fd_sc_hd__decap_3
XFILLER_33_402 VGND VGND VPWR VPWR sky130_fd_sc_hd__decap_3
XFILLER_45_240 VGND VGND VPWR VPWR sky130_fd_sc_hd__decap_3
XFILLER_92_368 VGND VGND VPWR VPWR sky130_fd_sc_hd__decap_3
XFILLER_93_84 VGND VGND VPWR VPWR sky130_fd_sc_hd__decap_3
XFILLER_33_435 VGND VGND VPWR VPWR sky130_fd_sc_hd__decap_3
XFILLER_45_273 VGND VGND VPWR VPWR sky130_fd_sc_hd__decap_3
XFILLER_45_284 VGND VGND VPWR VPWR sky130_fd_sc_hd__decap_3
XFILLER_60_221 VGND VGND VPWR VPWR sky130_fd_sc_hd__decap_3
XFILLER_33_479 VGND VGND VPWR VPWR sky130_fd_sc_hd__decap_3
XFILLER_20_129 VGND VGND VPWR VPWR sky130_fd_sc_hd__decap_3
XFILLER_60_298 VGND VGND VPWR VPWR sky130_fd_sc_hd__decap_3
Xclkbuf_leaf_40_clk clkload0/A VGND VGND VPWR VPWR clkload8/A sky130_fd_sc_hd__clkbuf_8
XTAP_TAPCELL_ROW_31_658 VGND VPWR sky130_fd_sc_hd__tapvpwrvgnd_1
XFILLER_119_529 VGND VGND VPWR VPWR sky130_fd_sc_hd__decap_3
XTAP_TAPCELL_ROW_99_1546 VGND VPWR sky130_fd_sc_hd__tapvpwrvgnd_1
X_6370_ _8186_/Q _8250_/Q _8288_/Q VGND VGND VPWR VPWR _6370_/X sky130_fd_sc_hd__mux2_2
X_5321_ split/X _5411_/B VGND VGND VPWR VPWR _5417_/B sky130_fd_sc_hd__nor2_2
XFILLER_114_223 VGND VGND VPWR VPWR sky130_fd_sc_hd__decap_3
XFILLER_5_391 VGND VGND VPWR VPWR sky130_fd_sc_hd__fill_1
XFILLER_88_608 VGND VGND VPWR VPWR sky130_fd_sc_hd__fill_1
X_8040_ _8187_/CLK _8040_/D VGND VGND VPWR VPWR _8040_/Q sky130_fd_sc_hd__dfxtp_2
XFILLER_102_407 VGND VGND VPWR VPWR sky130_fd_sc_hd__decap_3
X_5252_ _8163_/Q _8164_/Q _7805_/A VGND VGND VPWR VPWR _5252_/X sky130_fd_sc_hd__mux2_2
XFILLER_68_321 VGND VGND VPWR VPWR sky130_fd_sc_hd__decap_3
XFILLER_96_630 VGND VGND VPWR VPWR sky130_fd_sc_hd__decap_3
X_5183_ _5528_/A VGND VGND VPWR VPWR _6623_/A sky130_fd_sc_hd__inv_2
X_4203_ _4203_/A VGND VGND VPWR VPWR _8039_/D sky130_fd_sc_hd__buf_1
XFILLER_29_708 VGND VGND VPWR VPWR sky130_fd_sc_hd__decap_3
XFILLER_56_505 VGND VGND VPWR VPWR sky130_fd_sc_hd__decap_3
XFILLER_68_365 VGND VGND VPWR VPWR sky130_fd_sc_hd__decap_3
XFILLER_96_663 VGND VGND VPWR VPWR sky130_fd_sc_hd__decap_3
X_4134_ _7930_/B _7937_/Q VGND VGND VPWR VPWR _4135_/A sky130_fd_sc_hd__and2_2
XFILLER_3_93 VGND VGND VPWR VPWR sky130_fd_sc_hd__decap_3
XFILLER_56_527 VGND VGND VPWR VPWR sky130_fd_sc_hd__decap_3
XFILLER_83_324 VGND VGND VPWR VPWR sky130_fd_sc_hd__decap_3
XFILLER_95_151 VGND VGND VPWR VPWR sky130_fd_sc_hd__decap_3
XFILLER_96_685 VGND VGND VPWR VPWR sky130_fd_sc_hd__decap_3
XFILLER_113_39 VGND VGND VPWR VPWR sky130_fd_sc_hd__fill_1
XFILLER_49_590 VGND VGND VPWR VPWR sky130_fd_sc_hd__fill_1
XFILLER_56_549 VGND VGND VPWR VPWR sky130_fd_sc_hd__decap_3
X_4065_ _4065_/A VGND VGND VPWR VPWR _7970_/D sky130_fd_sc_hd__buf_1
XTAP_TAPCELL_ROW_39_769 VGND VPWR sky130_fd_sc_hd__tapvpwrvgnd_1
XFILLER_36_251 VGND VGND VPWR VPWR sky130_fd_sc_hd__fill_1
XFILLER_64_560 VGND VGND VPWR VPWR sky130_fd_sc_hd__decap_3
XFILLER_71_508 VGND VGND VPWR VPWR sky130_fd_sc_hd__decap_3
XTAP_TAPCELL_ROW_108_1664 VGND VPWR sky130_fd_sc_hd__tapvpwrvgnd_1
XFILLER_24_424 VGND VGND VPWR VPWR sky130_fd_sc_hd__decap_3
XFILLER_24_435 VGND VGND VPWR VPWR sky130_fd_sc_hd__decap_3
XFILLER_36_273 VGND VGND VPWR VPWR sky130_fd_sc_hd__decap_3
XFILLER_36_284 VGND VGND VPWR VPWR sky130_fd_sc_hd__decap_3
XFILLER_91_390 VGND VGND VPWR VPWR sky130_fd_sc_hd__fill_2
X_7824_ _7786_/X _7823_/X _7824_/S VGND VGND VPWR VPWR _7824_/X sky130_fd_sc_hd__mux2_2
XFILLER_51_254 VGND VGND VPWR VPWR sky130_fd_sc_hd__decap_3
XFILLER_51_287 VGND VGND VPWR VPWR sky130_fd_sc_hd__decap_3
X_7755_ _7797_/A1 _7749_/X _7752_/Y _5363_/X _7754_/Y VGND VGND VPWR VPWR _7755_/X
+ sky130_fd_sc_hd__o221a_2
X_4967_ _5346_/A split/A VGND VGND VPWR VPWR _4967_/Y sky130_fd_sc_hd__nand2_2
XTAP_TAPCELL_ROW_50_912 VGND VPWR sky130_fd_sc_hd__tapvpwrvgnd_1
XFILLER_20_630 VGND VGND VPWR VPWR sky130_fd_sc_hd__decap_3
XFILLER_22_25 VGND VGND VPWR VPWR sky130_fd_sc_hd__decap_3
X_7686_ _7653_/X _8220_/Q _7655_/X _7684_/Y _7685_/X VGND VGND VPWR VPWR _7686_/X
+ sky130_fd_sc_hd__a311o_2
Xclkbuf_leaf_31_clk clkbuf_2_2__f_clk/X VGND VGND VPWR VPWR _8384_/CLK sky130_fd_sc_hd__clkbuf_8
X_6706_ _6705_/X _6572_/X _6706_/S VGND VGND VPWR VPWR _6706_/X sky130_fd_sc_hd__mux2_2
X_4898_ _8247_/Q _8183_/Q VGND VGND VPWR VPWR _6400_/C sky130_fd_sc_hd__or2b_2
X_6637_ _8257_/Q _5292_/X _5111_/X VGND VGND VPWR VPWR _6637_/X sky130_fd_sc_hd__a21o_2
XFILLER_20_696 VGND VGND VPWR VPWR sky130_fd_sc_hd__decap_3
X_6568_ _6792_/C _6568_/B VGND VGND VPWR VPWR _6568_/Y sky130_fd_sc_hd__xnor2_2
XTAP_TAPCELL_ROW_59_1029 VGND VPWR sky130_fd_sc_hd__tapvpwrvgnd_1
XFILLER_3_306 VGND VGND VPWR VPWR sky130_fd_sc_hd__decap_3
XFILLER_3_317 VGND VGND VPWR VPWR sky130_fd_sc_hd__fill_2
X_8307_ _8386_/CLK _8307_/D VGND VGND VPWR VPWR _8307_/Q sky130_fd_sc_hd__dfxtp_2
X_5519_ _5477_/X _5516_/X _5518_/X VGND VGND VPWR VPWR _5519_/Y sky130_fd_sc_hd__o21ai_2
XFILLER_105_223 VGND VGND VPWR VPWR sky130_fd_sc_hd__fill_1
XFILLER_105_234 VGND VGND VPWR VPWR sky130_fd_sc_hd__decap_3
X_6499_ _6504_/A2 _5618_/A _5332_/A _6496_/Y VGND VGND VPWR VPWR _6499_/X sky130_fd_sc_hd__a22o_2
XFILLER_105_278 VGND VGND VPWR VPWR sky130_fd_sc_hd__fill_2
X_8238_ clkload5/A _8238_/D VGND VGND VPWR VPWR _8238_/Q sky130_fd_sc_hd__dfxtp_2
X_8169_ clkload7/A _8169_/D VGND VGND VPWR VPWR _8169_/Q sky130_fd_sc_hd__dfxtp_4
XFILLER_47_22 VGND VGND VPWR VPWR sky130_fd_sc_hd__decap_3
XFILLER_47_505 VGND VGND VPWR VPWR sky130_fd_sc_hd__decap_3
XFILLER_87_663 VGND VGND VPWR VPWR sky130_fd_sc_hd__decap_3
XFILLER_101_484 VGND VGND VPWR VPWR sky130_fd_sc_hd__fill_2
XFILLER_19_218 VGND VGND VPWR VPWR sky130_fd_sc_hd__decap_3
XFILLER_47_55 VGND VGND VPWR VPWR sky130_fd_sc_hd__fill_1
XFILLER_59_365 VGND VGND VPWR VPWR sky130_fd_sc_hd__decap_3
XFILLER_74_324 VGND VGND VPWR VPWR sky130_fd_sc_hd__decap_3
XFILLER_74_357 VGND VGND VPWR VPWR sky130_fd_sc_hd__decap_3
XFILLER_27_240 VGND VGND VPWR VPWR sky130_fd_sc_hd__decap_3
XFILLER_47_99 VGND VGND VPWR VPWR sky130_fd_sc_hd__decap_3
XFILLER_55_571 VGND VGND VPWR VPWR sky130_fd_sc_hd__fill_2
XFILLER_62_519 VGND VGND VPWR VPWR sky130_fd_sc_hd__decap_3
XFILLER_74_368 VGND VGND VPWR VPWR sky130_fd_sc_hd__decap_3
XFILLER_27_284 VGND VGND VPWR VPWR sky130_fd_sc_hd__decap_3
XFILLER_63_32 VGND VGND VPWR VPWR sky130_fd_sc_hd__decap_3
XTAP_TAPCELL_ROW_83_1336 VGND VPWR sky130_fd_sc_hd__tapvpwrvgnd_1
XFILLER_70_541 VGND VGND VPWR VPWR sky130_fd_sc_hd__decap_3
XFILLER_70_563 VGND VGND VPWR VPWR sky130_fd_sc_hd__decap_3
XFILLER_30_405 VGND VGND VPWR VPWR sky130_fd_sc_hd__decap_3
XFILLER_30_427 VGND VGND VPWR VPWR sky130_fd_sc_hd__decap_3
XFILLER_63_98 VGND VGND VPWR VPWR sky130_fd_sc_hd__decap_3
XFILLER_23_490 VGND VGND VPWR VPWR sky130_fd_sc_hd__decap_3
XFILLER_8_38 VGND VGND VPWR VPWR sky130_fd_sc_hd__decap_3
Xclkbuf_leaf_22_clk clkload2/A VGND VGND VPWR VPWR _8397_/CLK sky130_fd_sc_hd__clkbuf_8
XFILLER_11_685 VGND VGND VPWR VPWR sky130_fd_sc_hd__decap_3
XFILLER_7_612 VGND VGND VPWR VPWR sky130_fd_sc_hd__decap_3
XFILLER_7_623 VGND VGND VPWR VPWR sky130_fd_sc_hd__decap_3
XFILLER_6_144 VGND VGND VPWR VPWR sky130_fd_sc_hd__decap_3
XFILLER_6_155 VGND VGND VPWR VPWR sky130_fd_sc_hd__decap_3
XFILLER_109_595 VGND VGND VPWR VPWR sky130_fd_sc_hd__decap_3
XFILLER_12_91 VGND VGND VPWR VPWR sky130_fd_sc_hd__decap_3
XFILLER_88_51 VGND VGND VPWR VPWR sky130_fd_sc_hd__decap_3
XTAP_TAPCELL_ROW_94_1487 VGND VPWR sky130_fd_sc_hd__tapvpwrvgnd_1
XTAP_TAPCELL_ROW_94_1476 VGND VPWR sky130_fd_sc_hd__tapvpwrvgnd_1
XFILLER_111_237 VGND VGND VPWR VPWR sky130_fd_sc_hd__decap_3
XFILLER_97_449 VGND VGND VPWR VPWR sky130_fd_sc_hd__decap_3
XFILLER_77_140 VGND VGND VPWR VPWR sky130_fd_sc_hd__decap_3
XFILLER_38_527 VGND VGND VPWR VPWR sky130_fd_sc_hd__decap_3
XFILLER_65_302 VGND VGND VPWR VPWR sky130_fd_sc_hd__decap_3
XFILLER_77_162 VGND VGND VPWR VPWR sky130_fd_sc_hd__decap_3
XFILLER_93_600 VGND VGND VPWR VPWR sky130_fd_sc_hd__decap_3
XPHY_EDGE_ROW_108_Left_228 VGND VGND VPWR VPWR sky130_fd_sc_hd__decap_3
XFILLER_65_335 VGND VGND VPWR VPWR sky130_fd_sc_hd__fill_1
XFILLER_65_346 VGND VGND VPWR VPWR sky130_fd_sc_hd__decap_3
XFILLER_77_184 VGND VGND VPWR VPWR sky130_fd_sc_hd__decap_3
XFILLER_92_110 VGND VGND VPWR VPWR sky130_fd_sc_hd__decap_3
XFILLER_93_633 VGND VGND VPWR VPWR sky130_fd_sc_hd__decap_3
Xclone455 clone455/A VGND VGND VPWR VPWR _5452_/S sky130_fd_sc_hd__clkbuf_16
XFILLER_18_240 VGND VGND VPWR VPWR sky130_fd_sc_hd__decap_3
XFILLER_53_508 VGND VGND VPWR VPWR sky130_fd_sc_hd__decap_3
XFILLER_80_316 VGND VGND VPWR VPWR sky130_fd_sc_hd__decap_3
XFILLER_92_154 VGND VGND VPWR VPWR sky130_fd_sc_hd__decap_3
XFILLER_18_262 VGND VGND VPWR VPWR sky130_fd_sc_hd__decap_3
XFILLER_18_295 VGND VGND VPWR VPWR sky130_fd_sc_hd__decap_3
XFILLER_33_210 VGND VGND VPWR VPWR sky130_fd_sc_hd__decap_3
XFILLER_46_582 VGND VGND VPWR VPWR sky130_fd_sc_hd__fill_1
X_5870_ _8168_/Q _8232_/Q _8233_/Q _4936_/A VGND VGND VPWR VPWR _5870_/X sky130_fd_sc_hd__a22o_4
XTAP_TAPCELL_ROW_36_728 VGND VPWR sky130_fd_sc_hd__tapvpwrvgnd_1
XFILLER_61_552 VGND VGND VPWR VPWR sky130_fd_sc_hd__decap_3
X_4821_ _8201_/Q _8265_/Q VGND VGND VPWR VPWR _6956_/B sky130_fd_sc_hd__and2b_2
XFILLER_21_416 VGND VGND VPWR VPWR sky130_fd_sc_hd__decap_3
XTAP_TAPCELL_ROW_16_463 VGND VPWR sky130_fd_sc_hd__tapvpwrvgnd_1
XFILLER_21_449 VGND VGND VPWR VPWR sky130_fd_sc_hd__decap_3
XPHY_EDGE_ROW_117_Left_237 VGND VGND VPWR VPWR sky130_fd_sc_hd__decap_3
XTAP_TAPCELL_ROW_103_1594 VGND VPWR sky130_fd_sc_hd__tapvpwrvgnd_1
X_7540_ _7606_/A1 _7517_/X _7539_/X _7843_/A VGND VGND VPWR VPWR _8354_/D sky130_fd_sc_hd__o211a_4
Xclkbuf_leaf_13_clk clkload2/A VGND VGND VPWR VPWR _8355_/CLK sky130_fd_sc_hd__clkbuf_8
X_4752_ _7646_/A _8287_/Q VGND VGND VPWR VPWR _7844_/B sky130_fd_sc_hd__or2_2
XFILLER_119_315 VGND VGND VPWR VPWR sky130_fd_sc_hd__fill_2
XFILLER_119_326 VGND VGND VPWR VPWR sky130_fd_sc_hd__decap_3
XFILLER_119_337 VGND VGND VPWR VPWR sky130_fd_sc_hd__decap_3
X_7471_ _8217_/Q _7471_/B VGND VGND VPWR VPWR _7532_/C sky130_fd_sc_hd__or2_4
X_4683_ _4683_/A VGND VGND VPWR VPWR _8279_/D sky130_fd_sc_hd__buf_1
X_6422_ _7825_/A _6422_/B VGND VGND VPWR VPWR _6422_/Y sky130_fd_sc_hd__nor2_2
X_6353_ _6353_/A _6353_/B VGND VGND VPWR VPWR _6354_/B sky130_fd_sc_hd__nor2_2
XFILLER_0_309 VGND VGND VPWR VPWR sky130_fd_sc_hd__decap_3
XFILLER_88_405 VGND VGND VPWR VPWR sky130_fd_sc_hd__decap_3
X_6284_ _7930_/B _6284_/B VGND VGND VPWR VPWR _6285_/A sky130_fd_sc_hd__and2_4
X_5304_ _5319_/A _5615_/A _5304_/S VGND VGND VPWR VPWR _5304_/X sky130_fd_sc_hd__mux2_2
XFILLER_102_215 VGND VGND VPWR VPWR sky130_fd_sc_hd__decap_3
XFILLER_69_630 VGND VGND VPWR VPWR sky130_fd_sc_hd__decap_3
XFILLER_88_438 VGND VGND VPWR VPWR sky130_fd_sc_hd__fill_1
X_8023_ _8398_/CLK _8023_/D VGND VGND VPWR VPWR _8403_/A sky130_fd_sc_hd__dfxtp_2
X_5235_ _5231_/X _5234_/X _5579_/S VGND VGND VPWR VPWR _5235_/X sky130_fd_sc_hd__mux2_2
XFILLER_69_663 VGND VGND VPWR VPWR sky130_fd_sc_hd__decap_3
XFILLER_29_505 VGND VGND VPWR VPWR sky130_fd_sc_hd__decap_3
XFILLER_68_162 VGND VGND VPWR VPWR sky130_fd_sc_hd__decap_3
XFILLER_69_685 VGND VGND VPWR VPWR sky130_fd_sc_hd__fill_2
XFILLER_96_460 VGND VGND VPWR VPWR sky130_fd_sc_hd__decap_3
X_5166_ _5162_/X _5165_/X _5684_/S VGND VGND VPWR VPWR _5166_/X sky130_fd_sc_hd__mux2_2
XFILLER_29_538 VGND VGND VPWR VPWR sky130_fd_sc_hd__decap_3
XFILLER_68_195 VGND VGND VPWR VPWR sky130_fd_sc_hd__fill_1
X_5097_ _5452_/S _6380_/S _7555_/S VGND VGND VPWR VPWR _7745_/B sky130_fd_sc_hd__or3_2
X_4117_ _4117_/A VGND VGND VPWR VPWR _7996_/D sky130_fd_sc_hd__buf_1
XFILLER_56_368 VGND VGND VPWR VPWR sky130_fd_sc_hd__decap_3
XFILLER_83_165 VGND VGND VPWR VPWR sky130_fd_sc_hd__decap_3
X_4048_ _7930_/B _8365_/Q VGND VGND VPWR VPWR _4049_/A sky130_fd_sc_hd__and2_2
XFILLER_24_221 VGND VGND VPWR VPWR sky130_fd_sc_hd__decap_3
XFILLER_52_530 VGND VGND VPWR VPWR sky130_fd_sc_hd__fill_2
XFILLER_52_563 VGND VGND VPWR VPWR sky130_fd_sc_hd__fill_2
XFILLER_64_390 VGND VGND VPWR VPWR sky130_fd_sc_hd__decap_3
XFILLER_12_416 VGND VGND VPWR VPWR sky130_fd_sc_hd__decap_3
XFILLER_12_427 VGND VGND VPWR VPWR sky130_fd_sc_hd__decap_3
XFILLER_24_287 VGND VGND VPWR VPWR sky130_fd_sc_hd__decap_3
XFILLER_33_13 VGND VGND VPWR VPWR sky130_fd_sc_hd__decap_3
XFILLER_52_585 VGND VGND VPWR VPWR sky130_fd_sc_hd__decap_3
X_7807_ _5684_/S _5121_/A _7805_/Y _7806_/Y VGND VGND VPWR VPWR _7807_/X sky130_fd_sc_hd__a31o_2
X_5999_ _5978_/X _5979_/X _5990_/Y _5998_/X _7898_/B VGND VGND VPWR VPWR _8309_/D
+ sky130_fd_sc_hd__o41a_2
XFILLER_33_46 VGND VGND VPWR VPWR sky130_fd_sc_hd__fill_2
XFILLER_33_57 VGND VGND VPWR VPWR sky130_fd_sc_hd__decap_3
X_7738_ _8179_/Q _7660_/A _7664_/X VGND VGND VPWR VPWR _7738_/Y sky130_fd_sc_hd__o21ai_2
XTAP_TAPCELL_ROW_65_1099 VGND VPWR sky130_fd_sc_hd__tapvpwrvgnd_1
XFILLER_33_79 VGND VGND VPWR VPWR sky130_fd_sc_hd__decap_3
XFILLER_20_471 VGND VGND VPWR VPWR sky130_fd_sc_hd__decap_3
X_7669_ _7670_/A _7670_/B VGND VGND VPWR VPWR _7680_/B sky130_fd_sc_hd__nand2_2
XFILLER_106_521 VGND VGND VPWR VPWR sky130_fd_sc_hd__fill_1
XFILLER_109_3 VGND VGND VPWR VPWR sky130_fd_sc_hd__fill_2
XFILLER_106_554 VGND VGND VPWR VPWR sky130_fd_sc_hd__decap_3
XFILLER_79_416 VGND VGND VPWR VPWR sky130_fd_sc_hd__decap_3
XFILLER_106_587 VGND VGND VPWR VPWR sky130_fd_sc_hd__fill_1
XFILLER_79_449 VGND VGND VPWR VPWR sky130_fd_sc_hd__decap_3
XFILLER_58_32 VGND VGND VPWR VPWR sky130_fd_sc_hd__decap_3
XFILLER_59_151 VGND VGND VPWR VPWR sky130_fd_sc_hd__decap_3
XFILLER_87_482 VGND VGND VPWR VPWR sky130_fd_sc_hd__decap_3
XFILLER_94_419 VGND VGND VPWR VPWR sky130_fd_sc_hd__fill_1
XFILLER_101_281 VGND VGND VPWR VPWR sky130_fd_sc_hd__decap_3
XFILLER_47_324 VGND VGND VPWR VPWR sky130_fd_sc_hd__decap_3
XFILLER_47_346 VGND VGND VPWR VPWR sky130_fd_sc_hd__fill_1
XFILLER_59_195 VGND VGND VPWR VPWR sky130_fd_sc_hd__decap_3
XFILLER_74_121 VGND VGND VPWR VPWR sky130_fd_sc_hd__fill_1
XFILLER_35_508 VGND VGND VPWR VPWR sky130_fd_sc_hd__decap_3
XFILLER_47_357 VGND VGND VPWR VPWR sky130_fd_sc_hd__decap_3
XFILLER_74_20 VGND VGND VPWR VPWR sky130_fd_sc_hd__decap_3
XFILLER_75_666 VGND VGND VPWR VPWR sky130_fd_sc_hd__decap_3
XFILLER_28_582 VGND VGND VPWR VPWR sky130_fd_sc_hd__decap_3
XFILLER_62_327 VGND VGND VPWR VPWR sky130_fd_sc_hd__decap_3
XFILLER_74_75 VGND VGND VPWR VPWR sky130_fd_sc_hd__decap_3
XFILLER_90_625 VGND VGND VPWR VPWR sky130_fd_sc_hd__decap_3
XFILLER_90_658 VGND VGND VPWR VPWR sky130_fd_sc_hd__decap_3
XFILLER_15_221 VGND VGND VPWR VPWR sky130_fd_sc_hd__decap_3
XFILLER_15_243 VGND VGND VPWR VPWR sky130_fd_sc_hd__decap_3
XFILLER_43_530 VGND VGND VPWR VPWR sky130_fd_sc_hd__decap_3
XFILLER_55_390 VGND VGND VPWR VPWR sky130_fd_sc_hd__fill_2
XFILLER_15_287 VGND VGND VPWR VPWR sky130_fd_sc_hd__decap_3
XFILLER_31_714 VGND VGND VPWR VPWR sky130_fd_sc_hd__decap_3
XFILLER_70_360 VGND VGND VPWR VPWR sky130_fd_sc_hd__decap_3
XFILLER_70_371 VGND VGND VPWR VPWR sky130_fd_sc_hd__decap_3
XFILLER_70_393 VGND VGND VPWR VPWR sky130_fd_sc_hd__decap_3
XFILLER_90_41 VGND VGND VPWR VPWR sky130_fd_sc_hd__decap_3
XTAP_TAPCELL_ROW_13_422 VGND VPWR sky130_fd_sc_hd__tapvpwrvgnd_1
XTAP_TAPCELL_ROW_13_433 VGND VPWR sky130_fd_sc_hd__tapvpwrvgnd_1
XFILLER_11_460 VGND VGND VPWR VPWR sky130_fd_sc_hd__fill_1
XFILLER_30_268 VGND VGND VPWR VPWR sky130_fd_sc_hd__decap_3
XFILLER_90_85 VGND VGND VPWR VPWR sky130_fd_sc_hd__decap_3
XFILLER_7_442 VGND VGND VPWR VPWR sky130_fd_sc_hd__decap_3
XTAP_TAPCELL_ROW_96_1505 VGND VPWR sky130_fd_sc_hd__tapvpwrvgnd_1
XTAP_TAPCELL_ROW_41_797 VGND VPWR sky130_fd_sc_hd__tapvpwrvgnd_1
XTAP_TAPCELL_ROW_41_786 VGND VPWR sky130_fd_sc_hd__tapvpwrvgnd_1
XFILLER_116_307 VGND VGND VPWR VPWR sky130_fd_sc_hd__fill_1
XFILLER_116_318 VGND VGND VPWR VPWR sky130_fd_sc_hd__decap_3
XFILLER_7_475 VGND VGND VPWR VPWR sky130_fd_sc_hd__decap_3
XFILLER_99_50 VGND VGND VPWR VPWR sky130_fd_sc_hd__decap_3
XFILLER_99_83 VGND VGND VPWR VPWR sky130_fd_sc_hd__decap_3
XFILLER_112_557 VGND VGND VPWR VPWR sky130_fd_sc_hd__decap_3
XFILLER_2_191 VGND VGND VPWR VPWR sky130_fd_sc_hd__decap_3
XFILLER_85_408 VGND VGND VPWR VPWR sky130_fd_sc_hd__fill_2
XFILLER_97_268 VGND VGND VPWR VPWR sky130_fd_sc_hd__fill_1
X_5020_ _8231_/Q _5019_/X _8167_/Q VGND VGND VPWR VPWR _5020_/X sky130_fd_sc_hd__a21bo_2
XFILLER_85_419 VGND VGND VPWR VPWR sky130_fd_sc_hd__fill_2
Xclkbuf_leaf_2_clk clkload1/A VGND VGND VPWR VPWR _8199_/CLK sky130_fd_sc_hd__clkbuf_8
XFILLER_78_493 VGND VGND VPWR VPWR sky130_fd_sc_hd__decap_3
XPHY_EDGE_ROW_119_Right_119 VGND VGND VPWR VPWR sky130_fd_sc_hd__decap_3
XFILLER_26_508 VGND VGND VPWR VPWR sky130_fd_sc_hd__fill_1
XFILLER_38_357 VGND VGND VPWR VPWR sky130_fd_sc_hd__decap_3
XFILLER_38_368 VGND VGND VPWR VPWR sky130_fd_sc_hd__decap_3
XFILLER_66_677 VGND VGND VPWR VPWR sky130_fd_sc_hd__decap_3
XFILLER_81_614 VGND VGND VPWR VPWR sky130_fd_sc_hd__fill_2
XFILLER_93_452 VGND VGND VPWR VPWR sky130_fd_sc_hd__decap_3
XFILLER_0_50 VGND VGND VPWR VPWR sky130_fd_sc_hd__decap_3
XFILLER_65_187 VGND VGND VPWR VPWR sky130_fd_sc_hd__decap_3
XFILLER_66_699 VGND VGND VPWR VPWR sky130_fd_sc_hd__fill_1
XFILLER_81_636 VGND VGND VPWR VPWR sky130_fd_sc_hd__fill_1
XFILLER_93_485 VGND VGND VPWR VPWR sky130_fd_sc_hd__decap_3
XTAP_TAPCELL_ROW_105_1623 VGND VPWR sky130_fd_sc_hd__tapvpwrvgnd_1
X_6971_ _5192_/A _6968_/Y _6970_/X _5313_/A VGND VGND VPWR VPWR _6971_/X sky130_fd_sc_hd__a2bb2o_4
XTAP_TAPCELL_ROW_49_897 VGND VPWR sky130_fd_sc_hd__tapvpwrvgnd_1
XFILLER_0_72 VGND VGND VPWR VPWR sky130_fd_sc_hd__decap_3
XFILLER_0_94 VGND VGND VPWR VPWR sky130_fd_sc_hd__decap_3
XFILLER_80_135 VGND VGND VPWR VPWR sky130_fd_sc_hd__decap_3
X_5922_ _6109_/A _5915_/X _5919_/Y _5921_/Y VGND VGND VPWR VPWR _5922_/X sky130_fd_sc_hd__a22o_2
XFILLER_110_29 VGND VGND VPWR VPWR sky130_fd_sc_hd__fill_1
X_5853_ _5466_/X _5472_/A _6507_/S VGND VGND VPWR VPWR _5853_/X sky130_fd_sc_hd__mux2_2
XFILLER_21_246 VGND VGND VPWR VPWR sky130_fd_sc_hd__decap_3
XFILLER_61_393 VGND VGND VPWR VPWR sky130_fd_sc_hd__decap_3
X_5784_ _5381_/X _5385_/X _5355_/X _5375_/X _6070_/A _6507_/S VGND VGND VPWR VPWR
+ _5785_/B sky130_fd_sc_hd__mux4_2
X_4804_ _4805_/A _8270_/Q VGND VGND VPWR VPWR _4806_/A sky130_fd_sc_hd__nand2_2
XFILLER_21_279 VGND VGND VPWR VPWR sky130_fd_sc_hd__fill_1
X_7523_ _8220_/Q _5600_/A _5718_/A _8284_/Q VGND VGND VPWR VPWR _7523_/X sky130_fd_sc_hd__a2bb2o_2
X_4735_ _8219_/Q _4736_/B VGND VGND VPWR VPWR _4737_/A sky130_fd_sc_hd__nor2_2
XFILLER_107_318 VGND VGND VPWR VPWR sky130_fd_sc_hd__decap_3
XFILLER_119_38 VGND VGND VPWR VPWR sky130_fd_sc_hd__decap_3
X_7454_ _7440_/X _8217_/Q _7442_/Y _7453_/X VGND VGND VPWR VPWR _7454_/X sky130_fd_sc_hd__a211o_4
X_4666_ _7930_/B _8137_/Q VGND VGND VPWR VPWR _4667_/A sky130_fd_sc_hd__and2_2
X_7385_ _5407_/X _7383_/Y _7438_/C _6368_/B VGND VGND VPWR VPWR _7385_/X sky130_fd_sc_hd__a22o_2
X_6405_ _6411_/A _6405_/B VGND VGND VPWR VPWR _6405_/Y sky130_fd_sc_hd__nand2_2
X_4597_ _4597_/A VGND VGND VPWR VPWR _8236_/D sky130_fd_sc_hd__buf_1
XFILLER_115_340 VGND VGND VPWR VPWR sky130_fd_sc_hd__decap_3
XTAP_TAPCELL_ROW_116_1763 VGND VPWR sky130_fd_sc_hd__tapvpwrvgnd_1
X_6336_ _8184_/Q _6336_/B VGND VGND VPWR VPWR _6336_/X sky130_fd_sc_hd__and2_2
XFILLER_0_106 VGND VGND VPWR VPWR sky130_fd_sc_hd__decap_3
XFILLER_0_128 VGND VGND VPWR VPWR sky130_fd_sc_hd__fill_1
XFILLER_103_546 VGND VGND VPWR VPWR sky130_fd_sc_hd__decap_3
X_6267_ _8183_/Q _6237_/X _6263_/Y _8290_/Q _6266_/X VGND VGND VPWR VPWR _6282_/A
+ sky130_fd_sc_hd__a221o_2
XFILLER_29_302 VGND VGND VPWR VPWR sky130_fd_sc_hd__decap_3
XFILLER_76_419 VGND VGND VPWR VPWR sky130_fd_sc_hd__fill_1
XFILLER_88_268 VGND VGND VPWR VPWR sky130_fd_sc_hd__decap_3
X_8006_ _8390_/CLK _8006_/D VGND VGND VPWR VPWR _8006_/Q sky130_fd_sc_hd__dfxtp_2
X_6198_ _8290_/Q _6189_/X _6191_/X _5812_/A _6197_/X VGND VGND VPWR VPWR _6198_/X
+ sky130_fd_sc_hd__a221o_2
X_5218_ _5216_/X _5217_/X _5384_/S VGND VGND VPWR VPWR _5218_/X sky130_fd_sc_hd__mux2_2
XFILLER_28_35 VGND VGND VPWR VPWR sky130_fd_sc_hd__decap_3
XFILLER_57_633 VGND VGND VPWR VPWR sky130_fd_sc_hd__decap_3
XFILLER_69_482 VGND VGND VPWR VPWR sky130_fd_sc_hd__decap_3
X_5149_ _8196_/Q _8197_/Q _5484_/S VGND VGND VPWR VPWR _5149_/X sky130_fd_sc_hd__mux2_2
XFILLER_28_68 VGND VGND VPWR VPWR sky130_fd_sc_hd__decap_3
XFILLER_44_305 VGND VGND VPWR VPWR sky130_fd_sc_hd__decap_3
XFILLER_56_132 VGND VGND VPWR VPWR sky130_fd_sc_hd__decap_3
XFILLER_56_165 VGND VGND VPWR VPWR sky130_fd_sc_hd__decap_3
XFILLER_57_666 VGND VGND VPWR VPWR sky130_fd_sc_hd__decap_3
XFILLER_72_614 VGND VGND VPWR VPWR sky130_fd_sc_hd__fill_2
XFILLER_84_463 VGND VGND VPWR VPWR sky130_fd_sc_hd__decap_3
XFILLER_44_327 VGND VGND VPWR VPWR sky130_fd_sc_hd__fill_2
XFILLER_44_338 VGND VGND VPWR VPWR sky130_fd_sc_hd__decap_3
XFILLER_71_102 VGND VGND VPWR VPWR sky130_fd_sc_hd__fill_1
XFILLER_71_113 VGND VGND VPWR VPWR sky130_fd_sc_hd__decap_3
XFILLER_72_636 VGND VGND VPWR VPWR sky130_fd_sc_hd__decap_3
XTAP_TAPCELL_ROW_67_1128 VGND VPWR sky130_fd_sc_hd__tapvpwrvgnd_1
XFILLER_25_541 VGND VGND VPWR VPWR sky130_fd_sc_hd__fill_2
XFILLER_40_511 VGND VGND VPWR VPWR sky130_fd_sc_hd__fill_2
XFILLER_40_533 VGND VGND VPWR VPWR sky130_fd_sc_hd__decap_3
XFILLER_100_51 VGND VGND VPWR VPWR sky130_fd_sc_hd__decap_3
XFILLER_100_73 VGND VGND VPWR VPWR sky130_fd_sc_hd__decap_3
XFILLER_12_268 VGND VGND VPWR VPWR sky130_fd_sc_hd__decap_3
XFILLER_9_729 VGND VGND VPWR VPWR sky130_fd_sc_hd__decap_3
XFILLER_60_77 VGND VGND VPWR VPWR sky130_fd_sc_hd__decap_3
XFILLER_60_88 VGND VGND VPWR VPWR sky130_fd_sc_hd__decap_3
XFILLER_4_434 VGND VGND VPWR VPWR sky130_fd_sc_hd__fill_2
XFILLER_5_17 VGND VGND VPWR VPWR sky130_fd_sc_hd__fill_1
XTAP_TAPCELL_ROW_78_1279 VGND VPWR sky130_fd_sc_hd__tapvpwrvgnd_1
XTAP_TAPCELL_ROW_78_1268 VGND VPWR sky130_fd_sc_hd__tapvpwrvgnd_1
XFILLER_106_340 VGND VGND VPWR VPWR sky130_fd_sc_hd__decap_3
XFILLER_109_82 VGND VGND VPWR VPWR sky130_fd_sc_hd__decap_3
XFILLER_4_456 VGND VGND VPWR VPWR sky130_fd_sc_hd__decap_3
XFILLER_79_202 VGND VGND VPWR VPWR sky130_fd_sc_hd__decap_3
XTAP_TAPCELL_ROW_91_1446 VGND VPWR sky130_fd_sc_hd__tapvpwrvgnd_1
XFILLER_0_640 VGND VGND VPWR VPWR sky130_fd_sc_hd__decap_3
XFILLER_0_662 VGND VGND VPWR VPWR sky130_fd_sc_hd__fill_2
XFILLER_67_408 VGND VGND VPWR VPWR sky130_fd_sc_hd__decap_3
XFILLER_79_268 VGND VGND VPWR VPWR sky130_fd_sc_hd__decap_3
XFILLER_94_216 VGND VGND VPWR VPWR sky130_fd_sc_hd__decap_3
XFILLER_48_633 VGND VGND VPWR VPWR sky130_fd_sc_hd__decap_3
XFILLER_87_290 VGND VGND VPWR VPWR sky130_fd_sc_hd__decap_3
XFILLER_48_666 VGND VGND VPWR VPWR sky130_fd_sc_hd__decap_3
XFILLER_75_452 VGND VGND VPWR VPWR sky130_fd_sc_hd__decap_3
XFILLER_85_63 VGND VGND VPWR VPWR sky130_fd_sc_hd__decap_3
XFILLER_48_699 VGND VGND VPWR VPWR sky130_fd_sc_hd__fill_1
XFILLER_75_496 VGND VGND VPWR VPWR sky130_fd_sc_hd__decap_3
XFILLER_85_96 VGND VGND VPWR VPWR sky130_fd_sc_hd__decap_3
XFILLER_16_530 VGND VGND VPWR VPWR sky130_fd_sc_hd__fill_2
XFILLER_35_349 VGND VGND VPWR VPWR sky130_fd_sc_hd__decap_3
XFILLER_62_124 VGND VGND VPWR VPWR sky130_fd_sc_hd__decap_3
XFILLER_90_433 VGND VGND VPWR VPWR sky130_fd_sc_hd__decap_3
XTAP_TAPCELL_ROW_46_856 VGND VPWR sky130_fd_sc_hd__tapvpwrvgnd_1
XFILLER_16_563 VGND VGND VPWR VPWR sky130_fd_sc_hd__decap_3
XFILLER_31_500 VGND VGND VPWR VPWR sky130_fd_sc_hd__decap_3
XFILLER_62_168 VGND VGND VPWR VPWR sky130_fd_sc_hd__fill_2
XFILLER_62_179 VGND VGND VPWR VPWR sky130_fd_sc_hd__decap_3
XFILLER_90_477 VGND VGND VPWR VPWR sky130_fd_sc_hd__decap_3
XFILLER_90_499 VGND VGND VPWR VPWR sky130_fd_sc_hd__decap_3
XFILLER_43_382 VGND VGND VPWR VPWR sky130_fd_sc_hd__decap_3
XFILLER_43_393 VGND VGND VPWR VPWR sky130_fd_sc_hd__decap_3
XTAP_TAPCELL_ROW_26_591 VGND VPWR sky130_fd_sc_hd__tapvpwrvgnd_1
XTAP_TAPCELL_ROW_100_1553 VGND VPWR sky130_fd_sc_hd__tapvpwrvgnd_1
XTAP_TAPCELL_ROW_100_1564 VGND VPWR sky130_fd_sc_hd__tapvpwrvgnd_1
XFILLER_11_290 VGND VGND VPWR VPWR sky130_fd_sc_hd__decap_3
X_4520_ _7898_/B _8064_/Q VGND VGND VPWR VPWR _4521_/A sky130_fd_sc_hd__and2_2
XFILLER_116_137 VGND VGND VPWR VPWR sky130_fd_sc_hd__decap_3
X_4451_ _4451_/A VGND VGND VPWR VPWR _8163_/D sky130_fd_sc_hd__buf_1
XFILLER_7_294 VGND VGND VPWR VPWR sky130_fd_sc_hd__decap_3
X_7170_ _8206_/Q _8270_/Q _7169_/Y VGND VGND VPWR VPWR _7172_/B sky130_fd_sc_hd__o21a_2
XFILLER_98_533 VGND VGND VPWR VPWR sky130_fd_sc_hd__fill_2
X_6121_ _6394_/B _6121_/B VGND VGND VPWR VPWR _6121_/Y sky130_fd_sc_hd__nand2_2
X_4382_ _7930_/B _4382_/B VGND VGND VPWR VPWR _4383_/A sky130_fd_sc_hd__and2_2
XFILLER_112_343 VGND VGND VPWR VPWR sky130_fd_sc_hd__decap_3
XFILLER_98_544 VGND VGND VPWR VPWR sky130_fd_sc_hd__decap_3
XFILLER_100_516 VGND VGND VPWR VPWR sky130_fd_sc_hd__decap_3
XFILLER_112_365 VGND VGND VPWR VPWR sky130_fd_sc_hd__decap_3
XFILLER_39_600 VGND VGND VPWR VPWR sky130_fd_sc_hd__decap_3
XFILLER_58_419 VGND VGND VPWR VPWR sky130_fd_sc_hd__fill_1
XPHY_EDGE_ROW_7_Right_7 VGND VGND VPWR VPWR sky130_fd_sc_hd__decap_3
X_6052_ _8177_/Q _8241_/Q VGND VGND VPWR VPWR _6052_/X sky130_fd_sc_hd__or2_2
XFILLER_100_538 VGND VGND VPWR VPWR sky130_fd_sc_hd__decap_3
XFILLER_100_549 VGND VGND VPWR VPWR sky130_fd_sc_hd__decap_3
XFILLER_112_398 VGND VGND VPWR VPWR sky130_fd_sc_hd__decap_3
XFILLER_39_644 VGND VGND VPWR VPWR sky130_fd_sc_hd__decap_3
XFILLER_66_430 VGND VGND VPWR VPWR sky130_fd_sc_hd__decap_3
X_5003_ _4853_/B _5002_/Y _4851_/Y VGND VGND VPWR VPWR _5003_/Y sky130_fd_sc_hd__a21oi_2
XFILLER_39_688 VGND VGND VPWR VPWR sky130_fd_sc_hd__decap_3
XFILLER_53_102 VGND VGND VPWR VPWR sky130_fd_sc_hd__decap_3
XFILLER_53_113 VGND VGND VPWR VPWR sky130_fd_sc_hd__decap_3
XFILLER_66_474 VGND VGND VPWR VPWR sky130_fd_sc_hd__fill_2
XFILLER_81_411 VGND VGND VPWR VPWR sky130_fd_sc_hd__decap_3
XFILLER_81_444 VGND VGND VPWR VPWR sky130_fd_sc_hd__decap_3
XFILLER_81_466 VGND VGND VPWR VPWR sky130_fd_sc_hd__decap_3
X_6954_ _5778_/X _5779_/X _6952_/Y _6953_/X _5528_/A VGND VGND VPWR VPWR _6954_/X
+ sky130_fd_sc_hd__a32o_2
XFILLER_34_360 VGND VGND VPWR VPWR sky130_fd_sc_hd__decap_3
XFILLER_81_499 VGND VGND VPWR VPWR sky130_fd_sc_hd__decap_3
X_5905_ _8173_/Q _8237_/Q VGND VGND VPWR VPWR _5905_/X sky130_fd_sc_hd__or2_2
XFILLER_22_522 VGND VGND VPWR VPWR sky130_fd_sc_hd__decap_3
XFILLER_22_533 VGND VGND VPWR VPWR sky130_fd_sc_hd__decap_3
XFILLER_34_382 VGND VGND VPWR VPWR sky130_fd_sc_hd__decap_3
X_6885_ _6885_/A _6885_/B VGND VGND VPWR VPWR _6885_/Y sky130_fd_sc_hd__xnor2_2
XFILLER_22_577 VGND VGND VPWR VPWR sky130_fd_sc_hd__decap_3
X_5836_ _6763_/A _5809_/Y _5812_/Y _5819_/X _5835_/X VGND VGND VPWR VPWR _5836_/X
+ sky130_fd_sc_hd__o2111a_2
XTAP_TAPCELL_ROW_62_1069 VGND VPWR sky130_fd_sc_hd__tapvpwrvgnd_1
Xrebuffer314 rebuffer792/X VGND VGND VPWR VPWR _5022_/A sky130_fd_sc_hd__buf_6
X_5767_ _7776_/B _5701_/A _5766_/X _8288_/Q VGND VGND VPWR VPWR _5767_/X sky130_fd_sc_hd__o22a_2
XFILLER_5_209 VGND VGND VPWR VPWR sky130_fd_sc_hd__decap_3
X_7506_ _7193_/A _7505_/X _6529_/A VGND VGND VPWR VPWR _7506_/Y sky130_fd_sc_hd__o21ai_2
Xrebuffer347 _6147_/C VGND VGND VPWR VPWR _6096_/A sky130_fd_sc_hd__buf_2
X_5698_ _5695_/S _5697_/Y _8288_/Q VGND VGND VPWR VPWR _5698_/X sky130_fd_sc_hd__mux2_2
X_4718_ split/X _4718_/B VGND VGND VPWR VPWR _4718_/X sky130_fd_sc_hd__xor2_2
XFILLER_107_137 VGND VGND VPWR VPWR sky130_fd_sc_hd__decap_3
XFILLER_108_638 VGND VGND VPWR VPWR sky130_fd_sc_hd__decap_3
X_7437_ _7437_/A _7437_/B VGND VGND VPWR VPWR _7437_/Y sky130_fd_sc_hd__xnor2_2
X_4649_ _4649_/A VGND VGND VPWR VPWR _8262_/D sky130_fd_sc_hd__buf_1
XFILLER_116_660 VGND VGND VPWR VPWR sky130_fd_sc_hd__decap_3
X_7368_ _7312_/A _7312_/B _7353_/Y _4980_/A VGND VGND VPWR VPWR _7370_/C sky130_fd_sc_hd__a211o_2
XFILLER_103_332 VGND VGND VPWR VPWR sky130_fd_sc_hd__decap_3
XFILLER_103_343 VGND VGND VPWR VPWR sky130_fd_sc_hd__decap_3
XFILLER_39_23 VGND VGND VPWR VPWR sky130_fd_sc_hd__decap_3
X_7299_ _7193_/A _7298_/X _6533_/A VGND VGND VPWR VPWR _7300_/B sky130_fd_sc_hd__o21ai_2
X_6319_ _6317_/X _6318_/X _8184_/Q VGND VGND VPWR VPWR _6319_/X sky130_fd_sc_hd__mux2_2
XFILLER_76_227 VGND VGND VPWR VPWR sky130_fd_sc_hd__decap_3
XFILLER_57_441 VGND VGND VPWR VPWR sky130_fd_sc_hd__decap_3
XFILLER_57_452 VGND VGND VPWR VPWR sky130_fd_sc_hd__decap_3
XFILLER_69_290 VGND VGND VPWR VPWR sky130_fd_sc_hd__decap_3
XFILLER_91_208 VGND VGND VPWR VPWR sky130_fd_sc_hd__decap_3
XFILLER_92_709 VGND VGND VPWR VPWR sky130_fd_sc_hd__decap_3
XFILLER_17_316 VGND VGND VPWR VPWR sky130_fd_sc_hd__fill_2
XFILLER_44_102 VGND VGND VPWR VPWR sky130_fd_sc_hd__decap_3
XFILLER_45_625 VGND VGND VPWR VPWR sky130_fd_sc_hd__decap_3
XFILLER_57_496 VGND VGND VPWR VPWR sky130_fd_sc_hd__fill_1
XFILLER_72_400 VGND VGND VPWR VPWR sky130_fd_sc_hd__decap_3
XFILLER_84_271 VGND VGND VPWR VPWR sky130_fd_sc_hd__decap_3
XFILLER_17_349 VGND VGND VPWR VPWR sky130_fd_sc_hd__decap_3
XFILLER_44_124 VGND VGND VPWR VPWR sky130_fd_sc_hd__decap_3
XFILLER_55_55 VGND VGND VPWR VPWR sky130_fd_sc_hd__fill_1
XFILLER_72_455 VGND VGND VPWR VPWR sky130_fd_sc_hd__decap_3
XFILLER_25_360 VGND VGND VPWR VPWR sky130_fd_sc_hd__fill_2
XFILLER_72_477 VGND VGND VPWR VPWR sky130_fd_sc_hd__decap_3
XTAP_TAPCELL_ROW_43_815 VGND VPWR sky130_fd_sc_hd__tapvpwrvgnd_1
XFILLER_111_72 VGND VGND VPWR VPWR sky130_fd_sc_hd__decap_3
XFILLER_13_511 VGND VGND VPWR VPWR sky130_fd_sc_hd__fill_2
XFILLER_25_371 VGND VGND VPWR VPWR sky130_fd_sc_hd__decap_3
XFILLER_40_330 VGND VGND VPWR VPWR sky130_fd_sc_hd__decap_3
XFILLER_71_43 VGND VGND VPWR VPWR sky130_fd_sc_hd__decap_3
XFILLER_40_385 VGND VGND VPWR VPWR sky130_fd_sc_hd__decap_3
XFILLER_71_87 VGND VGND VPWR VPWR sky130_fd_sc_hd__fill_1
XTAP_TAPCELL_ROW_23_561 VGND VPWR sky130_fd_sc_hd__tapvpwrvgnd_1
XFILLER_5_721 VGND VGND VPWR VPWR sky130_fd_sc_hd__decap_3
XFILLER_5_732 VGND VGND VPWR VPWR sky130_fd_sc_hd__fill_1
XFILLER_58_9 VGND VGND VPWR VPWR sky130_fd_sc_hd__decap_3
Xrebuffer892 _7439_/B VGND VGND VPWR VPWR rebuffer892/X sky130_fd_sc_hd__buf_2
XFILLER_107_660 VGND VGND VPWR VPWR sky130_fd_sc_hd__decap_3
XFILLER_4_253 VGND VGND VPWR VPWR sky130_fd_sc_hd__decap_3
XFILLER_106_192 VGND VGND VPWR VPWR sky130_fd_sc_hd__decap_3
XFILLER_95_503 VGND VGND VPWR VPWR sky130_fd_sc_hd__fill_1
XFILLER_96_51 VGND VGND VPWR VPWR sky130_fd_sc_hd__decap_3
XFILLER_67_216 VGND VGND VPWR VPWR sky130_fd_sc_hd__decap_3
XFILLER_67_249 VGND VGND VPWR VPWR sky130_fd_sc_hd__decap_3
XFILLER_48_430 VGND VGND VPWR VPWR sky130_fd_sc_hd__decap_3
XFILLER_83_709 VGND VGND VPWR VPWR sky130_fd_sc_hd__fill_2
XFILLER_36_625 VGND VGND VPWR VPWR sky130_fd_sc_hd__decap_3
XFILLER_63_422 VGND VGND VPWR VPWR sky130_fd_sc_hd__decap_3
XFILLER_75_293 VGND VGND VPWR VPWR sky130_fd_sc_hd__decap_3
XFILLER_90_230 VGND VGND VPWR VPWR sky130_fd_sc_hd__decap_3
XFILLER_90_241 VGND VGND VPWR VPWR sky130_fd_sc_hd__decap_3
XFILLER_23_308 VGND VGND VPWR VPWR sky130_fd_sc_hd__decap_3
XFILLER_63_466 VGND VGND VPWR VPWR sky130_fd_sc_hd__decap_3
XFILLER_63_488 VGND VGND VPWR VPWR sky130_fd_sc_hd__decap_3
XFILLER_31_330 VGND VGND VPWR VPWR sky130_fd_sc_hd__decap_3
X_6670_ _8192_/Q _8193_/Q _6670_/C VGND VGND VPWR VPWR _6670_/X sky130_fd_sc_hd__and3_2
XFILLER_31_363 VGND VGND VPWR VPWR sky130_fd_sc_hd__decap_3
XFILLER_31_385 VGND VGND VPWR VPWR sky130_fd_sc_hd__decap_3
X_5621_ _5396_/A _7809_/A1 _5620_/Y _5402_/X _5888_/C VGND VGND VPWR VPWR _5621_/X
+ sky130_fd_sc_hd__a32o_2
X_8340_ _8353_/CLK _8340_/D VGND VGND VPWR VPWR _8340_/Q sky130_fd_sc_hd__dfxtp_2
X_5552_ _5261_/X _5224_/X _6706_/S VGND VGND VPWR VPWR _5552_/X sky130_fd_sc_hd__mux2_2
XFILLER_8_592 VGND VGND VPWR VPWR sky130_fd_sc_hd__decap_3
X_8271_ _8401_/CLK _8271_/D VGND VGND VPWR VPWR _8271_/Q sky130_fd_sc_hd__dfxtp_2
X_4503_ _4503_/A VGND VGND VPWR VPWR _8189_/D sky130_fd_sc_hd__buf_1
XFILLER_6_60 VGND VGND VPWR VPWR sky130_fd_sc_hd__decap_3
X_5483_ _5950_/A VGND VGND VPWR VPWR _7754_/A sky130_fd_sc_hd__buf_1
XFILLER_6_71 VGND VGND VPWR VPWR sky130_fd_sc_hd__fill_2
XFILLER_6_82 VGND VGND VPWR VPWR sky130_fd_sc_hd__fill_2
XTAP_TAPCELL_ROW_113_1722 VGND VPWR sky130_fd_sc_hd__tapvpwrvgnd_1
XTAP_TAPCELL_ROW_113_1733 VGND VPWR sky130_fd_sc_hd__tapvpwrvgnd_1
X_7222_ _8209_/Q _7222_/B _7223_/C VGND VGND VPWR VPWR _7222_/X sky130_fd_sc_hd__and3_2
X_4434_ _7898_/B input3/X VGND VGND VPWR VPWR _4435_/A sky130_fd_sc_hd__and2_2
XFILLER_113_641 VGND VGND VPWR VPWR sky130_fd_sc_hd__decap_3
XFILLER_98_341 VGND VGND VPWR VPWR sky130_fd_sc_hd__decap_3
X_7153_ _8261_/Q _6801_/X _6812_/X _7152_/X VGND VGND VPWR VPWR _7156_/A sky130_fd_sc_hd__o211a_2
X_4365_ _4365_/A VGND VGND VPWR VPWR _8120_/D sky130_fd_sc_hd__buf_1
XFILLER_113_663 VGND VGND VPWR VPWR sky130_fd_sc_hd__fill_2
XFILLER_113_685 VGND VGND VPWR VPWR sky130_fd_sc_hd__decap_3
X_7084_ _8203_/Q _8267_/Q _7082_/X _8266_/Q _7083_/X VGND VGND VPWR VPWR _7084_/X
+ sky130_fd_sc_hd__o221a_2
X_6104_ _8178_/Q _8177_/Q _6380_/S VGND VGND VPWR VPWR _6104_/X sky130_fd_sc_hd__mux2_2
XFILLER_100_302 VGND VGND VPWR VPWR sky130_fd_sc_hd__decap_3
XFILLER_112_195 VGND VGND VPWR VPWR sky130_fd_sc_hd__fill_1
XFILLER_86_536 VGND VGND VPWR VPWR sky130_fd_sc_hd__decap_3
XFILLER_98_396 VGND VGND VPWR VPWR sky130_fd_sc_hd__decap_3
X_6035_ _5587_/X _6033_/X _6045_/B _5108_/X VGND VGND VPWR VPWR _6035_/X sky130_fd_sc_hd__a22o_2
X_4296_ _7843_/A _4296_/B VGND VGND VPWR VPWR _4297_/A sky130_fd_sc_hd__and2_2
XFILLER_100_368 VGND VGND VPWR VPWR sky130_fd_sc_hd__decap_3
XFILLER_39_452 VGND VGND VPWR VPWR sky130_fd_sc_hd__decap_3
XFILLER_86_569 VGND VGND VPWR VPWR sky130_fd_sc_hd__decap_3
XFILLER_54_400 VGND VGND VPWR VPWR sky130_fd_sc_hd__decap_3
XFILLER_66_271 VGND VGND VPWR VPWR sky130_fd_sc_hd__decap_3
XFILLER_73_219 VGND VGND VPWR VPWR sky130_fd_sc_hd__decap_3
XFILLER_27_647 VGND VGND VPWR VPWR sky130_fd_sc_hd__decap_3
XFILLER_54_455 VGND VGND VPWR VPWR sky130_fd_sc_hd__decap_3
XTAP_TAPCELL_ROW_1_267 VGND VPWR sky130_fd_sc_hd__tapvpwrvgnd_1
XFILLER_26_168 VGND VGND VPWR VPWR sky130_fd_sc_hd__decap_3
XFILLER_54_477 VGND VGND VPWR VPWR sky130_fd_sc_hd__decap_3
XFILLER_81_252 VGND VGND VPWR VPWR sky130_fd_sc_hd__decap_3
X_7986_ _8389_/CLK _7986_/D VGND VGND VPWR VPWR _7986_/Q sky130_fd_sc_hd__dfxtp_2
XTAP_TAPCELL_ROW_1_278 VGND VPWR sky130_fd_sc_hd__tapvpwrvgnd_1
XFILLER_41_138 VGND VGND VPWR VPWR sky130_fd_sc_hd__decap_3
X_6937_ _8266_/Q _5337_/A _5093_/X VGND VGND VPWR VPWR _6937_/X sky130_fd_sc_hd__o21a_2
XFILLER_22_330 VGND VGND VPWR VPWR sky130_fd_sc_hd__fill_2
XFILLER_22_341 VGND VGND VPWR VPWR sky130_fd_sc_hd__decap_3
X_6868_ _7193_/A _6867_/X _6533_/A VGND VGND VPWR VPWR _6868_/Y sky130_fd_sc_hd__o21ai_2
XFILLER_10_525 VGND VGND VPWR VPWR sky130_fd_sc_hd__decap_3
XFILLER_22_374 VGND VGND VPWR VPWR sky130_fd_sc_hd__fill_1
XFILLER_50_694 VGND VGND VPWR VPWR sky130_fd_sc_hd__decap_3
X_5819_ _5897_/A _5815_/X _5816_/X _5818_/Y VGND VGND VPWR VPWR _5819_/X sky130_fd_sc_hd__a22o_2
XFILLER_41_57 VGND VGND VPWR VPWR sky130_fd_sc_hd__fill_1
XFILLER_6_507 VGND VGND VPWR VPWR sky130_fd_sc_hd__decap_3
X_6799_ _6799_/A VGND VGND VPWR VPWR _6799_/Y sky130_fd_sc_hd__inv_2
XTAP_TAPCELL_ROW_20_520 VGND VPWR sky130_fd_sc_hd__tapvpwrvgnd_1
XFILLER_108_446 VGND VGND VPWR VPWR sky130_fd_sc_hd__decap_3
XFILLER_2_713 VGND VGND VPWR VPWR sky130_fd_sc_hd__decap_3
XTAP_TAPCELL_ROW_75_1238 VGND VPWR sky130_fd_sc_hd__tapvpwrvgnd_1
XFILLER_104_641 VGND VGND VPWR VPWR sky130_fd_sc_hd__decap_3
XFILLER_89_341 VGND VGND VPWR VPWR sky130_fd_sc_hd__fill_2
XFILLER_103_140 VGND VGND VPWR VPWR sky130_fd_sc_hd__decap_3
XFILLER_104_663 VGND VGND VPWR VPWR sky130_fd_sc_hd__decap_3
XFILLER_104_674 VGND VGND VPWR VPWR sky130_fd_sc_hd__fill_2
XFILLER_49_205 VGND VGND VPWR VPWR sky130_fd_sc_hd__fill_1
XFILLER_89_374 VGND VGND VPWR VPWR sky130_fd_sc_hd__decap_3
XTAP_TAPCELL_ROW_9_378 VGND VPWR sky130_fd_sc_hd__tapvpwrvgnd_1
XFILLER_103_184 VGND VGND VPWR VPWR sky130_fd_sc_hd__decap_3
XFILLER_2_29 VGND VGND VPWR VPWR sky130_fd_sc_hd__fill_2
XFILLER_49_216 VGND VGND VPWR VPWR sky130_fd_sc_hd__decap_3
XFILLER_77_525 VGND VGND VPWR VPWR sky130_fd_sc_hd__decap_3
XFILLER_66_43 VGND VGND VPWR VPWR sky130_fd_sc_hd__decap_3
XFILLER_18_625 VGND VGND VPWR VPWR sky130_fd_sc_hd__decap_3
XFILLER_57_260 VGND VGND VPWR VPWR sky130_fd_sc_hd__decap_3
XFILLER_66_76 VGND VGND VPWR VPWR sky130_fd_sc_hd__decap_3
XFILLER_17_113 VGND VGND VPWR VPWR sky130_fd_sc_hd__decap_3
XFILLER_45_422 VGND VGND VPWR VPWR sky130_fd_sc_hd__decap_3
XFILLER_45_444 VGND VGND VPWR VPWR sky130_fd_sc_hd__decap_3
XFILLER_57_293 VGND VGND VPWR VPWR sky130_fd_sc_hd__decap_3
XFILLER_72_230 VGND VGND VPWR VPWR sky130_fd_sc_hd__decap_3
XTAP_TAPCELL_ROW_28_620 VGND VPWR sky130_fd_sc_hd__tapvpwrvgnd_1
XFILLER_17_157 VGND VGND VPWR VPWR sky130_fd_sc_hd__decap_3
XFILLER_33_617 VGND VGND VPWR VPWR sky130_fd_sc_hd__decap_3
XFILLER_33_628 VGND VGND VPWR VPWR sky130_fd_sc_hd__decap_3
XFILLER_60_403 VGND VGND VPWR VPWR sky130_fd_sc_hd__decap_3
XTAP_TAPCELL_ROW_86_1378 VGND VPWR sky130_fd_sc_hd__tapvpwrvgnd_1
XTAP_TAPCELL_ROW_56_984 VGND VPWR sky130_fd_sc_hd__tapvpwrvgnd_1
XFILLER_72_274 VGND VGND VPWR VPWR sky130_fd_sc_hd__decap_3
XFILLER_13_352 VGND VGND VPWR VPWR sky130_fd_sc_hd__decap_3
XFILLER_25_190 VGND VGND VPWR VPWR sky130_fd_sc_hd__decap_3
XFILLER_41_661 VGND VGND VPWR VPWR sky130_fd_sc_hd__fill_2
XFILLER_82_97 VGND VGND VPWR VPWR sky130_fd_sc_hd__decap_3
XFILLER_40_171 VGND VGND VPWR VPWR sky130_fd_sc_hd__decap_3
XFILLER_9_334 VGND VGND VPWR VPWR sky130_fd_sc_hd__fill_2
XFILLER_40_193 VGND VGND VPWR VPWR sky130_fd_sc_hd__decap_3
XFILLER_9_345 VGND VGND VPWR VPWR sky130_fd_sc_hd__decap_3
XFILLER_9_367 VGND VGND VPWR VPWR sky130_fd_sc_hd__decap_3
XFILLER_114_416 VGND VGND VPWR VPWR sky130_fd_sc_hd__decap_3
XFILLER_5_551 VGND VGND VPWR VPWR sky130_fd_sc_hd__decap_3
XFILLER_99_116 VGND VGND VPWR VPWR sky130_fd_sc_hd__decap_3
XFILLER_99_149 VGND VGND VPWR VPWR sky130_fd_sc_hd__decap_3
X_4150_ _7930_/B _7945_/Q VGND VGND VPWR VPWR _4151_/A sky130_fd_sc_hd__and2_2
XFILLER_68_569 VGND VGND VPWR VPWR sky130_fd_sc_hd__decap_3
XFILLER_95_355 VGND VGND VPWR VPWR sky130_fd_sc_hd__decap_3
X_4081_ _4081_/A VGND VGND VPWR VPWR _7978_/D sky130_fd_sc_hd__buf_1
XFILLER_36_400 VGND VGND VPWR VPWR sky130_fd_sc_hd__decap_3
XFILLER_48_271 VGND VGND VPWR VPWR sky130_fd_sc_hd__decap_3
XFILLER_83_517 VGND VGND VPWR VPWR sky130_fd_sc_hd__decap_3
XFILLER_95_388 VGND VGND VPWR VPWR sky130_fd_sc_hd__decap_3
XFILLER_95_399 VGND VGND VPWR VPWR sky130_fd_sc_hd__decap_3
XFILLER_36_433 VGND VGND VPWR VPWR sky130_fd_sc_hd__decap_3
X_7840_ _8222_/Q _7840_/B _7840_/C VGND VGND VPWR VPWR _7840_/X sky130_fd_sc_hd__or3_4
XFILLER_36_466 VGND VGND VPWR VPWR sky130_fd_sc_hd__decap_3
XFILLER_36_477 VGND VGND VPWR VPWR sky130_fd_sc_hd__decap_3
XFILLER_63_252 VGND VGND VPWR VPWR sky130_fd_sc_hd__decap_3
XFILLER_91_561 VGND VGND VPWR VPWR sky130_fd_sc_hd__decap_3
XFILLER_23_105 VGND VGND VPWR VPWR sky130_fd_sc_hd__decap_3
XFILLER_23_116 VGND VGND VPWR VPWR sky130_fd_sc_hd__decap_3
XFILLER_23_127 VGND VGND VPWR VPWR sky130_fd_sc_hd__decap_3
XFILLER_36_499 VGND VGND VPWR VPWR sky130_fd_sc_hd__decap_3
XFILLER_51_414 VGND VGND VPWR VPWR sky130_fd_sc_hd__decap_3
XFILLER_91_583 VGND VGND VPWR VPWR sky130_fd_sc_hd__decap_3
X_7771_ _6022_/B _7672_/X _7681_/X VGND VGND VPWR VPWR _7771_/Y sky130_fd_sc_hd__o21ai_2
X_4983_ _8278_/Q _4983_/B VGND VGND VPWR VPWR _4983_/Y sky130_fd_sc_hd__nor2_2
XFILLER_51_458 VGND VGND VPWR VPWR sky130_fd_sc_hd__decap_3
X_6722_ _6722_/A _6722_/B _6721_/Y VGND VGND VPWR VPWR _6722_/X sky130_fd_sc_hd__or3b_2
XFILLER_32_672 VGND VGND VPWR VPWR sky130_fd_sc_hd__decap_3
X_6653_ _8180_/Q _8181_/Q _8184_/Q _8190_/Q VGND VGND VPWR VPWR _6655_/C sky130_fd_sc_hd__or4_2
X_5604_ _5599_/X _5602_/Y _6769_/A VGND VGND VPWR VPWR _5604_/X sky130_fd_sc_hd__mux2_2
XFILLER_118_722 VGND VGND VPWR VPWR sky130_fd_sc_hd__decap_3
X_6584_ _6999_/A1 _6581_/X _6583_/X VGND VGND VPWR VPWR _6584_/X sky130_fd_sc_hd__a21o_2
X_8323_ _8352_/CLK _8323_/D VGND VGND VPWR VPWR _8323_/Q sky130_fd_sc_hd__dfxtp_2
X_5535_ _8164_/Q _8165_/Q _5535_/C VGND VGND VPWR VPWR _5688_/B sky130_fd_sc_hd__or3_4
X_8254_ _8322_/CLK _8254_/D VGND VGND VPWR VPWR _8254_/Q sky130_fd_sc_hd__dfxtp_2
X_5466_ _5157_/X _5131_/X _5596_/S VGND VGND VPWR VPWR _5466_/X sky130_fd_sc_hd__mux2_2
X_7205_ _7195_/A _7132_/B _7183_/X _8208_/Q _7204_/X VGND VGND VPWR VPWR _7205_/X
+ sky130_fd_sc_hd__o221a_2
X_4417_ _4417_/A VGND VGND VPWR VPWR _8146_/D sky130_fd_sc_hd__buf_1
X_8185_ clkload8/A _8185_/D VGND VGND VPWR VPWR _8185_/Q sky130_fd_sc_hd__dfxtp_4
X_5397_ _5397_/A VGND VGND VPWR VPWR _5398_/A sky130_fd_sc_hd__buf_1
XFILLER_113_493 VGND VGND VPWR VPWR sky130_fd_sc_hd__decap_3
XFILLER_59_514 VGND VGND VPWR VPWR sky130_fd_sc_hd__fill_2
XFILLER_59_547 VGND VGND VPWR VPWR sky130_fd_sc_hd__decap_3
XFILLER_86_300 VGND VGND VPWR VPWR sky130_fd_sc_hd__decap_3
XFILLER_98_171 VGND VGND VPWR VPWR sky130_fd_sc_hd__decap_3
X_7136_ _5671_/A _6008_/A _6067_/Y VGND VGND VPWR VPWR _7136_/X sky130_fd_sc_hd__a21bo_2
X_4348_ _7898_/B _4348_/B VGND VGND VPWR VPWR _4349_/A sky130_fd_sc_hd__and2_2
XTAP_TAPCELL_ROW_6_337 VGND VPWR sky130_fd_sc_hd__tapvpwrvgnd_1
XFILLER_86_344 VGND VGND VPWR VPWR sky130_fd_sc_hd__decap_3
XFILLER_98_193 VGND VGND VPWR VPWR sky130_fd_sc_hd__decap_3
X_7067_ _7067_/A VGND VGND VPWR VPWR _7068_/C sky130_fd_sc_hd__inv_2
X_4279_ _4279_/A VGND VGND VPWR VPWR _8077_/D sky130_fd_sc_hd__buf_1
XTAP_TAPCELL_ROW_70_1168 VGND VPWR sky130_fd_sc_hd__tapvpwrvgnd_1
XFILLER_100_176 VGND VGND VPWR VPWR sky130_fd_sc_hd__decap_3
XFILLER_101_677 VGND VGND VPWR VPWR sky130_fd_sc_hd__fill_1
XFILLER_67_580 VGND VGND VPWR VPWR sky130_fd_sc_hd__fill_1
XFILLER_86_377 VGND VGND VPWR VPWR sky130_fd_sc_hd__decap_3
X_6018_ _5159_/X _5174_/X _6819_/A VGND VGND VPWR VPWR _6018_/X sky130_fd_sc_hd__mux2_2
XFILLER_27_444 VGND VGND VPWR VPWR sky130_fd_sc_hd__decap_3
XFILLER_39_293 VGND VGND VPWR VPWR sky130_fd_sc_hd__decap_3
XFILLER_54_230 VGND VGND VPWR VPWR sky130_fd_sc_hd__decap_3
XFILLER_27_455 VGND VGND VPWR VPWR sky130_fd_sc_hd__decap_3
XFILLER_36_57 VGND VGND VPWR VPWR sky130_fd_sc_hd__decap_3
XFILLER_42_403 VGND VGND VPWR VPWR sky130_fd_sc_hd__decap_3
XFILLER_70_701 VGND VGND VPWR VPWR sky130_fd_sc_hd__decap_3
XFILLER_15_628 VGND VGND VPWR VPWR sky130_fd_sc_hd__decap_3
XFILLER_42_436 VGND VGND VPWR VPWR sky130_fd_sc_hd__decap_3
XFILLER_54_274 VGND VGND VPWR VPWR sky130_fd_sc_hd__decap_3
X_7969_ _8384_/CLK _7969_/D VGND VGND VPWR VPWR _7969_/Q sky130_fd_sc_hd__dfxtp_2
XTAP_TAPCELL_ROW_53_943 VGND VPWR sky130_fd_sc_hd__tapvpwrvgnd_1
XFILLER_14_138 VGND VGND VPWR VPWR sky130_fd_sc_hd__fill_2
XFILLER_23_650 VGND VGND VPWR VPWR sky130_fd_sc_hd__decap_3
XTAP_TAPCELL_ROW_53_954 VGND VPWR sky130_fd_sc_hd__tapvpwrvgnd_1
XFILLER_52_45 VGND VGND VPWR VPWR sky130_fd_sc_hd__fill_1
XFILLER_10_333 VGND VGND VPWR VPWR sky130_fd_sc_hd__fill_2
XFILLER_10_344 VGND VGND VPWR VPWR sky130_fd_sc_hd__decap_3
XFILLER_22_193 VGND VGND VPWR VPWR sky130_fd_sc_hd__decap_3
XFILLER_6_315 VGND VGND VPWR VPWR sky130_fd_sc_hd__decap_3
XFILLER_108_221 VGND VGND VPWR VPWR sky130_fd_sc_hd__decap_3
XFILLER_10_388 VGND VGND VPWR VPWR sky130_fd_sc_hd__fill_1
XFILLER_10_399 VGND VGND VPWR VPWR sky130_fd_sc_hd__decap_3
XFILLER_6_359 VGND VGND VPWR VPWR sky130_fd_sc_hd__decap_3
XFILLER_108_265 VGND VGND VPWR VPWR sky130_fd_sc_hd__decap_3
XFILLER_2_587 VGND VGND VPWR VPWR sky130_fd_sc_hd__fill_1
XFILLER_77_311 VGND VGND VPWR VPWR sky130_fd_sc_hd__decap_3
XFILLER_77_53 VGND VGND VPWR VPWR sky130_fd_sc_hd__decap_3
XFILLER_89_193 VGND VGND VPWR VPWR sky130_fd_sc_hd__decap_3
XTAP_TAPCELL_ROW_88_1407 VGND VPWR sky130_fd_sc_hd__tapvpwrvgnd_1
XFILLER_37_219 VGND VGND VPWR VPWR sky130_fd_sc_hd__decap_3
XFILLER_65_517 VGND VGND VPWR VPWR sky130_fd_sc_hd__fill_2
XFILLER_77_366 VGND VGND VPWR VPWR sky130_fd_sc_hd__decap_3
XFILLER_92_325 VGND VGND VPWR VPWR sky130_fd_sc_hd__decap_3
XFILLER_18_411 VGND VGND VPWR VPWR sky130_fd_sc_hd__fill_2
XFILLER_45_252 VGND VGND VPWR VPWR sky130_fd_sc_hd__decap_3
XFILLER_73_550 VGND VGND VPWR VPWR sky130_fd_sc_hd__decap_3
XFILLER_73_561 VGND VGND VPWR VPWR sky130_fd_sc_hd__decap_3
XFILLER_93_63 VGND VGND VPWR VPWR sky130_fd_sc_hd__decap_3
XFILLER_18_488 VGND VGND VPWR VPWR sky130_fd_sc_hd__decap_3
XFILLER_33_414 VGND VGND VPWR VPWR sky130_fd_sc_hd__decap_3
XFILLER_60_200 VGND VGND VPWR VPWR sky130_fd_sc_hd__decap_3
XFILLER_93_96 VGND VGND VPWR VPWR sky130_fd_sc_hd__fill_2
XFILLER_33_447 VGND VGND VPWR VPWR sky130_fd_sc_hd__fill_1
XFILLER_33_458 VGND VGND VPWR VPWR sky130_fd_sc_hd__decap_3
XFILLER_60_233 VGND VGND VPWR VPWR sky130_fd_sc_hd__decap_3
XFILLER_60_277 VGND VGND VPWR VPWR sky130_fd_sc_hd__decap_3
XFILLER_119_508 VGND VGND VPWR VPWR sky130_fd_sc_hd__fill_1
XFILLER_14_694 VGND VGND VPWR VPWR sky130_fd_sc_hd__decap_3
XFILLER_41_480 VGND VGND VPWR VPWR sky130_fd_sc_hd__decap_3
XTAP_TAPCELL_ROW_31_659 VGND VPWR sky130_fd_sc_hd__tapvpwrvgnd_1
XFILLER_9_175 VGND VGND VPWR VPWR sky130_fd_sc_hd__decap_3
XTAP_TAPCELL_ROW_99_1547 VGND VPWR sky130_fd_sc_hd__tapvpwrvgnd_1
XFILLER_115_725 VGND VGND VPWR VPWR sky130_fd_sc_hd__decap_3
XFILLER_54_3 VGND VGND VPWR VPWR sky130_fd_sc_hd__decap_3
X_5320_ _5411_/B _6148_/A _5318_/X _5817_/A _5430_/A VGND VGND VPWR VPWR _5320_/X
+ sky130_fd_sc_hd__a221o_2
X_5251_ _5310_/A _5491_/C _7805_/A VGND VGND VPWR VPWR _5251_/X sky130_fd_sc_hd__mux2_2
XFILLER_102_419 VGND VGND VPWR VPWR sky130_fd_sc_hd__fill_1
XFILLER_114_246 VGND VGND VPWR VPWR sky130_fd_sc_hd__decap_3
XFILLER_114_268 VGND VGND VPWR VPWR sky130_fd_sc_hd__decap_3
X_4202_ _7898_/B _4202_/B VGND VGND VPWR VPWR _4203_/A sky130_fd_sc_hd__and2_2
XFILLER_87_119 VGND VGND VPWR VPWR sky130_fd_sc_hd__decap_3
X_5182_ _5182_/A VGND VGND VPWR VPWR _6784_/A sky130_fd_sc_hd__buf_1
XFILLER_110_430 VGND VGND VPWR VPWR sky130_fd_sc_hd__decap_3
XFILLER_3_72 VGND VGND VPWR VPWR sky130_fd_sc_hd__decap_3
XFILLER_68_344 VGND VGND VPWR VPWR sky130_fd_sc_hd__decap_3
XFILLER_95_130 VGND VGND VPWR VPWR sky130_fd_sc_hd__decap_3
X_4133_ _4133_/A VGND VGND VPWR VPWR _8004_/D sky130_fd_sc_hd__buf_1
XFILLER_110_485 VGND VGND VPWR VPWR sky130_fd_sc_hd__decap_3
XFILLER_113_18 VGND VGND VPWR VPWR sky130_fd_sc_hd__decap_3
XFILLER_28_219 VGND VGND VPWR VPWR sky130_fd_sc_hd__fill_2
XFILLER_56_539 VGND VGND VPWR VPWR sky130_fd_sc_hd__fill_1
XFILLER_68_388 VGND VGND VPWR VPWR sky130_fd_sc_hd__decap_3
XFILLER_83_303 VGND VGND VPWR VPWR sky130_fd_sc_hd__decap_3
XFILLER_95_163 VGND VGND VPWR VPWR sky130_fd_sc_hd__decap_3
XFILLER_96_697 VGND VGND VPWR VPWR sky130_fd_sc_hd__decap_3
X_4064_ _7898_/B _8373_/Q VGND VGND VPWR VPWR _4065_/A sky130_fd_sc_hd__and2_2
XFILLER_95_185 VGND VGND VPWR VPWR sky130_fd_sc_hd__decap_3
XFILLER_24_403 VGND VGND VPWR VPWR sky130_fd_sc_hd__decap_3
XTAP_TAPCELL_ROW_108_1665 VGND VPWR sky130_fd_sc_hd__tapvpwrvgnd_1
XFILLER_51_211 VGND VGND VPWR VPWR sky130_fd_sc_hd__decap_3
XFILLER_64_572 VGND VGND VPWR VPWR sky130_fd_sc_hd__decap_3
X_7823_ _7652_/Y _7795_/X _7804_/X _7822_/X VGND VGND VPWR VPWR _7823_/X sky130_fd_sc_hd__a31o_2
XFILLER_24_447 VGND VGND VPWR VPWR sky130_fd_sc_hd__decap_3
X_7754_ _7754_/A _7754_/B VGND VGND VPWR VPWR _7754_/Y sky130_fd_sc_hd__nand2_2
XFILLER_51_266 VGND VGND VPWR VPWR sky130_fd_sc_hd__decap_3
X_6705_ _8195_/Q _8194_/Q _8193_/Q _8192_/Q _6380_/S _5452_/S VGND VGND VPWR VPWR
+ _6705_/X sky130_fd_sc_hd__mux4_2
X_4966_ _6706_/S _5491_/C VGND VGND VPWR VPWR _5316_/A sky130_fd_sc_hd__xor2_2
XTAP_TAPCELL_ROW_50_913 VGND VPWR sky130_fd_sc_hd__tapvpwrvgnd_1
XFILLER_20_642 VGND VGND VPWR VPWR sky130_fd_sc_hd__fill_2
XFILLER_32_480 VGND VGND VPWR VPWR sky130_fd_sc_hd__decap_3
XFILLER_51_299 VGND VGND VPWR VPWR sky130_fd_sc_hd__decap_3
X_7685_ _7783_/A _8221_/Q _7820_/B VGND VGND VPWR VPWR _7685_/X sky130_fd_sc_hd__and3_2
X_4897_ _4897_/A _4897_/B VGND VGND VPWR VPWR _6297_/C sky130_fd_sc_hd__nand2_2
XFILLER_20_664 VGND VGND VPWR VPWR sky130_fd_sc_hd__decap_3
X_6636_ _6636_/A _6636_/B VGND VGND VPWR VPWR _6636_/Y sky130_fd_sc_hd__xnor2_2
X_6567_ _6567_/A _6567_/B VGND VGND VPWR VPWR _6568_/B sky130_fd_sc_hd__and2_4
XFILLER_105_202 VGND VGND VPWR VPWR sky130_fd_sc_hd__decap_3
XFILLER_98_19 VGND VGND VPWR VPWR sky130_fd_sc_hd__fill_2
X_8306_ _8377_/CLK _8306_/D VGND VGND VPWR VPWR _8306_/Q sky130_fd_sc_hd__dfxtp_2
X_5518_ _6648_/A _5517_/X _5515_/X VGND VGND VPWR VPWR _5518_/X sky130_fd_sc_hd__a21o_2
X_6498_ _6496_/Y _6334_/A _6497_/X VGND VGND VPWR VPWR _6498_/Y sky130_fd_sc_hd__o21ai_2
X_8237_ clkload5/A _8237_/D VGND VGND VPWR VPWR _8237_/Q sky130_fd_sc_hd__dfxtp_2
X_5449_ _5230_/X _5225_/X _5451_/S VGND VGND VPWR VPWR _5449_/X sky130_fd_sc_hd__mux2_2
XFILLER_59_311 VGND VGND VPWR VPWR sky130_fd_sc_hd__decap_3
XFILLER_59_322 VGND VGND VPWR VPWR sky130_fd_sc_hd__decap_3
X_8168_ clkload7/A _8168_/D VGND VGND VPWR VPWR _8168_/Q sky130_fd_sc_hd__dfxtp_4
XFILLER_101_441 VGND VGND VPWR VPWR sky130_fd_sc_hd__fill_1
XFILLER_59_355 VGND VGND VPWR VPWR sky130_fd_sc_hd__fill_2
XFILLER_86_141 VGND VGND VPWR VPWR sky130_fd_sc_hd__fill_2
X_7119_ _7110_/X _7111_/X _7119_/C _7119_/D VGND VGND VPWR VPWR _7119_/X sky130_fd_sc_hd__and4bb_2
XFILLER_101_463 VGND VGND VPWR VPWR sky130_fd_sc_hd__decap_3
XFILLER_47_34 VGND VGND VPWR VPWR sky130_fd_sc_hd__decap_3
XFILLER_59_388 VGND VGND VPWR VPWR sky130_fd_sc_hd__decap_3
XFILLER_74_303 VGND VGND VPWR VPWR sky130_fd_sc_hd__decap_3
XFILLER_86_152 VGND VGND VPWR VPWR sky130_fd_sc_hd__decap_3
XFILLER_86_174 VGND VGND VPWR VPWR sky130_fd_sc_hd__decap_3
X_8099_ clkload7/A _8099_/D VGND VGND VPWR VPWR _8099_/Q sky130_fd_sc_hd__dfxtp_2
XFILLER_47_78 VGND VGND VPWR VPWR sky130_fd_sc_hd__decap_3
XFILLER_59_399 VGND VGND VPWR VPWR sky130_fd_sc_hd__decap_3
XFILLER_74_336 VGND VGND VPWR VPWR sky130_fd_sc_hd__decap_3
XFILLER_62_509 VGND VGND VPWR VPWR sky130_fd_sc_hd__decap_3
XFILLER_15_403 VGND VGND VPWR VPWR sky130_fd_sc_hd__decap_3
XFILLER_27_263 VGND VGND VPWR VPWR sky130_fd_sc_hd__decap_3
XFILLER_42_200 VGND VGND VPWR VPWR sky130_fd_sc_hd__decap_3
XFILLER_43_712 VGND VGND VPWR VPWR sky130_fd_sc_hd__fill_2
XFILLER_63_11 VGND VGND VPWR VPWR sky130_fd_sc_hd__fill_1
XFILLER_82_380 VGND VGND VPWR VPWR sky130_fd_sc_hd__decap_3
XTAP_TAPCELL_ROW_83_1337 VGND VPWR sky130_fd_sc_hd__tapvpwrvgnd_1
XFILLER_15_447 VGND VGND VPWR VPWR sky130_fd_sc_hd__fill_1
XFILLER_42_233 VGND VGND VPWR VPWR sky130_fd_sc_hd__decap_3
XFILLER_63_55 VGND VGND VPWR VPWR sky130_fd_sc_hd__fill_1
XFILLER_63_66 VGND VGND VPWR VPWR sky130_fd_sc_hd__decap_3
XFILLER_30_417 VGND VGND VPWR VPWR sky130_fd_sc_hd__decap_3
XFILLER_42_288 VGND VGND VPWR VPWR sky130_fd_sc_hd__decap_3
XFILLER_70_586 VGND VGND VPWR VPWR sky130_fd_sc_hd__fill_2
XFILLER_10_141 VGND VGND VPWR VPWR sky130_fd_sc_hd__decap_3
XFILLER_11_664 VGND VGND VPWR VPWR sky130_fd_sc_hd__decap_3
XFILLER_109_574 VGND VGND VPWR VPWR sky130_fd_sc_hd__decap_3
XFILLER_12_70 VGND VGND VPWR VPWR sky130_fd_sc_hd__decap_3
XFILLER_7_668 VGND VGND VPWR VPWR sky130_fd_sc_hd__decap_3
XFILLER_6_189 VGND VGND VPWR VPWR sky130_fd_sc_hd__decap_3
XFILLER_88_63 VGND VGND VPWR VPWR sky130_fd_sc_hd__decap_3
XFILLER_97_406 VGND VGND VPWR VPWR sky130_fd_sc_hd__decap_3
XTAP_TAPCELL_ROW_94_1477 VGND VPWR sky130_fd_sc_hd__tapvpwrvgnd_1
XFILLER_111_216 VGND VGND VPWR VPWR sky130_fd_sc_hd__decap_3
XFILLER_69_119 VGND VGND VPWR VPWR sky130_fd_sc_hd__decap_3
XFILLER_104_290 VGND VGND VPWR VPWR sky130_fd_sc_hd__fill_1
XFILLER_78_653 VGND VGND VPWR VPWR sky130_fd_sc_hd__fill_1
XFILLER_65_314 VGND VGND VPWR VPWR sky130_fd_sc_hd__decap_3
XFILLER_78_697 VGND VGND VPWR VPWR sky130_fd_sc_hd__decap_3
XFILLER_92_100 VGND VGND VPWR VPWR sky130_fd_sc_hd__decap_3
XFILLER_93_612 VGND VGND VPWR VPWR sky130_fd_sc_hd__decap_3
XFILLER_92_122 VGND VGND VPWR VPWR sky130_fd_sc_hd__decap_3
XFILLER_93_656 VGND VGND VPWR VPWR sky130_fd_sc_hd__decap_3
XFILLER_34_701 VGND VGND VPWR VPWR sky130_fd_sc_hd__fill_2
XFILLER_46_550 VGND VGND VPWR VPWR sky130_fd_sc_hd__fill_1
XFILLER_46_561 VGND VGND VPWR VPWR sky130_fd_sc_hd__decap_3
XFILLER_65_358 VGND VGND VPWR VPWR sky130_fd_sc_hd__decap_3
XFILLER_18_274 VGND VGND VPWR VPWR sky130_fd_sc_hd__decap_3
XFILLER_61_520 VGND VGND VPWR VPWR sky130_fd_sc_hd__decap_3
XFILLER_73_380 VGND VGND VPWR VPWR sky130_fd_sc_hd__decap_3
XFILLER_80_328 VGND VGND VPWR VPWR sky130_fd_sc_hd__decap_3
XTAP_TAPCELL_ROW_36_729 VGND VPWR sky130_fd_sc_hd__tapvpwrvgnd_1
XFILLER_33_222 VGND VGND VPWR VPWR sky130_fd_sc_hd__fill_2
XFILLER_33_244 VGND VGND VPWR VPWR sky130_fd_sc_hd__decap_3
X_4820_ _4820_/A _7151_/B VGND VGND VPWR VPWR _7076_/B sky130_fd_sc_hd__nand2_2
XFILLER_21_428 VGND VGND VPWR VPWR sky130_fd_sc_hd__decap_3
XFILLER_33_266 VGND VGND VPWR VPWR sky130_fd_sc_hd__decap_3
XFILLER_33_277 VGND VGND VPWR VPWR sky130_fd_sc_hd__decap_3
XFILLER_61_564 VGND VGND VPWR VPWR sky130_fd_sc_hd__decap_3
XFILLER_61_586 VGND VGND VPWR VPWR sky130_fd_sc_hd__decap_3
XTAP_TAPCELL_ROW_16_464 VGND VPWR sky130_fd_sc_hd__tapvpwrvgnd_1
XFILLER_14_491 VGND VGND VPWR VPWR sky130_fd_sc_hd__decap_3
XTAP_TAPCELL_ROW_103_1595 VGND VPWR sky130_fd_sc_hd__tapvpwrvgnd_1
X_4751_ _8223_/Q VGND VGND VPWR VPWR _7646_/A sky130_fd_sc_hd__inv_2
X_7470_ _5627_/A _7465_/X _7469_/X _8290_/Q _6687_/A VGND VGND VPWR VPWR _7483_/B
+ sky130_fd_sc_hd__a221o_2
X_4682_ _7930_/B _8145_/Q VGND VGND VPWR VPWR _4683_/A sky130_fd_sc_hd__and2_2
XFILLER_119_349 VGND VGND VPWR VPWR sky130_fd_sc_hd__decap_3
X_6421_ _6420_/X _6128_/X _6421_/S VGND VGND VPWR VPWR _6422_/B sky130_fd_sc_hd__mux2_2
XFILLER_115_500 VGND VGND VPWR VPWR sky130_fd_sc_hd__decap_3
X_6352_ _6109_/A _6351_/X _5186_/A VGND VGND VPWR VPWR _6352_/Y sky130_fd_sc_hd__o21ai_2
X_6283_ _6910_/A _6256_/Y _6259_/X _6589_/B2 _6282_/X VGND VGND VPWR VPWR _6284_/B
+ sky130_fd_sc_hd__a221o_2
X_5303_ _5491_/A split/A VGND VGND VPWR VPWR _5304_/S sky130_fd_sc_hd__xnor2_2
XFILLER_102_227 VGND VGND VPWR VPWR sky130_fd_sc_hd__decap_3
XFILLER_69_620 VGND VGND VPWR VPWR sky130_fd_sc_hd__fill_1
X_8022_ _8269_/CLK _8022_/D VGND VGND VPWR VPWR _8022_/Q sky130_fd_sc_hd__dfxtp_2
X_5234_ _5232_/X _5233_/X _5451_/S VGND VGND VPWR VPWR _5234_/X sky130_fd_sc_hd__mux2_2
XFILLER_69_642 VGND VGND VPWR VPWR sky130_fd_sc_hd__decap_3
X_5165_ _5163_/X _5164_/X _7653_/A VGND VGND VPWR VPWR _5165_/X sky130_fd_sc_hd__mux2_2
XFILLER_29_517 VGND VGND VPWR VPWR sky130_fd_sc_hd__decap_3
X_4116_ _7930_/B _8399_/Q VGND VGND VPWR VPWR _4117_/A sky130_fd_sc_hd__and2_2
XFILLER_110_271 VGND VGND VPWR VPWR sky130_fd_sc_hd__fill_1
XFILLER_56_336 VGND VGND VPWR VPWR sky130_fd_sc_hd__decap_3
XFILLER_68_185 VGND VGND VPWR VPWR sky130_fd_sc_hd__fill_1
XFILLER_96_483 VGND VGND VPWR VPWR sky130_fd_sc_hd__decap_3
X_5096_ split/X _5435_/A _4718_/B _6763_/A _5095_/X VGND VGND VPWR VPWR _5096_/X sky130_fd_sc_hd__o32a_2
XFILLER_37_561 VGND VGND VPWR VPWR sky130_fd_sc_hd__fill_2
XFILLER_84_678 VGND VGND VPWR VPWR sky130_fd_sc_hd__decap_3
X_4047_ _4047_/A VGND VGND VPWR VPWR _7961_/D sky130_fd_sc_hd__buf_1
XFILLER_17_48 VGND VGND VPWR VPWR sky130_fd_sc_hd__decap_3
XFILLER_24_200 VGND VGND VPWR VPWR sky130_fd_sc_hd__decap_3
XFILLER_37_583 VGND VGND VPWR VPWR sky130_fd_sc_hd__decap_3
XFILLER_83_199 VGND VGND VPWR VPWR sky130_fd_sc_hd__decap_3
XFILLER_24_233 VGND VGND VPWR VPWR sky130_fd_sc_hd__decap_3
XFILLER_52_542 VGND VGND VPWR VPWR sky130_fd_sc_hd__fill_2
X_7806_ _7776_/A _8166_/Q _7670_/B _5596_/S VGND VGND VPWR VPWR _7806_/Y sky130_fd_sc_hd__a211oi_2
XFILLER_40_704 VGND VGND VPWR VPWR sky130_fd_sc_hd__fill_1
X_5998_ _5996_/X _5997_/X _5998_/S VGND VGND VPWR VPWR _5998_/X sky130_fd_sc_hd__mux2_2
XFILLER_12_439 VGND VGND VPWR VPWR sky130_fd_sc_hd__decap_3
X_7737_ _8179_/Q _7680_/B _7672_/A VGND VGND VPWR VPWR _7737_/Y sky130_fd_sc_hd__o21ai_2
X_4949_ _5528_/A _8165_/Q VGND VGND VPWR VPWR _5548_/A sky130_fd_sc_hd__xor2_2
XFILLER_33_69 VGND VGND VPWR VPWR sky130_fd_sc_hd__fill_1
X_7668_ _5785_/A _7666_/Y _7667_/X VGND VGND VPWR VPWR _7668_/Y sky130_fd_sc_hd__a21oi_2
X_6619_ _5124_/A _6615_/X _6011_/X _6618_/X VGND VGND VPWR VPWR _6619_/X sky130_fd_sc_hd__a22o_2
X_7599_ _5396_/A _8222_/Q _7597_/Y _7598_/X VGND VGND VPWR VPWR _7599_/X sky130_fd_sc_hd__a31o_2
XFILLER_106_533 VGND VGND VPWR VPWR sky130_fd_sc_hd__decap_3
XFILLER_4_638 VGND VGND VPWR VPWR sky130_fd_sc_hd__decap_3
XFILLER_106_566 VGND VGND VPWR VPWR sky130_fd_sc_hd__decap_3
XFILLER_3_159 VGND VGND VPWR VPWR sky130_fd_sc_hd__decap_3
XFILLER_58_22 VGND VGND VPWR VPWR sky130_fd_sc_hd__decap_3
XFILLER_79_428 VGND VGND VPWR VPWR sky130_fd_sc_hd__decap_3
XFILLER_47_303 VGND VGND VPWR VPWR sky130_fd_sc_hd__decap_3
XFILLER_58_77 VGND VGND VPWR VPWR sky130_fd_sc_hd__decap_3
XFILLER_58_88 VGND VGND VPWR VPWR sky130_fd_sc_hd__decap_3
XFILLER_59_163 VGND VGND VPWR VPWR sky130_fd_sc_hd__decap_3
XFILLER_75_612 VGND VGND VPWR VPWR sky130_fd_sc_hd__decap_3
XFILLER_75_645 VGND VGND VPWR VPWR sky130_fd_sc_hd__decap_3
XFILLER_16_701 VGND VGND VPWR VPWR sky130_fd_sc_hd__decap_3
XFILLER_74_144 VGND VGND VPWR VPWR sky130_fd_sc_hd__decap_3
XFILLER_74_32 VGND VGND VPWR VPWR sky130_fd_sc_hd__decap_3
XFILLER_90_604 VGND VGND VPWR VPWR sky130_fd_sc_hd__decap_3
XFILLER_62_339 VGND VGND VPWR VPWR sky130_fd_sc_hd__decap_3
XFILLER_74_177 VGND VGND VPWR VPWR sky130_fd_sc_hd__decap_3
XFILLER_74_54 VGND VGND VPWR VPWR sky130_fd_sc_hd__decap_3
XFILLER_74_98 VGND VGND VPWR VPWR sky130_fd_sc_hd__decap_3
XFILLER_15_255 VGND VGND VPWR VPWR sky130_fd_sc_hd__decap_3
XFILLER_15_277 VGND VGND VPWR VPWR sky130_fd_sc_hd__decap_3
XFILLER_30_203 VGND VGND VPWR VPWR sky130_fd_sc_hd__decap_3
XFILLER_43_564 VGND VGND VPWR VPWR sky130_fd_sc_hd__fill_2
XFILLER_90_20 VGND VGND VPWR VPWR sky130_fd_sc_hd__decap_3
XFILLER_90_53 VGND VGND VPWR VPWR sky130_fd_sc_hd__decap_3
XTAP_TAPCELL_ROW_13_423 VGND VPWR sky130_fd_sc_hd__tapvpwrvgnd_1
XTAP_TAPCELL_ROW_13_434 VGND VPWR sky130_fd_sc_hd__tapvpwrvgnd_1
XFILLER_7_410 VGND VGND VPWR VPWR sky130_fd_sc_hd__decap_3
XTAP_TAPCELL_ROW_96_1506 VGND VPWR sky130_fd_sc_hd__tapvpwrvgnd_1
XTAP_TAPCELL_ROW_41_798 VGND VPWR sky130_fd_sc_hd__tapvpwrvgnd_1
XTAP_TAPCELL_ROW_41_787 VGND VPWR sky130_fd_sc_hd__tapvpwrvgnd_1
XFILLER_109_382 VGND VGND VPWR VPWR sky130_fd_sc_hd__decap_3
XFILLER_109_393 VGND VGND VPWR VPWR sky130_fd_sc_hd__decap_3
XFILLER_7_487 VGND VGND VPWR VPWR sky130_fd_sc_hd__decap_3
XFILLER_99_95 VGND VGND VPWR VPWR sky130_fd_sc_hd__decap_3
XFILLER_97_225 VGND VGND VPWR VPWR sky130_fd_sc_hd__decap_3
XFILLER_66_601 VGND VGND VPWR VPWR sky130_fd_sc_hd__decap_3
XFILLER_65_122 VGND VGND VPWR VPWR sky130_fd_sc_hd__decap_3
XFILLER_66_623 VGND VGND VPWR VPWR sky130_fd_sc_hd__decap_3
XFILLER_66_645 VGND VGND VPWR VPWR sky130_fd_sc_hd__fill_1
XFILLER_93_431 VGND VGND VPWR VPWR sky130_fd_sc_hd__decap_3
XFILLER_19_550 VGND VGND VPWR VPWR sky130_fd_sc_hd__fill_2
XFILLER_65_155 VGND VGND VPWR VPWR sky130_fd_sc_hd__decap_3
XFILLER_66_656 VGND VGND VPWR VPWR sky130_fd_sc_hd__decap_3
XFILLER_66_689 VGND VGND VPWR VPWR sky130_fd_sc_hd__fill_1
XFILLER_93_464 VGND VGND VPWR VPWR sky130_fd_sc_hd__decap_3
X_6970_ _8266_/Q _6963_/B _6969_/X VGND VGND VPWR VPWR _6970_/X sky130_fd_sc_hd__o21a_4
XFILLER_19_561 VGND VGND VPWR VPWR sky130_fd_sc_hd__decap_3
XFILLER_65_199 VGND VGND VPWR VPWR sky130_fd_sc_hd__decap_3
X_5921_ _6109_/A _5920_/X _5186_/A VGND VGND VPWR VPWR _5921_/Y sky130_fd_sc_hd__o21ai_2
XTAP_TAPCELL_ROW_49_898 VGND VPWR sky130_fd_sc_hd__tapvpwrvgnd_1
XFILLER_34_531 VGND VGND VPWR VPWR sky130_fd_sc_hd__fill_1
XFILLER_34_542 VGND VGND VPWR VPWR sky130_fd_sc_hd__fill_1
XTAP_TAPCELL_ROW_105_1624 VGND VPWR sky130_fd_sc_hd__tapvpwrvgnd_1
XFILLER_21_203 VGND VGND VPWR VPWR sky130_fd_sc_hd__decap_3
XFILLER_34_586 VGND VGND VPWR VPWR sky130_fd_sc_hd__fill_2
XFILLER_61_372 VGND VGND VPWR VPWR sky130_fd_sc_hd__decap_3
X_5852_ _6497_/B _7195_/B _5816_/X _5851_/Y _5897_/A _4927_/A VGND VGND VPWR VPWR
+ _5852_/X sky130_fd_sc_hd__mux4_2
XFILLER_21_225 VGND VGND VPWR VPWR sky130_fd_sc_hd__decap_3
X_5783_ _5350_/A _5746_/X _5782_/Y _6707_/S VGND VGND VPWR VPWR _5783_/X sky130_fd_sc_hd__o22a_2
X_4803_ _8206_/Q VGND VGND VPWR VPWR _4805_/A sky130_fd_sc_hd__inv_2
XFILLER_9_60 VGND VGND VPWR VPWR sky130_fd_sc_hd__fill_2
X_7522_ _7522_/A _7522_/B VGND VGND VPWR VPWR _7522_/X sky130_fd_sc_hd__xor2_2
X_4734_ _8283_/Q VGND VGND VPWR VPWR _4736_/B sky130_fd_sc_hd__inv_2
Xrebuffer507 _7473_/A2 VGND VGND VPWR VPWR _7475_/B sky130_fd_sc_hd__buf_2
X_7453_ _7453_/A _7453_/B _7453_/C _7452_/X VGND VGND VPWR VPWR _7453_/X sky130_fd_sc_hd__or4b_2
X_4665_ _4665_/A VGND VGND VPWR VPWR _8270_/D sky130_fd_sc_hd__buf_1
X_7384_ _8213_/Q _8214_/Q _7384_/C VGND VGND VPWR VPWR _7438_/C sky130_fd_sc_hd__and3_2
X_6404_ _6411_/A _6405_/B VGND VGND VPWR VPWR _6404_/X sky130_fd_sc_hd__or2_2
X_4596_ _7898_/B _8102_/Q VGND VGND VPWR VPWR _4597_/A sky130_fd_sc_hd__and2_2
XFILLER_115_352 VGND VGND VPWR VPWR sky130_fd_sc_hd__decap_3
XFILLER_89_704 VGND VGND VPWR VPWR sky130_fd_sc_hd__decap_3
XTAP_TAPCELL_ROW_116_1764 VGND VPWR sky130_fd_sc_hd__tapvpwrvgnd_1
X_6335_ _8184_/Q _7562_/A _6336_/B VGND VGND VPWR VPWR _6433_/C sky130_fd_sc_hd__and3_2
XFILLER_103_503 VGND VGND VPWR VPWR sky130_fd_sc_hd__fill_1
XFILLER_103_514 VGND VGND VPWR VPWR sky130_fd_sc_hd__fill_1
XFILLER_115_363 VGND VGND VPWR VPWR sky130_fd_sc_hd__decap_3
XFILLER_103_558 VGND VGND VPWR VPWR sky130_fd_sc_hd__fill_2
XFILLER_115_396 VGND VGND VPWR VPWR sky130_fd_sc_hd__fill_2
X_8005_ _8390_/CLK _8005_/D VGND VGND VPWR VPWR _8005_/Q sky130_fd_sc_hd__dfxtp_2
X_6266_ _6264_/X _6265_/X _5626_/A VGND VGND VPWR VPWR _6266_/X sky130_fd_sc_hd__o21a_2
XFILLER_69_461 VGND VGND VPWR VPWR sky130_fd_sc_hd__decap_3
X_6197_ _6195_/X _6197_/B VGND VGND VPWR VPWR _6197_/X sky130_fd_sc_hd__and2b_2
X_5217_ _8213_/Q _8214_/Q _5484_/S VGND VGND VPWR VPWR _5217_/X sky130_fd_sc_hd__mux2_2
XFILLER_28_47 VGND VGND VPWR VPWR sky130_fd_sc_hd__decap_3
XFILLER_29_314 VGND VGND VPWR VPWR sky130_fd_sc_hd__decap_3
XFILLER_29_325 VGND VGND VPWR VPWR sky130_fd_sc_hd__decap_3
XFILLER_56_100 VGND VGND VPWR VPWR sky130_fd_sc_hd__decap_3
XFILLER_57_623 VGND VGND VPWR VPWR sky130_fd_sc_hd__fill_1
XFILLER_57_645 VGND VGND VPWR VPWR sky130_fd_sc_hd__fill_2
XFILLER_69_494 VGND VGND VPWR VPWR sky130_fd_sc_hd__decap_3
X_5148_ _8198_/Q _8199_/Q _5484_/S VGND VGND VPWR VPWR _5148_/X sky130_fd_sc_hd__mux2_2
XFILLER_56_144 VGND VGND VPWR VPWR sky130_fd_sc_hd__decap_3
X_5079_ _7619_/A _6767_/A VGND VGND VPWR VPWR _5700_/B sky130_fd_sc_hd__nand2_2
XFILLER_57_689 VGND VGND VPWR VPWR sky130_fd_sc_hd__decap_3
XFILLER_84_475 VGND VGND VPWR VPWR sky130_fd_sc_hd__fill_1
XTAP_TAPCELL_ROW_67_1129 VGND VPWR sky130_fd_sc_hd__tapvpwrvgnd_1
XFILLER_37_391 VGND VGND VPWR VPWR sky130_fd_sc_hd__fill_1
XFILLER_71_158 VGND VGND VPWR VPWR sky130_fd_sc_hd__decap_3
XFILLER_72_659 VGND VGND VPWR VPWR sky130_fd_sc_hd__decap_3
XFILLER_25_564 VGND VGND VPWR VPWR sky130_fd_sc_hd__decap_3
XFILLER_25_586 VGND VGND VPWR VPWR sky130_fd_sc_hd__fill_2
XFILLER_44_46 VGND VGND VPWR VPWR sky130_fd_sc_hd__decap_3
XFILLER_52_350 VGND VGND VPWR VPWR sky130_fd_sc_hd__decap_3
XFILLER_71_169 VGND VGND VPWR VPWR sky130_fd_sc_hd__decap_3
XFILLER_12_214 VGND VGND VPWR VPWR sky130_fd_sc_hd__decap_3
XFILLER_12_236 VGND VGND VPWR VPWR sky130_fd_sc_hd__decap_3
XFILLER_44_79 VGND VGND VPWR VPWR sky130_fd_sc_hd__decap_3
XFILLER_52_383 VGND VGND VPWR VPWR sky130_fd_sc_hd__decap_3
XFILLER_9_708 VGND VGND VPWR VPWR sky130_fd_sc_hd__decap_3
XFILLER_40_556 VGND VGND VPWR VPWR sky130_fd_sc_hd__decap_3
XFILLER_40_578 VGND VGND VPWR VPWR sky130_fd_sc_hd__fill_2
XFILLER_8_218 VGND VGND VPWR VPWR sky130_fd_sc_hd__decap_3
XFILLER_40_589 VGND VGND VPWR VPWR sky130_fd_sc_hd__decap_3
XFILLER_60_56 VGND VGND VPWR VPWR sky130_fd_sc_hd__decap_3
XFILLER_119_691 VGND VGND VPWR VPWR sky130_fd_sc_hd__decap_3
XFILLER_4_413 VGND VGND VPWR VPWR sky130_fd_sc_hd__decap_3
XTAP_TAPCELL_ROW_78_1269 VGND VPWR sky130_fd_sc_hd__tapvpwrvgnd_1
XFILLER_106_352 VGND VGND VPWR VPWR sky130_fd_sc_hd__decap_3
XFILLER_106_374 VGND VGND VPWR VPWR sky130_fd_sc_hd__fill_1
XFILLER_79_214 VGND VGND VPWR VPWR sky130_fd_sc_hd__decap_3
XTAP_TAPCELL_ROW_91_1447 VGND VPWR sky130_fd_sc_hd__tapvpwrvgnd_1
XTAP_TAPCELL_ROW_91_1436 VGND VPWR sky130_fd_sc_hd__tapvpwrvgnd_1
XFILLER_69_98 VGND VGND VPWR VPWR sky130_fd_sc_hd__decap_3
XFILLER_79_225 VGND VGND VPWR VPWR sky130_fd_sc_hd__decap_3
XFILLER_48_612 VGND VGND VPWR VPWR sky130_fd_sc_hd__decap_3
XFILLER_95_729 VGND VGND VPWR VPWR sky130_fd_sc_hd__decap_3
XFILLER_47_111 VGND VGND VPWR VPWR sky130_fd_sc_hd__fill_1
XFILLER_48_645 VGND VGND VPWR VPWR sky130_fd_sc_hd__decap_3
XFILLER_75_420 VGND VGND VPWR VPWR sky130_fd_sc_hd__decap_3
XFILLER_85_20 VGND VGND VPWR VPWR sky130_fd_sc_hd__decap_3
XFILLER_85_42 VGND VGND VPWR VPWR sky130_fd_sc_hd__decap_3
XFILLER_48_678 VGND VGND VPWR VPWR sky130_fd_sc_hd__decap_3
XFILLER_63_604 VGND VGND VPWR VPWR sky130_fd_sc_hd__decap_3
XFILLER_75_464 VGND VGND VPWR VPWR sky130_fd_sc_hd__decap_3
XFILLER_85_75 VGND VGND VPWR VPWR sky130_fd_sc_hd__decap_3
XFILLER_62_103 VGND VGND VPWR VPWR sky130_fd_sc_hd__decap_3
XFILLER_28_380 VGND VGND VPWR VPWR sky130_fd_sc_hd__decap_3
XFILLER_62_136 VGND VGND VPWR VPWR sky130_fd_sc_hd__decap_3
XFILLER_62_147 VGND VGND VPWR VPWR sky130_fd_sc_hd__decap_3
XFILLER_63_659 VGND VGND VPWR VPWR sky130_fd_sc_hd__decap_3
XFILLER_90_445 VGND VGND VPWR VPWR sky130_fd_sc_hd__decap_3
XTAP_TAPCELL_ROW_46_857 VGND VPWR sky130_fd_sc_hd__tapvpwrvgnd_1
XFILLER_50_309 VGND VGND VPWR VPWR sky130_fd_sc_hd__decap_3
XFILLER_71_670 VGND VGND VPWR VPWR sky130_fd_sc_hd__fill_2
XFILLER_90_489 VGND VGND VPWR VPWR sky130_fd_sc_hd__fill_2
XFILLER_16_597 VGND VGND VPWR VPWR sky130_fd_sc_hd__decap_3
XFILLER_31_545 VGND VGND VPWR VPWR sky130_fd_sc_hd__decap_3
XFILLER_70_180 VGND VGND VPWR VPWR sky130_fd_sc_hd__decap_3
XTAP_TAPCELL_ROW_26_592 VGND VPWR sky130_fd_sc_hd__tapvpwrvgnd_1
XFILLER_31_578 VGND VGND VPWR VPWR sky130_fd_sc_hd__fill_1
XTAP_TAPCELL_ROW_100_1554 VGND VPWR sky130_fd_sc_hd__tapvpwrvgnd_1
XTAP_TAPCELL_ROW_100_1565 VGND VPWR sky130_fd_sc_hd__tapvpwrvgnd_1
XFILLER_117_617 VGND VGND VPWR VPWR sky130_fd_sc_hd__decap_3
XFILLER_117_639 VGND VGND VPWR VPWR sky130_fd_sc_hd__decap_3
X_4450_ _7898_/B _8029_/Q VGND VGND VPWR VPWR _4451_/A sky130_fd_sc_hd__and2_2
XFILLER_109_190 VGND VGND VPWR VPWR sky130_fd_sc_hd__decap_3
X_4381_ _4381_/A VGND VGND VPWR VPWR _8128_/D sky130_fd_sc_hd__buf_1
X_6120_ _8179_/Q _6119_/Y _6999_/A1 VGND VGND VPWR VPWR _6120_/Y sky130_fd_sc_hd__a21oi_2
XFILLER_105_19 VGND VGND VPWR VPWR sky130_fd_sc_hd__decap_3
XFILLER_112_355 VGND VGND VPWR VPWR sky130_fd_sc_hd__decap_3
XFILLER_112_377 VGND VGND VPWR VPWR sky130_fd_sc_hd__fill_2
XFILLER_85_206 VGND VGND VPWR VPWR sky130_fd_sc_hd__decap_3
XFILLER_98_589 VGND VGND VPWR VPWR sky130_fd_sc_hd__decap_3
X_6051_ _7619_/A _6048_/X _6050_/X VGND VGND VPWR VPWR _6051_/X sky130_fd_sc_hd__a21o_2
XFILLER_39_612 VGND VGND VPWR VPWR sky130_fd_sc_hd__decap_3
XFILLER_39_623 VGND VGND VPWR VPWR sky130_fd_sc_hd__decap_3
XFILLER_85_228 VGND VGND VPWR VPWR sky130_fd_sc_hd__decap_3
X_5002_ _8258_/Q _5000_/X _5001_/X VGND VGND VPWR VPWR _5002_/Y sky130_fd_sc_hd__o21ai_2
XFILLER_38_144 VGND VGND VPWR VPWR sky130_fd_sc_hd__decap_3
XFILLER_26_306 VGND VGND VPWR VPWR sky130_fd_sc_hd__fill_2
XFILLER_26_328 VGND VGND VPWR VPWR sky130_fd_sc_hd__decap_3
XFILLER_54_615 VGND VGND VPWR VPWR sky130_fd_sc_hd__decap_3
XFILLER_66_486 VGND VGND VPWR VPWR sky130_fd_sc_hd__decap_3
XFILLER_53_136 VGND VGND VPWR VPWR sky130_fd_sc_hd__decap_3
XFILLER_54_648 VGND VGND VPWR VPWR sky130_fd_sc_hd__decap_3
X_6953_ _5779_/X _6952_/Y _5783_/X _5832_/A VGND VGND VPWR VPWR _6953_/X sky130_fd_sc_hd__a211o_2
XFILLER_53_169 VGND VGND VPWR VPWR sky130_fd_sc_hd__decap_3
XFILLER_81_478 VGND VGND VPWR VPWR sky130_fd_sc_hd__fill_1
X_6884_ _6883_/Y _6852_/B _6846_/B VGND VGND VPWR VPWR _6885_/B sky130_fd_sc_hd__a21oi_2
X_5904_ _7631_/A _5901_/X _5903_/X VGND VGND VPWR VPWR _5904_/Y sky130_fd_sc_hd__o21ai_2
XFILLER_14_27 VGND VGND VPWR VPWR sky130_fd_sc_hd__fill_1
XFILLER_34_394 VGND VGND VPWR VPWR sky130_fd_sc_hd__decap_3
X_5835_ _6109_/A _5827_/Y _5832_/X _5834_/Y VGND VGND VPWR VPWR _5835_/X sky130_fd_sc_hd__a22o_2
XFILLER_22_545 VGND VGND VPWR VPWR sky130_fd_sc_hd__decap_3
XFILLER_61_191 VGND VGND VPWR VPWR sky130_fd_sc_hd__fill_1
XTAP_TAPCELL_ROW_62_1059 VGND VPWR sky130_fd_sc_hd__tapvpwrvgnd_1
X_5766_ _6767_/A _5868_/A _5765_/Y _8290_/Q VGND VGND VPWR VPWR _5766_/X sky130_fd_sc_hd__o2bb2a_2
X_7505_ _6978_/X _7504_/X _6706_/X _7270_/X _6536_/A _6353_/B VGND VGND VPWR VPWR
+ _7505_/X sky130_fd_sc_hd__mux4_2
Xrebuffer348 _6194_/B VGND VGND VPWR VPWR _6656_/A sky130_fd_sc_hd__buf_2
Xrebuffer315 rebuffer947/X VGND VGND VPWR VPWR _4935_/A sky130_fd_sc_hd__buf_6
X_5697_ _8232_/Q VGND VGND VPWR VPWR _5697_/Y sky130_fd_sc_hd__inv_2
X_4717_ _7805_/A _7648_/A VGND VGND VPWR VPWR _4718_/B sky130_fd_sc_hd__xnor2_2
XFILLER_107_116 VGND VGND VPWR VPWR sky130_fd_sc_hd__decap_3
XFILLER_30_15 VGND VGND VPWR VPWR sky130_fd_sc_hd__fill_2
XFILLER_30_37 VGND VGND VPWR VPWR sky130_fd_sc_hd__decap_3
X_7436_ _7435_/X _7407_/B _7407_/C _4741_/B VGND VGND VPWR VPWR _7437_/B sky130_fd_sc_hd__a31o_2
X_4648_ _7930_/B _8128_/Q VGND VGND VPWR VPWR _4649_/A sky130_fd_sc_hd__and2_2
XFILLER_115_160 VGND VGND VPWR VPWR sky130_fd_sc_hd__decap_3
XFILLER_116_672 VGND VGND VPWR VPWR sky130_fd_sc_hd__decap_3
X_7367_ _8214_/Q _7365_/Y _7366_/Y _7290_/B _4983_/Y VGND VGND VPWR VPWR _7370_/B
+ sky130_fd_sc_hd__a221o_2
X_4579_ _4579_/A VGND VGND VPWR VPWR _8227_/D sky130_fd_sc_hd__buf_1
XFILLER_116_694 VGND VGND VPWR VPWR sky130_fd_sc_hd__decap_3
XFILLER_1_438 VGND VGND VPWR VPWR sky130_fd_sc_hd__decap_3
XFILLER_89_545 VGND VGND VPWR VPWR sky130_fd_sc_hd__decap_3
X_7298_ _6742_/X _7297_/X _6452_/X _7020_/X _7298_/S0 _7745_/A VGND VGND VPWR VPWR
+ _7298_/X sky130_fd_sc_hd__mux4_2
X_6318_ _6497_/B _6336_/B _6148_/A _6333_/B VGND VGND VPWR VPWR _6318_/X sky130_fd_sc_hd__a2bb2o_2
XFILLER_103_377 VGND VGND VPWR VPWR sky130_fd_sc_hd__decap_3
XFILLER_39_35 VGND VGND VPWR VPWR sky130_fd_sc_hd__decap_3
XFILLER_39_57 VGND VGND VPWR VPWR sky130_fd_sc_hd__decap_3
XFILLER_76_206 VGND VGND VPWR VPWR sky130_fd_sc_hd__decap_3
XFILLER_77_729 VGND VGND VPWR VPWR sky130_fd_sc_hd__decap_3
XFILLER_89_589 VGND VGND VPWR VPWR sky130_fd_sc_hd__decap_3
X_6249_ _7135_/B _6246_/X _6248_/Y VGND VGND VPWR VPWR _6249_/X sky130_fd_sc_hd__o21a_2
XFILLER_103_399 VGND VGND VPWR VPWR sky130_fd_sc_hd__decap_3
XFILLER_29_122 VGND VGND VPWR VPWR sky130_fd_sc_hd__decap_3
XFILLER_45_637 VGND VGND VPWR VPWR sky130_fd_sc_hd__fill_2
XFILLER_55_34 VGND VGND VPWR VPWR sky130_fd_sc_hd__decap_3
XFILLER_57_464 VGND VGND VPWR VPWR sky130_fd_sc_hd__decap_3
XFILLER_57_486 VGND VGND VPWR VPWR sky130_fd_sc_hd__fill_1
XFILLER_72_412 VGND VGND VPWR VPWR sky130_fd_sc_hd__decap_3
XFILLER_84_250 VGND VGND VPWR VPWR sky130_fd_sc_hd__fill_2
XFILLER_44_136 VGND VGND VPWR VPWR sky130_fd_sc_hd__decap_3
XFILLER_45_648 VGND VGND VPWR VPWR sky130_fd_sc_hd__decap_3
XFILLER_55_78 VGND VGND VPWR VPWR sky130_fd_sc_hd__decap_3
XFILLER_84_283 VGND VGND VPWR VPWR sky130_fd_sc_hd__decap_3
XFILLER_32_309 VGND VGND VPWR VPWR sky130_fd_sc_hd__decap_3
XFILLER_44_169 VGND VGND VPWR VPWR sky130_fd_sc_hd__decap_3
XFILLER_60_607 VGND VGND VPWR VPWR sky130_fd_sc_hd__decap_3
XFILLER_72_467 VGND VGND VPWR VPWR sky130_fd_sc_hd__decap_3
XFILLER_72_489 VGND VGND VPWR VPWR sky130_fd_sc_hd__decap_3
XTAP_TAPCELL_ROW_43_816 VGND VPWR sky130_fd_sc_hd__tapvpwrvgnd_1
XFILLER_13_523 VGND VGND VPWR VPWR sky130_fd_sc_hd__fill_1
XFILLER_71_11 VGND VGND VPWR VPWR sky130_fd_sc_hd__decap_3
XFILLER_111_95 VGND VGND VPWR VPWR sky130_fd_sc_hd__decap_3
XFILLER_52_191 VGND VGND VPWR VPWR sky130_fd_sc_hd__decap_3
XFILLER_71_55 VGND VGND VPWR VPWR sky130_fd_sc_hd__fill_1
XFILLER_9_505 VGND VGND VPWR VPWR sky130_fd_sc_hd__decap_3
XFILLER_13_578 VGND VGND VPWR VPWR sky130_fd_sc_hd__decap_3
XFILLER_71_66 VGND VGND VPWR VPWR sky130_fd_sc_hd__decap_3
XFILLER_71_99 VGND VGND VPWR VPWR sky130_fd_sc_hd__decap_3
XTAP_TAPCELL_ROW_23_562 VGND VPWR sky130_fd_sc_hd__tapvpwrvgnd_1
XFILLER_40_397 VGND VGND VPWR VPWR sky130_fd_sc_hd__decap_3
XFILLER_5_700 VGND VGND VPWR VPWR sky130_fd_sc_hd__decap_3
XFILLER_4_232 VGND VGND VPWR VPWR sky130_fd_sc_hd__decap_3
Xrebuffer893 _7425_/C VGND VGND VPWR VPWR rebuffer893/X sky130_fd_sc_hd__buf_2
XFILLER_113_108 VGND VGND VPWR VPWR sky130_fd_sc_hd__decap_3
XFILLER_113_119 VGND VGND VPWR VPWR sky130_fd_sc_hd__decap_3
XFILLER_4_265 VGND VGND VPWR VPWR sky130_fd_sc_hd__decap_3
XFILLER_106_171 VGND VGND VPWR VPWR sky130_fd_sc_hd__decap_3
XFILLER_4_298 VGND VGND VPWR VPWR sky130_fd_sc_hd__decap_3
XFILLER_67_228 VGND VGND VPWR VPWR sky130_fd_sc_hd__decap_3
XFILLER_95_548 VGND VGND VPWR VPWR sky130_fd_sc_hd__decap_3
XFILLER_96_63 VGND VGND VPWR VPWR sky130_fd_sc_hd__decap_3
XFILLER_29_90 VGND VGND VPWR VPWR sky130_fd_sc_hd__decap_3
XFILLER_35_103 VGND VGND VPWR VPWR sky130_fd_sc_hd__decap_3
XFILLER_48_464 VGND VGND VPWR VPWR sky130_fd_sc_hd__decap_3
XFILLER_48_486 VGND VGND VPWR VPWR sky130_fd_sc_hd__decap_3
XFILLER_75_250 VGND VGND VPWR VPWR sky130_fd_sc_hd__decap_3
XFILLER_82_209 VGND VGND VPWR VPWR sky130_fd_sc_hd__decap_3
XFILLER_91_721 VGND VGND VPWR VPWR sky130_fd_sc_hd__fill_1
XFILLER_36_648 VGND VGND VPWR VPWR sky130_fd_sc_hd__decap_3
XFILLER_63_434 VGND VGND VPWR VPWR sky130_fd_sc_hd__decap_3
XFILLER_91_732 VGND VGND VPWR VPWR sky130_fd_sc_hd__fill_1
XPHY_EDGE_ROW_11_Left_131 VGND VGND VPWR VPWR sky130_fd_sc_hd__decap_3
XFILLER_35_169 VGND VGND VPWR VPWR sky130_fd_sc_hd__decap_3
XFILLER_16_372 VGND VGND VPWR VPWR sky130_fd_sc_hd__decap_3
XFILLER_90_275 VGND VGND VPWR VPWR sky130_fd_sc_hd__decap_3
XFILLER_84_3 VGND VGND VPWR VPWR sky130_fd_sc_hd__fill_2
X_5620_ _8231_/Q _5337_/X _5400_/A VGND VGND VPWR VPWR _5620_/Y sky130_fd_sc_hd__o21ai_2
X_5551_ _5253_/X _5254_/X _5263_/X _5264_/X _7783_/A _5596_/S VGND VGND VPWR VPWR
+ _5551_/X sky130_fd_sc_hd__mux4_2
XFILLER_8_560 VGND VGND VPWR VPWR sky130_fd_sc_hd__decap_3
XFILLER_8_582 VGND VGND VPWR VPWR sky130_fd_sc_hd__fill_2
X_8270_ _8353_/CLK _8270_/D VGND VGND VPWR VPWR _8270_/Q sky130_fd_sc_hd__dfxtp_2
X_4502_ _7930_/B _8055_/Q VGND VGND VPWR VPWR _4503_/A sky130_fd_sc_hd__and2_2
XFILLER_117_458 VGND VGND VPWR VPWR sky130_fd_sc_hd__fill_1
XPHY_EDGE_ROW_20_Left_140 VGND VGND VPWR VPWR sky130_fd_sc_hd__decap_3
X_7221_ _8208_/Q _7221_/B _7223_/C VGND VGND VPWR VPWR _7221_/X sky130_fd_sc_hd__and3_2
X_5482_ _7812_/A _7796_/A VGND VGND VPWR VPWR _5950_/A sky130_fd_sc_hd__nor2_2
XFILLER_6_94 VGND VGND VPWR VPWR sky130_fd_sc_hd__fill_1
XTAP_TAPCELL_ROW_113_1723 VGND VPWR sky130_fd_sc_hd__tapvpwrvgnd_1
X_4433_ _4433_/A VGND VGND VPWR VPWR _8154_/D sky130_fd_sc_hd__buf_1
XFILLER_116_18 VGND VGND VPWR VPWR sky130_fd_sc_hd__decap_3
XFILLER_116_29 VGND VGND VPWR VPWR sky130_fd_sc_hd__decap_3
XTAP_TAPCELL_ROW_113_1734 VGND VPWR sky130_fd_sc_hd__tapvpwrvgnd_1
X_7152_ _7152_/A _7154_/A _7154_/C VGND VGND VPWR VPWR _7152_/X sky130_fd_sc_hd__and3_2
X_4364_ _7930_/B _4364_/B VGND VGND VPWR VPWR _4365_/A sky130_fd_sc_hd__and2_2
XFILLER_112_141 VGND VGND VPWR VPWR sky130_fd_sc_hd__decap_3
XFILLER_59_729 VGND VGND VPWR VPWR sky130_fd_sc_hd__decap_3
XFILLER_86_504 VGND VGND VPWR VPWR sky130_fd_sc_hd__decap_3
XFILLER_98_353 VGND VGND VPWR VPWR sky130_fd_sc_hd__decap_3
X_7083_ _8266_/Q _7082_/X _8202_/Q VGND VGND VPWR VPWR _7083_/X sky130_fd_sc_hd__a21o_2
X_6103_ _6277_/A _7827_/A _5371_/B _6009_/Y VGND VGND VPWR VPWR _7243_/A sky130_fd_sc_hd__o31a_2
X_4295_ _4295_/A VGND VGND VPWR VPWR _8085_/D sky130_fd_sc_hd__buf_1
XFILLER_100_325 VGND VGND VPWR VPWR sky130_fd_sc_hd__fill_1
XFILLER_112_163 VGND VGND VPWR VPWR sky130_fd_sc_hd__decap_3
XFILLER_39_420 VGND VGND VPWR VPWR sky130_fd_sc_hd__decap_3
XFILLER_58_217 VGND VGND VPWR VPWR sky130_fd_sc_hd__decap_3
XFILLER_58_239 VGND VGND VPWR VPWR sky130_fd_sc_hd__fill_2
XFILLER_86_548 VGND VGND VPWR VPWR sky130_fd_sc_hd__decap_3
X_6034_ _6097_/A _8240_/Q VGND VGND VPWR VPWR _6045_/B sky130_fd_sc_hd__or2_2
XFILLER_26_103 VGND VGND VPWR VPWR sky130_fd_sc_hd__decap_3
XFILLER_27_604 VGND VGND VPWR VPWR sky130_fd_sc_hd__decap_3
XFILLER_27_626 VGND VGND VPWR VPWR sky130_fd_sc_hd__decap_3
XFILLER_39_464 VGND VGND VPWR VPWR sky130_fd_sc_hd__decap_3
XFILLER_54_412 VGND VGND VPWR VPWR sky130_fd_sc_hd__decap_3
XFILLER_26_125 VGND VGND VPWR VPWR sky130_fd_sc_hd__decap_3
XFILLER_66_283 VGND VGND VPWR VPWR sky130_fd_sc_hd__decap_3
XFILLER_81_231 VGND VGND VPWR VPWR sky130_fd_sc_hd__decap_3
XFILLER_82_732 VGND VGND VPWR VPWR sky130_fd_sc_hd__fill_1
X_7985_ _8387_/CLK _7985_/D VGND VGND VPWR VPWR _7985_/Q sky130_fd_sc_hd__dfxtp_2
XFILLER_14_309 VGND VGND VPWR VPWR sky130_fd_sc_hd__decap_3
XFILLER_54_467 VGND VGND VPWR VPWR sky130_fd_sc_hd__decap_3
XFILLER_54_489 VGND VGND VPWR VPWR sky130_fd_sc_hd__decap_3
XFILLER_81_264 VGND VGND VPWR VPWR sky130_fd_sc_hd__decap_3
X_6936_ _6967_/A _6936_/A2 _5601_/A _8202_/Q VGND VGND VPWR VPWR _6936_/X sky130_fd_sc_hd__o22a_2
XTAP_TAPCELL_ROW_1_268 VGND VPWR sky130_fd_sc_hd__tapvpwrvgnd_1
XFILLER_25_48 VGND VGND VPWR VPWR sky130_fd_sc_hd__fill_1
XFILLER_35_692 VGND VGND VPWR VPWR sky130_fd_sc_hd__decap_3
X_6867_ _6275_/X _6866_/X _5985_/X _6573_/X _5181_/X _6321_/B VGND VGND VPWR VPWR
+ _6867_/X sky130_fd_sc_hd__mux4_2
XFILLER_10_504 VGND VGND VPWR VPWR sky130_fd_sc_hd__decap_3
XFILLER_22_353 VGND VGND VPWR VPWR sky130_fd_sc_hd__fill_2
XFILLER_41_14 VGND VGND VPWR VPWR sky130_fd_sc_hd__decap_3
X_6798_ _8254_/Q _6561_/B _6794_/B _6797_/X VGND VGND VPWR VPWR _6799_/A sky130_fd_sc_hd__a31o_2
X_5818_ _7182_/B _5897_/C _5897_/A VGND VGND VPWR VPWR _5818_/Y sky130_fd_sc_hd__a21oi_2
XFILLER_22_397 VGND VGND VPWR VPWR sky130_fd_sc_hd__decap_3
XFILLER_41_36 VGND VGND VPWR VPWR sky130_fd_sc_hd__fill_2
X_5749_ _5749_/A VGND VGND VPWR VPWR _5749_/Y sky130_fd_sc_hd__inv_2
XTAP_TAPCELL_ROW_20_521 VGND VPWR sky130_fd_sc_hd__tapvpwrvgnd_1
XFILLER_108_458 VGND VGND VPWR VPWR sky130_fd_sc_hd__decap_3
X_7419_ _7418_/X _7348_/X _7296_/X _7239_/X _7812_/A _7670_/A VGND VGND VPWR VPWR
+ _7419_/X sky130_fd_sc_hd__mux4_2
X_8399_ _8402_/CLK _8399_/D VGND VGND VPWR VPWR _8399_/Q sky130_fd_sc_hd__dfxtp_2
XTAP_TAPCELL_ROW_75_1239 VGND VPWR sky130_fd_sc_hd__tapvpwrvgnd_1
XTAP_TAPCELL_ROW_75_1228 VGND VPWR sky130_fd_sc_hd__tapvpwrvgnd_1
XFILLER_104_631 VGND VGND VPWR VPWR sky130_fd_sc_hd__decap_3
XFILLER_116_480 VGND VGND VPWR VPWR sky130_fd_sc_hd__decap_3
XFILLER_2_725 VGND VGND VPWR VPWR sky130_fd_sc_hd__decap_3
XFILLER_89_320 VGND VGND VPWR VPWR sky130_fd_sc_hd__decap_3
XFILLER_89_364 VGND VGND VPWR VPWR sky130_fd_sc_hd__fill_2
XTAP_TAPCELL_ROW_9_379 VGND VPWR sky130_fd_sc_hd__tapvpwrvgnd_1
XFILLER_103_152 VGND VGND VPWR VPWR sky130_fd_sc_hd__decap_3
XFILLER_104_697 VGND VGND VPWR VPWR sky130_fd_sc_hd__decap_3
XFILLER_49_239 VGND VGND VPWR VPWR sky130_fd_sc_hd__decap_3
XFILLER_77_537 VGND VGND VPWR VPWR sky130_fd_sc_hd__decap_3
XFILLER_89_386 VGND VGND VPWR VPWR sky130_fd_sc_hd__decap_3
XFILLER_103_196 VGND VGND VPWR VPWR sky130_fd_sc_hd__decap_3
XFILLER_77_559 VGND VGND VPWR VPWR sky130_fd_sc_hd__fill_1
XFILLER_18_604 VGND VGND VPWR VPWR sky130_fd_sc_hd__fill_1
XFILLER_57_272 VGND VGND VPWR VPWR sky130_fd_sc_hd__fill_1
XFILLER_66_88 VGND VGND VPWR VPWR sky130_fd_sc_hd__decap_3
XFILLER_85_570 VGND VGND VPWR VPWR sky130_fd_sc_hd__decap_3
XFILLER_92_529 VGND VGND VPWR VPWR sky130_fd_sc_hd__decap_3
XFILLER_17_125 VGND VGND VPWR VPWR sky130_fd_sc_hd__decap_3
XFILLER_17_136 VGND VGND VPWR VPWR sky130_fd_sc_hd__decap_3
XFILLER_73_732 VGND VGND VPWR VPWR sky130_fd_sc_hd__fill_1
XFILLER_85_592 VGND VGND VPWR VPWR sky130_fd_sc_hd__fill_1
XTAP_TAPCELL_ROW_28_621 VGND VPWR sky130_fd_sc_hd__tapvpwrvgnd_1
XFILLER_17_169 VGND VGND VPWR VPWR sky130_fd_sc_hd__decap_3
XFILLER_72_253 VGND VGND VPWR VPWR sky130_fd_sc_hd__decap_3
XFILLER_82_32 VGND VGND VPWR VPWR sky130_fd_sc_hd__decap_3
XTAP_TAPCELL_ROW_86_1379 VGND VPWR sky130_fd_sc_hd__tapvpwrvgnd_1
XFILLER_32_106 VGND VGND VPWR VPWR sky130_fd_sc_hd__fill_2
XFILLER_32_117 VGND VGND VPWR VPWR sky130_fd_sc_hd__fill_2
XFILLER_60_437 VGND VGND VPWR VPWR sky130_fd_sc_hd__decap_3
XFILLER_72_297 VGND VGND VPWR VPWR sky130_fd_sc_hd__decap_3
XTAP_TAPCELL_ROW_56_985 VGND VPWR sky130_fd_sc_hd__tapvpwrvgnd_1
XFILLER_13_331 VGND VGND VPWR VPWR sky130_fd_sc_hd__decap_3
XFILLER_40_150 VGND VGND VPWR VPWR sky130_fd_sc_hd__decap_3
XFILLER_9_313 VGND VGND VPWR VPWR sky130_fd_sc_hd__fill_2
XFILLER_40_183 VGND VGND VPWR VPWR sky130_fd_sc_hd__fill_1
XFILLER_9_379 VGND VGND VPWR VPWR sky130_fd_sc_hd__decap_3
XFILLER_68_504 VGND VGND VPWR VPWR sky130_fd_sc_hd__fill_2
XFILLER_110_612 VGND VGND VPWR VPWR sky130_fd_sc_hd__decap_3
XFILLER_68_526 VGND VGND VPWR VPWR sky130_fd_sc_hd__decap_3
XFILLER_68_548 VGND VGND VPWR VPWR sky130_fd_sc_hd__decap_3
XFILLER_95_301 VGND VGND VPWR VPWR sky130_fd_sc_hd__decap_3
XFILLER_95_312 VGND VGND VPWR VPWR sky130_fd_sc_hd__decap_3
XFILLER_95_334 VGND VGND VPWR VPWR sky130_fd_sc_hd__fill_2
X_4080_ _7898_/B _8381_/Q VGND VGND VPWR VPWR _4081_/A sky130_fd_sc_hd__and2_2
XFILLER_76_570 VGND VGND VPWR VPWR sky130_fd_sc_hd__decap_3
XFILLER_36_412 VGND VGND VPWR VPWR sky130_fd_sc_hd__decap_3
XFILLER_36_445 VGND VGND VPWR VPWR sky130_fd_sc_hd__decap_3
XFILLER_48_283 VGND VGND VPWR VPWR sky130_fd_sc_hd__decap_3
XFILLER_63_220 VGND VGND VPWR VPWR sky130_fd_sc_hd__decap_3
XFILLER_76_592 VGND VGND VPWR VPWR sky130_fd_sc_hd__decap_3
XFILLER_24_607 VGND VGND VPWR VPWR sky130_fd_sc_hd__decap_3
XFILLER_63_231 VGND VGND VPWR VPWR sky130_fd_sc_hd__decap_3
XFILLER_63_264 VGND VGND VPWR VPWR sky130_fd_sc_hd__decap_3
XFILLER_17_670 VGND VGND VPWR VPWR sky130_fd_sc_hd__fill_2
XFILLER_24_629 VGND VGND VPWR VPWR sky130_fd_sc_hd__fill_1
XFILLER_51_426 VGND VGND VPWR VPWR sky130_fd_sc_hd__decap_3
X_7770_ _6022_/B _7663_/B _7660_/X VGND VGND VPWR VPWR _7770_/Y sky130_fd_sc_hd__o21ai_2
X_4982_ _8278_/Q _4983_/B _8214_/Q VGND VGND VPWR VPWR _4982_/Y sky130_fd_sc_hd__a21boi_2
XFILLER_16_180 VGND VGND VPWR VPWR sky130_fd_sc_hd__decap_3
XFILLER_32_651 VGND VGND VPWR VPWR sky130_fd_sc_hd__decap_3
X_6721_ _6721_/A _6721_/B _6721_/C VGND VGND VPWR VPWR _6721_/Y sky130_fd_sc_hd__nand3_2
XFILLER_32_684 VGND VGND VPWR VPWR sky130_fd_sc_hd__decap_3
X_6652_ _8182_/Q _8183_/Q _8185_/Q _8186_/Q VGND VGND VPWR VPWR _6655_/B sky130_fd_sc_hd__or4_2
XFILLER_31_172 VGND VGND VPWR VPWR sky130_fd_sc_hd__decap_3
X_5603_ _6462_/A VGND VGND VPWR VPWR _6769_/A sky130_fd_sc_hd__buf_1
XFILLER_118_701 VGND VGND VPWR VPWR sky130_fd_sc_hd__decap_3
X_8322_ _8322_/CLK _8322_/D VGND VGND VPWR VPWR _8322_/Q sky130_fd_sc_hd__dfxtp_2
X_6583_ _5333_/A _8191_/Q _6582_/Y _5402_/A _4868_/A VGND VGND VPWR VPWR _6583_/X
+ sky130_fd_sc_hd__a32o_2
XFILLER_8_390 VGND VGND VPWR VPWR sky130_fd_sc_hd__decap_3
X_5534_ _8164_/Q _5490_/A _8165_/Q VGND VGND VPWR VPWR _5534_/Y sky130_fd_sc_hd__o21ai_2
XFILLER_105_406 VGND VGND VPWR VPWR sky130_fd_sc_hd__decap_3
X_8253_ _8389_/CLK _8253_/D VGND VGND VPWR VPWR _8253_/Q sky130_fd_sc_hd__dfxtp_4
X_5465_ _5150_/X _5154_/X _5596_/S VGND VGND VPWR VPWR _5465_/X sky130_fd_sc_hd__mux2_2
X_8184_ _8224_/CLK _8184_/D VGND VGND VPWR VPWR _8184_/Q sky130_fd_sc_hd__dfxtp_2
X_7204_ _7192_/X _7204_/B _7204_/C _7204_/D VGND VGND VPWR VPWR _7204_/X sky130_fd_sc_hd__and4b_2
X_4416_ _7930_/B _4416_/B VGND VGND VPWR VPWR _4417_/A sky130_fd_sc_hd__and2_2
XFILLER_99_673 VGND VGND VPWR VPWR sky130_fd_sc_hd__decap_3
X_7135_ _7193_/A _7135_/B VGND VGND VPWR VPWR _7135_/Y sky130_fd_sc_hd__nor2_2
X_5396_ _5396_/A VGND VGND VPWR VPWR _7631_/A sky130_fd_sc_hd__buf_6
XFILLER_101_601 VGND VGND VPWR VPWR sky130_fd_sc_hd__decap_3
XFILLER_101_623 VGND VGND VPWR VPWR sky130_fd_sc_hd__decap_3
XFILLER_59_526 VGND VGND VPWR VPWR sky130_fd_sc_hd__decap_3
XFILLER_86_312 VGND VGND VPWR VPWR sky130_fd_sc_hd__decap_3
XFILLER_98_150 VGND VGND VPWR VPWR sky130_fd_sc_hd__decap_3
XFILLER_98_183 VGND VGND VPWR VPWR sky130_fd_sc_hd__fill_2
X_4347_ _4347_/A VGND VGND VPWR VPWR _8111_/D sky130_fd_sc_hd__buf_1
XTAP_TAPCELL_ROW_6_338 VGND VPWR sky130_fd_sc_hd__tapvpwrvgnd_1
XFILLER_101_645 VGND VGND VPWR VPWR sky130_fd_sc_hd__decap_3
XFILLER_101_667 VGND VGND VPWR VPWR sky130_fd_sc_hd__decap_3
XFILLER_86_356 VGND VGND VPWR VPWR sky130_fd_sc_hd__decap_3
X_7066_ _7066_/A _8199_/Q _6838_/X VGND VGND VPWR VPWR _7129_/C sky130_fd_sc_hd__or3b_4
X_4278_ _7843_/A _4278_/B VGND VGND VPWR VPWR _4279_/A sky130_fd_sc_hd__and2_2
XTAP_TAPCELL_ROW_70_1169 VGND VPWR sky130_fd_sc_hd__tapvpwrvgnd_1
XFILLER_100_144 VGND VGND VPWR VPWR sky130_fd_sc_hd__decap_3
XFILLER_39_261 VGND VGND VPWR VPWR sky130_fd_sc_hd__decap_3
XFILLER_74_518 VGND VGND VPWR VPWR sky130_fd_sc_hd__fill_1
XFILLER_86_389 VGND VGND VPWR VPWR sky130_fd_sc_hd__decap_3
X_6017_ _7193_/B _6017_/B VGND VGND VPWR VPWR _7122_/B sky130_fd_sc_hd__nand2_2
XFILLER_100_188 VGND VGND VPWR VPWR sky130_fd_sc_hd__decap_3
XFILLER_27_412 VGND VGND VPWR VPWR sky130_fd_sc_hd__decap_3
XFILLER_36_36 VGND VGND VPWR VPWR sky130_fd_sc_hd__decap_3
XFILLER_55_732 VGND VGND VPWR VPWR sky130_fd_sc_hd__fill_1
XFILLER_67_592 VGND VGND VPWR VPWR sky130_fd_sc_hd__decap_3
XFILLER_27_467 VGND VGND VPWR VPWR sky130_fd_sc_hd__decap_3
XFILLER_14_117 VGND VGND VPWR VPWR sky130_fd_sc_hd__decap_3
XFILLER_54_286 VGND VGND VPWR VPWR sky130_fd_sc_hd__fill_1
XFILLER_54_297 VGND VGND VPWR VPWR sky130_fd_sc_hd__decap_3
XFILLER_82_584 VGND VGND VPWR VPWR sky130_fd_sc_hd__decap_3
X_7968_ _8388_/CLK _7968_/D VGND VGND VPWR VPWR _7968_/Q sky130_fd_sc_hd__dfxtp_2
XFILLER_42_459 VGND VGND VPWR VPWR sky130_fd_sc_hd__fill_2
X_7899_ _7899_/A VGND VGND VPWR VPWR _8386_/D sky130_fd_sc_hd__buf_1
X_6919_ _8265_/Q _5422_/X _6918_/X _8290_/Q _7453_/A VGND VGND VPWR VPWR _6919_/X
+ sky130_fd_sc_hd__a221o_2
XTAP_TAPCELL_ROW_53_944 VGND VPWR sky130_fd_sc_hd__tapvpwrvgnd_1
XFILLER_22_161 VGND VGND VPWR VPWR sky130_fd_sc_hd__decap_3
XFILLER_23_673 VGND VGND VPWR VPWR sky130_fd_sc_hd__decap_3
XFILLER_10_312 VGND VGND VPWR VPWR sky130_fd_sc_hd__decap_3
XTAP_TAPCELL_ROW_33_690 VGND VPWR sky130_fd_sc_hd__tapvpwrvgnd_1
XFILLER_108_200 VGND VGND VPWR VPWR sky130_fd_sc_hd__decap_3
XFILLER_109_701 VGND VGND VPWR VPWR sky130_fd_sc_hd__fill_1
XFILLER_10_356 VGND VGND VPWR VPWR sky130_fd_sc_hd__decap_3
XFILLER_108_233 VGND VGND VPWR VPWR sky130_fd_sc_hd__decap_3
XFILLER_6_327 VGND VGND VPWR VPWR sky130_fd_sc_hd__decap_3
XFILLER_2_533 VGND VGND VPWR VPWR sky130_fd_sc_hd__decap_3
XFILLER_111_409 VGND VGND VPWR VPWR sky130_fd_sc_hd__decap_3
XFILLER_2_544 VGND VGND VPWR VPWR sky130_fd_sc_hd__decap_3
XFILLER_96_109 VGND VGND VPWR VPWR sky130_fd_sc_hd__decap_3
XFILLER_104_483 VGND VGND VPWR VPWR sky130_fd_sc_hd__decap_3
XFILLER_77_323 VGND VGND VPWR VPWR sky130_fd_sc_hd__decap_3
XFILLER_89_161 VGND VGND VPWR VPWR sky130_fd_sc_hd__decap_3
XFILLER_89_172 VGND VGND VPWR VPWR sky130_fd_sc_hd__decap_3
XFILLER_77_378 VGND VGND VPWR VPWR sky130_fd_sc_hd__fill_1
XFILLER_77_98 VGND VGND VPWR VPWR sky130_fd_sc_hd__decap_3
XFILLER_92_304 VGND VGND VPWR VPWR sky130_fd_sc_hd__decap_3
XTAP_TAPCELL_ROW_88_1408 VGND VPWR sky130_fd_sc_hd__tapvpwrvgnd_1
XFILLER_18_434 VGND VGND VPWR VPWR sky130_fd_sc_hd__decap_3
XFILLER_45_220 VGND VGND VPWR VPWR sky130_fd_sc_hd__decap_3
XFILLER_58_581 VGND VGND VPWR VPWR sky130_fd_sc_hd__fill_1
XFILLER_58_592 VGND VGND VPWR VPWR sky130_fd_sc_hd__decap_3
XFILLER_92_337 VGND VGND VPWR VPWR sky130_fd_sc_hd__decap_3
XFILLER_93_20 VGND VGND VPWR VPWR sky130_fd_sc_hd__decap_3
XFILLER_45_231 VGND VGND VPWR VPWR sky130_fd_sc_hd__decap_3
XFILLER_93_53 VGND VGND VPWR VPWR sky130_fd_sc_hd__decap_3
XFILLER_93_75 VGND VGND VPWR VPWR sky130_fd_sc_hd__decap_3
XFILLER_33_426 VGND VGND VPWR VPWR sky130_fd_sc_hd__decap_3
XFILLER_45_264 VGND VGND VPWR VPWR sky130_fd_sc_hd__fill_1
XFILLER_60_212 VGND VGND VPWR VPWR sky130_fd_sc_hd__fill_2
XFILLER_73_584 VGND VGND VPWR VPWR sky130_fd_sc_hd__decap_3
XFILLER_26_91 VGND VGND VPWR VPWR sky130_fd_sc_hd__decap_3
XFILLER_60_256 VGND VGND VPWR VPWR sky130_fd_sc_hd__decap_3
XFILLER_60_289 VGND VGND VPWR VPWR sky130_fd_sc_hd__decap_3
XFILLER_13_161 VGND VGND VPWR VPWR sky130_fd_sc_hd__decap_3
XFILLER_13_172 VGND VGND VPWR VPWR sky130_fd_sc_hd__fill_2
XTAP_TAPCELL_ROW_99_1548 VGND VPWR sky130_fd_sc_hd__tapvpwrvgnd_1
X_5250_ _5246_/X _5247_/X _5248_/X _5249_/X _7783_/A _6706_/S VGND VGND VPWR VPWR
+ _5250_/X sky130_fd_sc_hd__mux4_2
XFILLER_47_3 VGND VGND VPWR VPWR sky130_fd_sc_hd__decap_3
X_4201_ _4201_/A VGND VGND VPWR VPWR _8038_/D sky130_fd_sc_hd__buf_1
XFILLER_3_40 VGND VGND VPWR VPWR sky130_fd_sc_hd__decap_3
XFILLER_68_301 VGND VGND VPWR VPWR sky130_fd_sc_hd__decap_3
XFILLER_68_312 VGND VGND VPWR VPWR sky130_fd_sc_hd__decap_3
XFILLER_96_621 VGND VGND VPWR VPWR sky130_fd_sc_hd__decap_3
X_5181_ _6536_/A VGND VGND VPWR VPWR _5181_/X sky130_fd_sc_hd__clkbuf_1
XFILLER_110_442 VGND VGND VPWR VPWR sky130_fd_sc_hd__fill_1
X_4132_ _7930_/B _7936_/Q VGND VGND VPWR VPWR _4133_/A sky130_fd_sc_hd__and2_2
XFILLER_110_464 VGND VGND VPWR VPWR sky130_fd_sc_hd__fill_2
XFILLER_110_475 VGND VGND VPWR VPWR sky130_fd_sc_hd__fill_1
XFILLER_3_84 VGND VGND VPWR VPWR sky130_fd_sc_hd__decap_3
XFILLER_95_175 VGND VGND VPWR VPWR sky130_fd_sc_hd__decap_3
X_4063_ _4063_/A VGND VGND VPWR VPWR _7969_/D sky130_fd_sc_hd__buf_1
XFILLER_110_497 VGND VGND VPWR VPWR sky130_fd_sc_hd__decap_3
XFILLER_37_732 VGND VGND VPWR VPWR sky130_fd_sc_hd__fill_1
XFILLER_83_337 VGND VGND VPWR VPWR sky130_fd_sc_hd__decap_3
XFILLER_36_253 VGND VGND VPWR VPWR sky130_fd_sc_hd__decap_3
XFILLER_64_551 VGND VGND VPWR VPWR sky130_fd_sc_hd__decap_3
XTAP_TAPCELL_ROW_108_1666 VGND VPWR sky130_fd_sc_hd__tapvpwrvgnd_1
XFILLER_52_724 VGND VGND VPWR VPWR sky130_fd_sc_hd__fill_1
XFILLER_91_381 VGND VGND VPWR VPWR sky130_fd_sc_hd__decap_3
X_7822_ _7652_/Y _7822_/B _7822_/C VGND VGND VPWR VPWR _7822_/X sky130_fd_sc_hd__and3b_2
XFILLER_24_459 VGND VGND VPWR VPWR sky130_fd_sc_hd__decap_3
XFILLER_51_234 VGND VGND VPWR VPWR sky130_fd_sc_hd__decap_3
X_7753_ _8203_/Q _7680_/B _7672_/X VGND VGND VPWR VPWR _7754_/B sky130_fd_sc_hd__o21ai_2
X_4965_ _5346_/A split/A VGND VGND VPWR VPWR _4968_/A sky130_fd_sc_hd__nor2_2
XFILLER_51_278 VGND VGND VPWR VPWR sky130_fd_sc_hd__fill_2
X_6704_ _5627_/A _6699_/X _6703_/Y _8290_/Q _6687_/X VGND VGND VPWR VPWR _6722_/A
+ sky130_fd_sc_hd__a221o_2
XTAP_TAPCELL_ROW_50_914 VGND VPWR sky130_fd_sc_hd__tapvpwrvgnd_1
XTAP_TAPCELL_ROW_50_903 VGND VPWR sky130_fd_sc_hd__tapvpwrvgnd_1
X_7684_ _7783_/A _7678_/X _7683_/X VGND VGND VPWR VPWR _7684_/Y sky130_fd_sc_hd__a21oi_2
X_4896_ _8180_/Q _8244_/Q VGND VGND VPWR VPWR _4897_/B sky130_fd_sc_hd__or2b_2
XFILLER_20_676 VGND VGND VPWR VPWR sky130_fd_sc_hd__fill_2
XFILLER_22_38 VGND VGND VPWR VPWR sky130_fd_sc_hd__fill_2
X_6635_ _8256_/Q _6635_/A2 _6634_/X VGND VGND VPWR VPWR _6636_/B sky130_fd_sc_hd__a21o_4
XFILLER_20_687 VGND VGND VPWR VPWR sky130_fd_sc_hd__decap_3
X_6566_ _8254_/Q _6527_/B _6527_/C _6794_/A VGND VGND VPWR VPWR _6567_/B sky130_fd_sc_hd__a31o_4
X_8305_ _8386_/CLK _8305_/D VGND VGND VPWR VPWR _8305_/Q sky130_fd_sc_hd__dfxtp_2
X_5517_ _5911_/B _8223_/Q _7555_/S VGND VGND VPWR VPWR _5517_/X sky130_fd_sc_hd__mux2_2
XFILLER_105_214 VGND VGND VPWR VPWR sky130_fd_sc_hd__decap_3
X_8236_ clkload5/A _8236_/D VGND VGND VPWR VPWR _8236_/Q sky130_fd_sc_hd__dfxtp_2
X_6497_ _7694_/B _6497_/B _6497_/C VGND VGND VPWR VPWR _6497_/X sky130_fd_sc_hd__or3_2
XFILLER_0_9 VGND VGND VPWR VPWR sky130_fd_sc_hd__decap_3
XFILLER_105_269 VGND VGND VPWR VPWR sky130_fd_sc_hd__decap_3
X_5448_ _5226_/X _5222_/X _5451_/S VGND VGND VPWR VPWR _5448_/X sky130_fd_sc_hd__mux2_2
XFILLER_78_109 VGND VGND VPWR VPWR sky130_fd_sc_hd__decap_3
XFILLER_99_481 VGND VGND VPWR VPWR sky130_fd_sc_hd__decap_3
X_8167_ _8187_/CLK _8167_/D VGND VGND VPWR VPWR _8167_/Q sky130_fd_sc_hd__dfxtp_4
X_5379_ _5171_/X _5167_/X _5384_/S VGND VGND VPWR VPWR _5379_/X sky130_fd_sc_hd__mux2_2
XFILLER_47_13 VGND VGND VPWR VPWR sky130_fd_sc_hd__decap_3
XFILLER_59_334 VGND VGND VPWR VPWR sky130_fd_sc_hd__fill_2
XFILLER_87_643 VGND VGND VPWR VPWR sky130_fd_sc_hd__decap_3
XFILLER_87_654 VGND VGND VPWR VPWR sky130_fd_sc_hd__decap_3
X_8098_ clkload8/A _8098_/D VGND VGND VPWR VPWR _8098_/Q sky130_fd_sc_hd__dfxtp_2
X_7118_ _8206_/Q _7118_/B VGND VGND VPWR VPWR _7119_/D sky130_fd_sc_hd__or2_2
XFILLER_101_475 VGND VGND VPWR VPWR sky130_fd_sc_hd__decap_3
XFILLER_47_46 VGND VGND VPWR VPWR sky130_fd_sc_hd__decap_3
XFILLER_74_315 VGND VGND VPWR VPWR sky130_fd_sc_hd__decap_3
XFILLER_87_676 VGND VGND VPWR VPWR sky130_fd_sc_hd__decap_3
X_7049_ _5966_/X _7028_/X _7029_/Y _7048_/X _7930_/B VGND VGND VPWR VPWR _8339_/D
+ sky130_fd_sc_hd__o311a_2
XFILLER_101_497 VGND VGND VPWR VPWR sky130_fd_sc_hd__decap_3
XFILLER_74_348 VGND VGND VPWR VPWR sky130_fd_sc_hd__decap_3
XFILLER_86_186 VGND VGND VPWR VPWR sky130_fd_sc_hd__fill_1
XFILLER_86_197 VGND VGND VPWR VPWR sky130_fd_sc_hd__decap_3
XPHY_EDGE_ROW_29_Right_29 VGND VGND VPWR VPWR sky130_fd_sc_hd__decap_3
XFILLER_27_231 VGND VGND VPWR VPWR sky130_fd_sc_hd__decap_3
XFILLER_55_551 VGND VGND VPWR VPWR sky130_fd_sc_hd__decap_3
XFILLER_27_275 VGND VGND VPWR VPWR sky130_fd_sc_hd__decap_3
XFILLER_82_392 VGND VGND VPWR VPWR sky130_fd_sc_hd__decap_3
XTAP_TAPCELL_ROW_83_1338 VGND VPWR sky130_fd_sc_hd__tapvpwrvgnd_1
XFILLER_42_256 VGND VGND VPWR VPWR sky130_fd_sc_hd__decap_3
XFILLER_63_78 VGND VGND VPWR VPWR sky130_fd_sc_hd__decap_3
XFILLER_8_29 VGND VGND VPWR VPWR sky130_fd_sc_hd__decap_3
XFILLER_11_676 VGND VGND VPWR VPWR sky130_fd_sc_hd__decap_3
XFILLER_7_603 VGND VGND VPWR VPWR sky130_fd_sc_hd__decap_3
XPHY_EDGE_ROW_38_Right_38 VGND VGND VPWR VPWR sky130_fd_sc_hd__decap_3
XFILLER_109_520 VGND VGND VPWR VPWR sky130_fd_sc_hd__decap_3
XFILLER_6_135 VGND VGND VPWR VPWR sky130_fd_sc_hd__fill_1
XFILLER_109_564 VGND VGND VPWR VPWR sky130_fd_sc_hd__decap_3
XFILLER_109_586 VGND VGND VPWR VPWR sky130_fd_sc_hd__decap_3
XFILLER_12_82 VGND VGND VPWR VPWR sky130_fd_sc_hd__fill_2
XFILLER_88_42 VGND VGND VPWR VPWR sky130_fd_sc_hd__decap_3
XTAP_TAPCELL_ROW_94_1478 VGND VPWR sky130_fd_sc_hd__tapvpwrvgnd_1
XFILLER_111_228 VGND VGND VPWR VPWR sky130_fd_sc_hd__decap_3
XFILLER_112_729 VGND VGND VPWR VPWR sky130_fd_sc_hd__decap_3
XFILLER_2_363 VGND VGND VPWR VPWR sky130_fd_sc_hd__fill_1
XFILLER_2_374 VGND VGND VPWR VPWR sky130_fd_sc_hd__fill_1
XFILLER_88_97 VGND VGND VPWR VPWR sky130_fd_sc_hd__decap_3
XFILLER_77_131 VGND VGND VPWR VPWR sky130_fd_sc_hd__fill_1
XFILLER_38_507 VGND VGND VPWR VPWR sky130_fd_sc_hd__fill_2
XFILLER_77_153 VGND VGND VPWR VPWR sky130_fd_sc_hd__decap_3
XFILLER_78_676 VGND VGND VPWR VPWR sky130_fd_sc_hd__fill_1
XPHY_EDGE_ROW_47_Right_47 VGND VGND VPWR VPWR sky130_fd_sc_hd__decap_3
XFILLER_19_732 VGND VGND VPWR VPWR sky130_fd_sc_hd__fill_1
XFILLER_65_326 VGND VGND VPWR VPWR sky130_fd_sc_hd__decap_3
XFILLER_65_337 VGND VGND VPWR VPWR sky130_fd_sc_hd__decap_3
XFILLER_77_197 VGND VGND VPWR VPWR sky130_fd_sc_hd__decap_3
XFILLER_93_624 VGND VGND VPWR VPWR sky130_fd_sc_hd__decap_3
XFILLER_92_134 VGND VGND VPWR VPWR sky130_fd_sc_hd__fill_1
XFILLER_93_668 VGND VGND VPWR VPWR sky130_fd_sc_hd__fill_1
XFILLER_18_253 VGND VGND VPWR VPWR sky130_fd_sc_hd__decap_3
XFILLER_18_286 VGND VGND VPWR VPWR sky130_fd_sc_hd__decap_3
XFILLER_33_201 VGND VGND VPWR VPWR sky130_fd_sc_hd__decap_3
XFILLER_46_573 VGND VGND VPWR VPWR sky130_fd_sc_hd__decap_3
XTAP_TAPCELL_ROW_16_465 VGND VPWR sky130_fd_sc_hd__tapvpwrvgnd_1
XPHY_EDGE_ROW_56_Right_56 VGND VGND VPWR VPWR sky130_fd_sc_hd__decap_3
XTAP_TAPCELL_ROW_103_1596 VGND VPWR sky130_fd_sc_hd__tapvpwrvgnd_1
X_4750_ _4750_/A _4750_/B VGND VGND VPWR VPWR _7463_/A sky130_fd_sc_hd__or2_2
X_4681_ _4681_/A VGND VGND VPWR VPWR _8278_/D sky130_fd_sc_hd__buf_1
X_6420_ _6419_/X _6274_/X _6706_/S VGND VGND VPWR VPWR _6420_/X sky130_fd_sc_hd__mux2_2
X_6351_ _5262_/X _5235_/X _5228_/X _5220_/B _6620_/A _6648_/A VGND VGND VPWR VPWR
+ _6351_/X sky130_fd_sc_hd__mux4_2
XFILLER_108_19 VGND VGND VPWR VPWR sky130_fd_sc_hd__decap_3
X_5302_ _5407_/A VGND VGND VPWR VPWR _5615_/A sky130_fd_sc_hd__buf_1
X_6282_ _6282_/A _6282_/B _6281_/X VGND VGND VPWR VPWR _6282_/X sky130_fd_sc_hd__or3b_2
XFILLER_102_206 VGND VGND VPWR VPWR sky130_fd_sc_hd__decap_3
XFILLER_88_429 VGND VGND VPWR VPWR sky130_fd_sc_hd__decap_3
XPHY_EDGE_ROW_65_Right_65 VGND VGND VPWR VPWR sky130_fd_sc_hd__decap_3
X_8021_ _8285_/CLK _8021_/D VGND VGND VPWR VPWR _8021_/Q sky130_fd_sc_hd__dfxtp_2
X_5233_ _8205_/Q _8206_/Q _6380_/S VGND VGND VPWR VPWR _5233_/X sky130_fd_sc_hd__mux2_2
XFILLER_68_120 VGND VGND VPWR VPWR sky130_fd_sc_hd__fill_2
XFILLER_69_654 VGND VGND VPWR VPWR sky130_fd_sc_hd__decap_3
X_5164_ _8180_/Q _7732_/B _5484_/S VGND VGND VPWR VPWR _5164_/X sky130_fd_sc_hd__mux2_2
XFILLER_56_304 VGND VGND VPWR VPWR sky130_fd_sc_hd__decap_3
XFILLER_69_676 VGND VGND VPWR VPWR sky130_fd_sc_hd__decap_3
XFILLER_96_451 VGND VGND VPWR VPWR sky130_fd_sc_hd__decap_3
X_4115_ _4115_/A VGND VGND VPWR VPWR _7995_/D sky130_fd_sc_hd__buf_1
XFILLER_110_283 VGND VGND VPWR VPWR sky130_fd_sc_hd__decap_3
XFILLER_29_529 VGND VGND VPWR VPWR sky130_fd_sc_hd__decap_3
XFILLER_68_197 VGND VGND VPWR VPWR sky130_fd_sc_hd__fill_2
XFILLER_84_635 VGND VGND VPWR VPWR sky130_fd_sc_hd__fill_1
XPHY_EDGE_ROW_3_Left_123 VGND VGND VPWR VPWR sky130_fd_sc_hd__decap_3
X_5095_ split/X _7631_/B _5090_/Y _5094_/X _7787_/A VGND VGND VPWR VPWR _5095_/X sky130_fd_sc_hd__o32a_2
XFILLER_56_348 VGND VGND VPWR VPWR sky130_fd_sc_hd__decap_3
XFILLER_84_657 VGND VGND VPWR VPWR sky130_fd_sc_hd__decap_3
X_4046_ _7930_/B _8364_/Q VGND VGND VPWR VPWR _4047_/A sky130_fd_sc_hd__and2_2
XTAP_TAPCELL_ROW_69_1160 VGND VPWR sky130_fd_sc_hd__tapvpwrvgnd_1
XFILLER_24_212 VGND VGND VPWR VPWR sky130_fd_sc_hd__decap_3
XFILLER_24_245 VGND VGND VPWR VPWR sky130_fd_sc_hd__decap_3
X_7805_ _7805_/A _8166_/Q VGND VGND VPWR VPWR _7805_/Y sky130_fd_sc_hd__nand2_2
XFILLER_24_256 VGND VGND VPWR VPWR sky130_fd_sc_hd__fill_2
XFILLER_24_278 VGND VGND VPWR VPWR sky130_fd_sc_hd__fill_2
XPHY_EDGE_ROW_74_Right_74 VGND VGND VPWR VPWR sky130_fd_sc_hd__decap_3
X_5997_ _5435_/A _5995_/X _5993_/Y _6624_/A VGND VGND VPWR VPWR _5997_/X sky130_fd_sc_hd__a2bb2o_2
XFILLER_33_37 VGND VGND VPWR VPWR sky130_fd_sc_hd__decap_3
X_7736_ _5684_/S _7656_/B _7734_/Y _7735_/Y VGND VGND VPWR VPWR _7736_/X sky130_fd_sc_hd__a31o_2
X_4948_ _5562_/A VGND VGND VPWR VPWR _5566_/A sky130_fd_sc_hd__inv_2
X_7667_ _6380_/S _4749_/A _7747_/A _5579_/S VGND VGND VPWR VPWR _7667_/X sky130_fd_sc_hd__o211a_2
X_4879_ _4880_/A _8249_/Q VGND VGND VPWR VPWR _4882_/A sky130_fd_sc_hd__nand2_2
XPHY_EDGE_ROW_49_Left_169 VGND VGND VPWR VPWR sky130_fd_sc_hd__decap_3
X_6618_ _6013_/X _6617_/X _5680_/A _6323_/X _7298_/S0 _7745_/A VGND VGND VPWR VPWR
+ _6618_/X sky130_fd_sc_hd__mux4_2
XFILLER_116_6 VGND VGND VPWR VPWR sky130_fd_sc_hd__decap_3
X_7598_ _7619_/A _8286_/Q _5332_/A _5951_/A VGND VGND VPWR VPWR _7598_/X sky130_fd_sc_hd__o211a_2
XFILLER_106_512 VGND VGND VPWR VPWR sky130_fd_sc_hd__decap_3
XFILLER_3_105 VGND VGND VPWR VPWR sky130_fd_sc_hd__decap_3
XFILLER_3_116 VGND VGND VPWR VPWR sky130_fd_sc_hd__fill_2
X_6549_ _8187_/Q _8188_/Q _6549_/C VGND VGND VPWR VPWR _6655_/A sky130_fd_sc_hd__or3_2
XFILLER_106_545 VGND VGND VPWR VPWR sky130_fd_sc_hd__decap_3
XFILLER_79_407 VGND VGND VPWR VPWR sky130_fd_sc_hd__decap_3
XPHY_EDGE_ROW_83_Right_83 VGND VGND VPWR VPWR sky130_fd_sc_hd__decap_3
XFILLER_58_12 VGND VGND VPWR VPWR sky130_fd_sc_hd__fill_1
X_8219_ _8226_/CLK _8219_/D VGND VGND VPWR VPWR _8219_/Q sky130_fd_sc_hd__dfxtp_2
XFILLER_58_56 VGND VGND VPWR VPWR sky130_fd_sc_hd__decap_3
XFILLER_59_142 VGND VGND VPWR VPWR sky130_fd_sc_hd__decap_3
XPHY_EDGE_ROW_58_Left_178 VGND VGND VPWR VPWR sky130_fd_sc_hd__decap_3
XFILLER_101_261 VGND VGND VPWR VPWR sky130_fd_sc_hd__decap_3
XFILLER_47_315 VGND VGND VPWR VPWR sky130_fd_sc_hd__decap_3
XFILLER_47_337 VGND VGND VPWR VPWR sky130_fd_sc_hd__decap_3
XFILLER_59_186 VGND VGND VPWR VPWR sky130_fd_sc_hd__decap_3
XFILLER_74_101 VGND VGND VPWR VPWR sky130_fd_sc_hd__fill_2
XFILLER_74_112 VGND VGND VPWR VPWR sky130_fd_sc_hd__decap_3
XFILLER_75_657 VGND VGND VPWR VPWR sky130_fd_sc_hd__fill_2
XFILLER_75_679 VGND VGND VPWR VPWR sky130_fd_sc_hd__decap_3
XFILLER_114_95 VGND VGND VPWR VPWR sky130_fd_sc_hd__decap_3
XFILLER_15_201 VGND VGND VPWR VPWR sky130_fd_sc_hd__decap_3
XFILLER_16_713 VGND VGND VPWR VPWR sky130_fd_sc_hd__fill_2
XFILLER_16_724 VGND VGND VPWR VPWR sky130_fd_sc_hd__decap_3
XFILLER_28_573 VGND VGND VPWR VPWR sky130_fd_sc_hd__decap_3
XFILLER_43_510 VGND VGND VPWR VPWR sky130_fd_sc_hd__decap_3
XFILLER_62_307 VGND VGND VPWR VPWR sky130_fd_sc_hd__fill_1
XFILLER_62_318 VGND VGND VPWR VPWR sky130_fd_sc_hd__decap_3
XFILLER_74_167 VGND VGND VPWR VPWR sky130_fd_sc_hd__decap_3
XFILLER_74_189 VGND VGND VPWR VPWR sky130_fd_sc_hd__decap_3
XFILLER_90_616 VGND VGND VPWR VPWR sky130_fd_sc_hd__decap_3
XFILLER_90_638 VGND VGND VPWR VPWR sky130_fd_sc_hd__decap_3
XFILLER_15_234 VGND VGND VPWR VPWR sky130_fd_sc_hd__decap_3
XFILLER_28_595 VGND VGND VPWR VPWR sky130_fd_sc_hd__decap_3
XFILLER_43_521 VGND VGND VPWR VPWR sky130_fd_sc_hd__decap_3
XPHY_EDGE_ROW_92_Right_92 VGND VGND VPWR VPWR sky130_fd_sc_hd__decap_3
XFILLER_15_267 VGND VGND VPWR VPWR sky130_fd_sc_hd__fill_2
XFILLER_30_215 VGND VGND VPWR VPWR sky130_fd_sc_hd__decap_3
XFILLER_70_384 VGND VGND VPWR VPWR sky130_fd_sc_hd__decap_3
XFILLER_90_32 VGND VGND VPWR VPWR sky130_fd_sc_hd__decap_3
XTAP_TAPCELL_ROW_13_424 VGND VPWR sky130_fd_sc_hd__tapvpwrvgnd_1
XFILLER_30_248 VGND VGND VPWR VPWR sky130_fd_sc_hd__decap_3
XFILLER_30_259 VGND VGND VPWR VPWR sky130_fd_sc_hd__decap_3
XFILLER_90_65 VGND VGND VPWR VPWR sky130_fd_sc_hd__fill_2
XFILLER_90_76 VGND VGND VPWR VPWR sky130_fd_sc_hd__decap_3
XPHY_EDGE_ROW_67_Left_187 VGND VGND VPWR VPWR sky130_fd_sc_hd__decap_3
XFILLER_11_484 VGND VGND VPWR VPWR sky130_fd_sc_hd__decap_3
XFILLER_90_98 VGND VGND VPWR VPWR sky130_fd_sc_hd__fill_2
XTAP_TAPCELL_ROW_96_1507 VGND VPWR sky130_fd_sc_hd__tapvpwrvgnd_1
XTAP_TAPCELL_ROW_41_788 VGND VPWR sky130_fd_sc_hd__tapvpwrvgnd_1
XFILLER_116_309 VGND VGND VPWR VPWR sky130_fd_sc_hd__decap_3
XFILLER_23_92 VGND VGND VPWR VPWR sky130_fd_sc_hd__decap_3
XFILLER_7_499 VGND VGND VPWR VPWR sky130_fd_sc_hd__decap_3
XFILLER_99_41 VGND VGND VPWR VPWR sky130_fd_sc_hd__decap_3
XFILLER_99_74 VGND VGND VPWR VPWR sky130_fd_sc_hd__fill_2
XFILLER_97_215 VGND VGND VPWR VPWR sky130_fd_sc_hd__decap_3
XFILLER_97_237 VGND VGND VPWR VPWR sky130_fd_sc_hd__decap_3
XPHY_EDGE_ROW_76_Left_196 VGND VGND VPWR VPWR sky130_fd_sc_hd__decap_3
XFILLER_38_304 VGND VGND VPWR VPWR sky130_fd_sc_hd__decap_3
XFILLER_78_451 VGND VGND VPWR VPWR sky130_fd_sc_hd__decap_3
XFILLER_66_635 VGND VGND VPWR VPWR sky130_fd_sc_hd__decap_3
XFILLER_78_473 VGND VGND VPWR VPWR sky130_fd_sc_hd__decap_3
XFILLER_66_668 VGND VGND VPWR VPWR sky130_fd_sc_hd__decap_3
XFILLER_81_605 VGND VGND VPWR VPWR sky130_fd_sc_hd__decap_3
XFILLER_93_443 VGND VGND VPWR VPWR sky130_fd_sc_hd__decap_3
XFILLER_0_41 VGND VGND VPWR VPWR sky130_fd_sc_hd__decap_3
XFILLER_19_573 VGND VGND VPWR VPWR sky130_fd_sc_hd__decap_3
XFILLER_53_329 VGND VGND VPWR VPWR sky130_fd_sc_hd__decap_3
XFILLER_65_167 VGND VGND VPWR VPWR sky130_fd_sc_hd__fill_1
XFILLER_65_178 VGND VGND VPWR VPWR sky130_fd_sc_hd__decap_3
XFILLER_93_476 VGND VGND VPWR VPWR sky130_fd_sc_hd__decap_3
X_5920_ _5552_/X _5553_/X _5520_/X _5550_/X _6784_/A _6648_/A VGND VGND VPWR VPWR
+ _5920_/X sky130_fd_sc_hd__mux4_2
XTAP_TAPCELL_ROW_49_899 VGND VPWR sky130_fd_sc_hd__tapvpwrvgnd_1
XFILLER_0_63 VGND VGND VPWR VPWR sky130_fd_sc_hd__decap_3
XFILLER_0_85 VGND VGND VPWR VPWR sky130_fd_sc_hd__decap_3
XFILLER_80_126 VGND VGND VPWR VPWR sky130_fd_sc_hd__decap_3
XTAP_TAPCELL_ROW_105_1625 VGND VPWR sky130_fd_sc_hd__tapvpwrvgnd_1
XFILLER_34_554 VGND VGND VPWR VPWR sky130_fd_sc_hd__decap_3
XFILLER_61_340 VGND VGND VPWR VPWR sky130_fd_sc_hd__decap_3
X_5851_ _6368_/B _5897_/C VGND VGND VPWR VPWR _5851_/Y sky130_fd_sc_hd__nand2_2
XFILLER_21_237 VGND VGND VPWR VPWR sky130_fd_sc_hd__decap_3
XFILLER_61_384 VGND VGND VPWR VPWR sky130_fd_sc_hd__fill_2
XPHY_EDGE_ROW_100_Right_100 VGND VGND VPWR VPWR sky130_fd_sc_hd__decap_3
X_5782_ _5782_/A VGND VGND VPWR VPWR _5782_/Y sky130_fd_sc_hd__inv_2
X_7521_ _7583_/C _7583_/D VGND VGND VPWR VPWR _7522_/B sky130_fd_sc_hd__nand2_2
X_4733_ _4733_/A _7633_/C VGND VGND VPWR VPWR _7522_/A sky130_fd_sc_hd__nand2_2
XTAP_TAPCELL_ROW_64_1090 VGND VPWR sky130_fd_sc_hd__tapvpwrvgnd_1
X_7452_ _5528_/A _6350_/X _6356_/X _7451_/Y VGND VGND VPWR VPWR _7452_/X sky130_fd_sc_hd__a22o_2
Xrebuffer508 rebuffer850/X VGND VGND VPWR VPWR rebuffer508/X sky130_fd_sc_hd__buf_6
XFILLER_119_169 VGND VGND VPWR VPWR sky130_fd_sc_hd__decap_3
XFILLER_119_29 VGND VGND VPWR VPWR sky130_fd_sc_hd__decap_3
X_6403_ _6564_/C _6403_/B VGND VGND VPWR VPWR _6405_/B sky130_fd_sc_hd__nand2_2
X_4664_ _7930_/B _8136_/Q VGND VGND VPWR VPWR _4665_/A sky130_fd_sc_hd__and2_2
X_7383_ _8214_/Q _7383_/B VGND VGND VPWR VPWR _7383_/Y sky130_fd_sc_hd__nor2_4
X_4595_ _4595_/A VGND VGND VPWR VPWR _8235_/D sky130_fd_sc_hd__buf_1
XTAP_TAPCELL_ROW_116_1765 VGND VPWR sky130_fd_sc_hd__tapvpwrvgnd_1
X_6334_ _6334_/A _6431_/C VGND VGND VPWR VPWR _6334_/Y sky130_fd_sc_hd__nor2_2
X_6265_ _8183_/Q _8247_/Q _6999_/A1 VGND VGND VPWR VPWR _6265_/X sky130_fd_sc_hd__o21a_2
XFILLER_0_119 VGND VGND VPWR VPWR sky130_fd_sc_hd__decap_3
XFILLER_103_537 VGND VGND VPWR VPWR sky130_fd_sc_hd__decap_3
XFILLER_88_248 VGND VGND VPWR VPWR sky130_fd_sc_hd__decap_3
X_8004_ _8390_/CLK _8004_/D VGND VGND VPWR VPWR _8004_/Q sky130_fd_sc_hd__dfxtp_2
X_5216_ _8215_/Q _8216_/Q _5484_/S VGND VGND VPWR VPWR _5216_/X sky130_fd_sc_hd__mux2_2
XFILLER_88_259 VGND VGND VPWR VPWR sky130_fd_sc_hd__decap_3
X_6196_ _6368_/B _6548_/C _6232_/B _5407_/X _7732_/B VGND VGND VPWR VPWR _6197_/B
+ sky130_fd_sc_hd__a221o_2
XFILLER_28_26 VGND VGND VPWR VPWR sky130_fd_sc_hd__fill_2
XFILLER_29_337 VGND VGND VPWR VPWR sky130_fd_sc_hd__fill_2
XFILLER_56_112 VGND VGND VPWR VPWR sky130_fd_sc_hd__decap_3
XFILLER_69_473 VGND VGND VPWR VPWR sky130_fd_sc_hd__decap_3
X_5147_ _5145_/X _5146_/X _5634_/S VGND VGND VPWR VPWR _5147_/X sky130_fd_sc_hd__mux2_2
XFILLER_28_59 VGND VGND VPWR VPWR sky130_fd_sc_hd__decap_3
XFILLER_29_359 VGND VGND VPWR VPWR sky130_fd_sc_hd__decap_3
XFILLER_56_156 VGND VGND VPWR VPWR sky130_fd_sc_hd__decap_3
XFILLER_72_605 VGND VGND VPWR VPWR sky130_fd_sc_hd__decap_3
XFILLER_84_443 VGND VGND VPWR VPWR sky130_fd_sc_hd__fill_1
X_5078_ _7631_/B VGND VGND VPWR VPWR _6767_/A sky130_fd_sc_hd__inv_2
XFILLER_44_318 VGND VGND VPWR VPWR sky130_fd_sc_hd__decap_3
XFILLER_56_189 VGND VGND VPWR VPWR sky130_fd_sc_hd__decap_3
XFILLER_72_627 VGND VGND VPWR VPWR sky130_fd_sc_hd__decap_3
X_4029_ _8294_/Q _8301_/Q _8318_/Q _8321_/Q VGND VGND VPWR VPWR _4031_/C sky130_fd_sc_hd__or4_2
XFILLER_25_532 VGND VGND VPWR VPWR sky130_fd_sc_hd__decap_3
XFILLER_37_370 VGND VGND VPWR VPWR sky130_fd_sc_hd__decap_3
XFILLER_71_148 VGND VGND VPWR VPWR sky130_fd_sc_hd__fill_2
XFILLER_52_362 VGND VGND VPWR VPWR sky130_fd_sc_hd__fill_2
XFILLER_80_660 VGND VGND VPWR VPWR sky130_fd_sc_hd__fill_2
XFILLER_12_204 VGND VGND VPWR VPWR sky130_fd_sc_hd__decap_3
XFILLER_52_395 VGND VGND VPWR VPWR sky130_fd_sc_hd__decap_3
XFILLER_12_259 VGND VGND VPWR VPWR sky130_fd_sc_hd__decap_3
X_7719_ _5785_/A _7717_/Y _7718_/X VGND VGND VPWR VPWR _7719_/Y sky130_fd_sc_hd__a21oi_2
XFILLER_100_97 VGND VGND VPWR VPWR sky130_fd_sc_hd__fill_2
XFILLER_20_281 VGND VGND VPWR VPWR sky130_fd_sc_hd__fill_1
XFILLER_60_68 VGND VGND VPWR VPWR sky130_fd_sc_hd__decap_3
XFILLER_114_3 VGND VGND VPWR VPWR sky130_fd_sc_hd__decap_3
XFILLER_106_331 VGND VGND VPWR VPWR sky130_fd_sc_hd__decap_3
XFILLER_69_22 VGND VGND VPWR VPWR sky130_fd_sc_hd__fill_2
XFILLER_69_55 VGND VGND VPWR VPWR sky130_fd_sc_hd__fill_1
XTAP_TAPCELL_ROW_91_1437 VGND VPWR sky130_fd_sc_hd__tapvpwrvgnd_1
XFILLER_106_386 VGND VGND VPWR VPWR sky130_fd_sc_hd__decap_3
XFILLER_69_88 VGND VGND VPWR VPWR sky130_fd_sc_hd__fill_2
XTAP_TAPCELL_ROW_91_1448 VGND VPWR sky130_fd_sc_hd__tapvpwrvgnd_1
XFILLER_0_653 VGND VGND VPWR VPWR sky130_fd_sc_hd__decap_3
XFILLER_79_259 VGND VGND VPWR VPWR sky130_fd_sc_hd__decap_3
XFILLER_102_570 VGND VGND VPWR VPWR sky130_fd_sc_hd__fill_2
XFILLER_102_581 VGND VGND VPWR VPWR sky130_fd_sc_hd__decap_3
XFILLER_48_624 VGND VGND VPWR VPWR sky130_fd_sc_hd__decap_3
XFILLER_87_281 VGND VGND VPWR VPWR sky130_fd_sc_hd__decap_3
XFILLER_48_657 VGND VGND VPWR VPWR sky130_fd_sc_hd__decap_3
XFILLER_63_638 VGND VGND VPWR VPWR sky130_fd_sc_hd__fill_1
XFILLER_75_487 VGND VGND VPWR VPWR sky130_fd_sc_hd__decap_3
XFILLER_85_87 VGND VGND VPWR VPWR sky130_fd_sc_hd__decap_3
XFILLER_90_413 VGND VGND VPWR VPWR sky130_fd_sc_hd__decap_3
XFILLER_62_115 VGND VGND VPWR VPWR sky130_fd_sc_hd__decap_3
XFILLER_90_457 VGND VGND VPWR VPWR sky130_fd_sc_hd__decap_3
XTAP_TAPCELL_ROW_46_858 VGND VPWR sky130_fd_sc_hd__tapvpwrvgnd_1
XFILLER_16_554 VGND VGND VPWR VPWR sky130_fd_sc_hd__decap_3
XFILLER_43_340 VGND VGND VPWR VPWR sky130_fd_sc_hd__decap_3
XFILLER_16_587 VGND VGND VPWR VPWR sky130_fd_sc_hd__fill_1
XFILLER_71_682 VGND VGND VPWR VPWR sky130_fd_sc_hd__decap_3
XFILLER_31_557 VGND VGND VPWR VPWR sky130_fd_sc_hd__decap_3
XFILLER_34_80 VGND VGND VPWR VPWR sky130_fd_sc_hd__decap_3
XFILLER_70_192 VGND VGND VPWR VPWR sky130_fd_sc_hd__decap_3
XTAP_TAPCELL_ROW_26_593 VGND VPWR sky130_fd_sc_hd__tapvpwrvgnd_1
XFILLER_8_731 VGND VGND VPWR VPWR sky130_fd_sc_hd__fill_2
XTAP_TAPCELL_ROW_100_1555 VGND VPWR sky130_fd_sc_hd__tapvpwrvgnd_1
XFILLER_117_607 VGND VGND VPWR VPWR sky130_fd_sc_hd__decap_3
XFILLER_11_281 VGND VGND VPWR VPWR sky130_fd_sc_hd__decap_3
XFILLER_117_629 VGND VGND VPWR VPWR sky130_fd_sc_hd__decap_3
X_4380_ _7930_/B _4380_/B VGND VGND VPWR VPWR _4381_/A sky130_fd_sc_hd__and2_2
XFILLER_98_502 VGND VGND VPWR VPWR sky130_fd_sc_hd__fill_1
XFILLER_98_524 VGND VGND VPWR VPWR sky130_fd_sc_hd__decap_3
XPHY_EDGE_ROW_84_Left_204 VGND VGND VPWR VPWR sky130_fd_sc_hd__decap_3
XFILLER_98_579 VGND VGND VPWR VPWR sky130_fd_sc_hd__decap_3
X_6050_ _6462_/A _8177_/Q _6049_/Y _5332_/A _4907_/A VGND VGND VPWR VPWR _6050_/X
+ sky130_fd_sc_hd__a32o_2
XFILLER_112_389 VGND VGND VPWR VPWR sky130_fd_sc_hd__decap_3
XFILLER_38_112 VGND VGND VPWR VPWR sky130_fd_sc_hd__decap_3
XFILLER_39_635 VGND VGND VPWR VPWR sky130_fd_sc_hd__decap_3
XFILLER_66_421 VGND VGND VPWR VPWR sky130_fd_sc_hd__decap_3
XFILLER_85_218 VGND VGND VPWR VPWR sky130_fd_sc_hd__decap_3
X_5001_ _8258_/Q _5000_/X _8194_/Q VGND VGND VPWR VPWR _5001_/X sky130_fd_sc_hd__a21bo_2
XFILLER_38_156 VGND VGND VPWR VPWR sky130_fd_sc_hd__decap_3
XFILLER_39_679 VGND VGND VPWR VPWR sky130_fd_sc_hd__decap_3
XFILLER_66_465 VGND VGND VPWR VPWR sky130_fd_sc_hd__decap_3
XFILLER_81_402 VGND VGND VPWR VPWR sky130_fd_sc_hd__decap_3
XFILLER_93_262 VGND VGND VPWR VPWR sky130_fd_sc_hd__decap_3
XFILLER_53_148 VGND VGND VPWR VPWR sky130_fd_sc_hd__decap_3
XFILLER_66_498 VGND VGND VPWR VPWR sky130_fd_sc_hd__decap_3
XFILLER_81_435 VGND VGND VPWR VPWR sky130_fd_sc_hd__decap_3
XFILLER_93_284 VGND VGND VPWR VPWR sky130_fd_sc_hd__decap_3
XPHY_EDGE_ROW_93_Left_213 VGND VGND VPWR VPWR sky130_fd_sc_hd__decap_3
X_6952_ _5528_/A _6951_/X _6529_/A VGND VGND VPWR VPWR _6952_/Y sky130_fd_sc_hd__o21ai_2
XFILLER_34_351 VGND VGND VPWR VPWR sky130_fd_sc_hd__decap_3
X_6883_ _6956_/D VGND VGND VPWR VPWR _6883_/Y sky130_fd_sc_hd__inv_2
X_5903_ _8288_/Q _5900_/S _5902_/X _5601_/X _4921_/A VGND VGND VPWR VPWR _5903_/X
+ sky130_fd_sc_hd__o32a_2
XFILLER_22_513 VGND VGND VPWR VPWR sky130_fd_sc_hd__decap_3
XFILLER_34_373 VGND VGND VPWR VPWR sky130_fd_sc_hd__decap_3
X_5834_ _6109_/A _5833_/X _5124_/A VGND VGND VPWR VPWR _5834_/Y sky130_fd_sc_hd__o21ai_2
XFILLER_22_557 VGND VGND VPWR VPWR sky130_fd_sc_hd__fill_2
XFILLER_22_568 VGND VGND VPWR VPWR sky130_fd_sc_hd__decap_3
X_5765_ _6767_/A _5765_/B VGND VGND VPWR VPWR _5765_/Y sky130_fd_sc_hd__nor2_2
X_7504_ _7503_/X _7388_/X _7623_/S VGND VGND VPWR VPWR _7504_/X sky130_fd_sc_hd__mux2_2
Xrebuffer327 _8227_/Q VGND VGND VPWR VPWR _6355_/A sky130_fd_sc_hd__buf_2
Xrebuffer316 rebuffer892/X VGND VGND VPWR VPWR _7426_/B1 sky130_fd_sc_hd__buf_6
X_5696_ _5702_/A _8232_/Q VGND VGND VPWR VPWR _5696_/Y sky130_fd_sc_hd__nor2_2
X_4716_ _6624_/A VGND VGND VPWR VPWR _4716_/X sky130_fd_sc_hd__clkbuf_1
XFILLER_107_128 VGND VGND VPWR VPWR sky130_fd_sc_hd__decap_3
X_7435_ _8216_/Q _8280_/Q VGND VGND VPWR VPWR _7435_/X sky130_fd_sc_hd__or2b_2
Xrebuffer349 _6564_/B VGND VGND VPWR VPWR _6403_/B sky130_fd_sc_hd__buf_2
X_4647_ _4647_/A VGND VGND VPWR VPWR _8261_/D sky130_fd_sc_hd__buf_1
XFILLER_30_49 VGND VGND VPWR VPWR sky130_fd_sc_hd__decap_3
X_7366_ _8278_/Q _7366_/B _7366_/C VGND VGND VPWR VPWR _7366_/Y sky130_fd_sc_hd__nor3_2
XFILLER_115_150 VGND VGND VPWR VPWR sky130_fd_sc_hd__fill_1
XFILLER_116_651 VGND VGND VPWR VPWR sky130_fd_sc_hd__decap_3
XFILLER_116_684 VGND VGND VPWR VPWR sky130_fd_sc_hd__decap_3
XFILLER_89_502 VGND VGND VPWR VPWR sky130_fd_sc_hd__fill_2
X_6317_ _7195_/B _6333_/B _6336_/B _5732_/X VGND VGND VPWR VPWR _6317_/X sky130_fd_sc_hd__a2bb2o_2
X_4578_ _7898_/B _8093_/Q VGND VGND VPWR VPWR _4579_/A sky130_fd_sc_hd__and2_2
XFILLER_103_323 VGND VGND VPWR VPWR sky130_fd_sc_hd__decap_3
XFILLER_115_194 VGND VGND VPWR VPWR sky130_fd_sc_hd__decap_3
XFILLER_89_557 VGND VGND VPWR VPWR sky130_fd_sc_hd__decap_3
X_7297_ _7296_/X _7239_/X _7123_/X _7059_/X _7812_/A _7670_/A VGND VGND VPWR VPWR
+ _7297_/X sky130_fd_sc_hd__mux4_2
XFILLER_39_47 VGND VGND VPWR VPWR sky130_fd_sc_hd__decap_3
X_6248_ _6248_/A _6571_/C VGND VGND VPWR VPWR _6248_/Y sky130_fd_sc_hd__nand2_2
XFILLER_103_389 VGND VGND VPWR VPWR sky130_fd_sc_hd__decap_3
XFILLER_39_69 VGND VGND VPWR VPWR sky130_fd_sc_hd__decap_3
XFILLER_57_421 VGND VGND VPWR VPWR sky130_fd_sc_hd__decap_3
X_6179_ _6155_/Y _6163_/X _6175_/X _6178_/X _6910_/A VGND VGND VPWR VPWR _6179_/X
+ sky130_fd_sc_hd__a32o_2
XFILLER_69_281 VGND VGND VPWR VPWR sky130_fd_sc_hd__decap_3
XFILLER_29_167 VGND VGND VPWR VPWR sky130_fd_sc_hd__fill_1
XFILLER_45_605 VGND VGND VPWR VPWR sky130_fd_sc_hd__decap_3
XFILLER_84_262 VGND VGND VPWR VPWR sky130_fd_sc_hd__decap_3
XFILLER_55_57 VGND VGND VPWR VPWR sky130_fd_sc_hd__decap_3
XFILLER_72_424 VGND VGND VPWR VPWR sky130_fd_sc_hd__decap_3
XFILLER_84_295 VGND VGND VPWR VPWR sky130_fd_sc_hd__decap_3
XFILLER_25_340 VGND VGND VPWR VPWR sky130_fd_sc_hd__fill_1
XFILLER_60_619 VGND VGND VPWR VPWR sky130_fd_sc_hd__decap_3
XTAP_TAPCELL_ROW_43_817 VGND VPWR sky130_fd_sc_hd__tapvpwrvgnd_1
XFILLER_111_63 VGND VGND VPWR VPWR sky130_fd_sc_hd__decap_3
XFILLER_53_671 VGND VGND VPWR VPWR sky130_fd_sc_hd__fill_1
XFILLER_13_557 VGND VGND VPWR VPWR sky130_fd_sc_hd__decap_3
XFILLER_40_321 VGND VGND VPWR VPWR sky130_fd_sc_hd__decap_3
XFILLER_71_34 VGND VGND VPWR VPWR sky130_fd_sc_hd__decap_3
XFILLER_40_376 VGND VGND VPWR VPWR sky130_fd_sc_hd__fill_1
XFILLER_71_78 VGND VGND VPWR VPWR sky130_fd_sc_hd__decap_3
XTAP_TAPCELL_ROW_23_563 VGND VPWR sky130_fd_sc_hd__tapvpwrvgnd_1
XTAP_TAPCELL_ROW_23_552 VGND VPWR sky130_fd_sc_hd__tapvpwrvgnd_1
XFILLER_4_200 VGND VGND VPWR VPWR sky130_fd_sc_hd__decap_3
XFILLER_5_712 VGND VGND VPWR VPWR sky130_fd_sc_hd__decap_3
Xrebuffer850 _7532_/C VGND VGND VPWR VPWR rebuffer850/X sky130_fd_sc_hd__buf_2
XFILLER_106_150 VGND VGND VPWR VPWR sky130_fd_sc_hd__decap_3
XFILLER_107_651 VGND VGND VPWR VPWR sky130_fd_sc_hd__decap_3
XFILLER_107_673 VGND VGND VPWR VPWR sky130_fd_sc_hd__decap_3
XFILLER_106_183 VGND VGND VPWR VPWR sky130_fd_sc_hd__decap_3
XFILLER_95_505 VGND VGND VPWR VPWR sky130_fd_sc_hd__decap_3
XFILLER_0_472 VGND VGND VPWR VPWR sky130_fd_sc_hd__decap_3
XFILLER_95_538 VGND VGND VPWR VPWR sky130_fd_sc_hd__fill_2
XFILLER_96_75 VGND VGND VPWR VPWR sky130_fd_sc_hd__fill_2
XFILLER_48_421 VGND VGND VPWR VPWR sky130_fd_sc_hd__decap_3
XFILLER_48_454 VGND VGND VPWR VPWR sky130_fd_sc_hd__fill_1
XFILLER_63_413 VGND VGND VPWR VPWR sky130_fd_sc_hd__decap_3
XFILLER_75_273 VGND VGND VPWR VPWR sky130_fd_sc_hd__decap_3
XFILLER_29_690 VGND VGND VPWR VPWR sky130_fd_sc_hd__decap_3
XFILLER_35_126 VGND VGND VPWR VPWR sky130_fd_sc_hd__decap_3
XFILLER_63_446 VGND VGND VPWR VPWR sky130_fd_sc_hd__fill_2
XFILLER_75_284 VGND VGND VPWR VPWR sky130_fd_sc_hd__decap_3
XFILLER_90_221 VGND VGND VPWR VPWR sky130_fd_sc_hd__decap_3
XFILLER_16_351 VGND VGND VPWR VPWR sky130_fd_sc_hd__fill_1
XFILLER_51_608 VGND VGND VPWR VPWR sky130_fd_sc_hd__decap_3
XFILLER_16_384 VGND VGND VPWR VPWR sky130_fd_sc_hd__fill_2
XFILLER_90_287 VGND VGND VPWR VPWR sky130_fd_sc_hd__decap_3
XFILLER_31_376 VGND VGND VPWR VPWR sky130_fd_sc_hd__decap_3
XFILLER_77_3 VGND VGND VPWR VPWR sky130_fd_sc_hd__fill_2
X_5550_ _5549_/X _5258_/X _6706_/S VGND VGND VPWR VPWR _5550_/X sky130_fd_sc_hd__mux2_2
XFILLER_117_404 VGND VGND VPWR VPWR sky130_fd_sc_hd__fill_2
X_5481_ _5506_/A _5481_/B VGND VGND VPWR VPWR _5481_/X sky130_fd_sc_hd__xor2_2
X_4501_ _4501_/A VGND VGND VPWR VPWR _8188_/D sky130_fd_sc_hd__buf_1
XFILLER_6_51 VGND VGND VPWR VPWR sky130_fd_sc_hd__decap_3
X_7220_ _7222_/B _7221_/B _7223_/C VGND VGND VPWR VPWR _7220_/X sky130_fd_sc_hd__and3_2
X_4432_ _7898_/B input2/X VGND VGND VPWR VPWR _4433_/A sky130_fd_sc_hd__and2_2
XTAP_TAPCELL_ROW_113_1724 VGND VPWR sky130_fd_sc_hd__tapvpwrvgnd_1
X_7151_ _7076_/A _7151_/B _7151_/C VGND VGND VPWR VPWR _7154_/C sky130_fd_sc_hd__and3b_2
X_4363_ _4363_/A VGND VGND VPWR VPWR _8119_/D sky130_fd_sc_hd__buf_1
XFILLER_112_131 VGND VGND VPWR VPWR sky130_fd_sc_hd__decap_3
XFILLER_113_676 VGND VGND VPWR VPWR sky130_fd_sc_hd__decap_3
XFILLER_59_719 VGND VGND VPWR VPWR sky130_fd_sc_hd__fill_1
XFILLER_98_365 VGND VGND VPWR VPWR sky130_fd_sc_hd__decap_3
X_7082_ _8265_/Q _7078_/B _8201_/Q VGND VGND VPWR VPWR _7082_/X sky130_fd_sc_hd__o21a_2
X_6102_ _6100_/Y _6101_/X _8178_/Q VGND VGND VPWR VPWR _6102_/X sky130_fd_sc_hd__mux2_2
X_4294_ _7898_/B _4294_/B VGND VGND VPWR VPWR _4295_/A sky130_fd_sc_hd__and2_2
XFILLER_112_186 VGND VGND VPWR VPWR sky130_fd_sc_hd__decap_3
XFILLER_86_516 VGND VGND VPWR VPWR sky130_fd_sc_hd__fill_2
XFILLER_86_527 VGND VGND VPWR VPWR sky130_fd_sc_hd__decap_3
XFILLER_98_387 VGND VGND VPWR VPWR sky130_fd_sc_hd__decap_3
X_6033_ _6097_/A _8240_/Q _8288_/Q VGND VGND VPWR VPWR _6033_/X sky130_fd_sc_hd__mux2_2
XFILLER_100_348 VGND VGND VPWR VPWR sky130_fd_sc_hd__fill_1
XFILLER_112_197 VGND VGND VPWR VPWR sky130_fd_sc_hd__fill_2
XFILLER_39_432 VGND VGND VPWR VPWR sky130_fd_sc_hd__decap_3
XFILLER_66_251 VGND VGND VPWR VPWR sky130_fd_sc_hd__fill_1
XFILLER_66_262 VGND VGND VPWR VPWR sky130_fd_sc_hd__decap_3
XFILLER_26_137 VGND VGND VPWR VPWR sky130_fd_sc_hd__decap_3
XFILLER_54_424 VGND VGND VPWR VPWR sky130_fd_sc_hd__decap_3
XFILLER_54_446 VGND VGND VPWR VPWR sky130_fd_sc_hd__decap_3
XFILLER_81_221 VGND VGND VPWR VPWR sky130_fd_sc_hd__decap_3
XFILLER_94_582 VGND VGND VPWR VPWR sky130_fd_sc_hd__decap_3
X_7984_ _8387_/CLK _7984_/D VGND VGND VPWR VPWR _7984_/Q sky130_fd_sc_hd__dfxtp_2
XFILLER_26_159 VGND VGND VPWR VPWR sky130_fd_sc_hd__decap_3
XFILLER_81_243 VGND VGND VPWR VPWR sky130_fd_sc_hd__decap_3
X_6935_ _7076_/B _6935_/B VGND VGND VPWR VPWR _6935_/Y sky130_fd_sc_hd__xnor2_2
XTAP_TAPCELL_ROW_1_269 VGND VPWR sky130_fd_sc_hd__tapvpwrvgnd_1
XFILLER_35_682 VGND VGND VPWR VPWR sky130_fd_sc_hd__fill_1
XFILLER_41_129 VGND VGND VPWR VPWR sky130_fd_sc_hd__decap_3
XFILLER_81_276 VGND VGND VPWR VPWR sky130_fd_sc_hd__decap_3
XFILLER_81_287 VGND VGND VPWR VPWR sky130_fd_sc_hd__decap_3
XFILLER_22_321 VGND VGND VPWR VPWR sky130_fd_sc_hd__decap_3
X_6866_ _6865_/X _6705_/X _7623_/S VGND VGND VPWR VPWR _6866_/X sky130_fd_sc_hd__mux2_2
XFILLER_10_516 VGND VGND VPWR VPWR sky130_fd_sc_hd__decap_3
XFILLER_22_365 VGND VGND VPWR VPWR sky130_fd_sc_hd__decap_3
X_6797_ _4845_/B _6795_/X _4849_/A _4998_/Y _6796_/Y VGND VGND VPWR VPWR _6797_/X
+ sky130_fd_sc_hd__a2111o_2
X_5817_ _5817_/A VGND VGND VPWR VPWR _7182_/B sky130_fd_sc_hd__clkbuf_2
X_5748_ _5747_/X _5544_/X _6706_/S VGND VGND VPWR VPWR _5749_/A sky130_fd_sc_hd__mux2_2
XTAP_TAPCELL_ROW_20_522 VGND VPWR sky130_fd_sc_hd__tapvpwrvgnd_1
XFILLER_108_404 VGND VGND VPWR VPWR sky130_fd_sc_hd__decap_3
XFILLER_108_437 VGND VGND VPWR VPWR sky130_fd_sc_hd__decap_3
X_5679_ _5678_/X _5594_/X _5484_/X _5348_/A _7812_/A _7670_/A VGND VGND VPWR VPWR
+ _5680_/A sky130_fd_sc_hd__mux4_2
XFILLER_2_704 VGND VGND VPWR VPWR sky130_fd_sc_hd__decap_3
X_7418_ _8216_/Q _8215_/Q _7796_/A VGND VGND VPWR VPWR _7418_/X sky130_fd_sc_hd__mux2_2
X_8398_ _8398_/CLK _8398_/D VGND VGND VPWR VPWR _8398_/Q sky130_fd_sc_hd__dfxtp_2
XTAP_TAPCELL_ROW_75_1229 VGND VPWR sky130_fd_sc_hd__tapvpwrvgnd_1
XFILLER_104_610 VGND VGND VPWR VPWR sky130_fd_sc_hd__fill_2
X_7349_ _7348_/X _7296_/X _7239_/X _7123_/X _7812_/A _7670_/A VGND VGND VPWR VPWR
+ _7349_/X sky130_fd_sc_hd__mux4_2
XFILLER_103_131 VGND VGND VPWR VPWR sky130_fd_sc_hd__decap_3
XFILLER_104_654 VGND VGND VPWR VPWR sky130_fd_sc_hd__decap_3
XFILLER_103_164 VGND VGND VPWR VPWR sky130_fd_sc_hd__decap_3
XFILLER_106_85 VGND VGND VPWR VPWR sky130_fd_sc_hd__decap_3
XFILLER_18_616 VGND VGND VPWR VPWR sky130_fd_sc_hd__decap_3
XFILLER_45_402 VGND VGND VPWR VPWR sky130_fd_sc_hd__decap_3
XFILLER_57_251 VGND VGND VPWR VPWR sky130_fd_sc_hd__decap_3
XFILLER_45_413 VGND VGND VPWR VPWR sky130_fd_sc_hd__decap_3
XFILLER_45_435 VGND VGND VPWR VPWR sky130_fd_sc_hd__decap_3
XFILLER_57_284 VGND VGND VPWR VPWR sky130_fd_sc_hd__decap_3
XFILLER_72_221 VGND VGND VPWR VPWR sky130_fd_sc_hd__decap_3
XTAP_TAPCELL_ROW_28_622 VGND VPWR sky130_fd_sc_hd__tapvpwrvgnd_1
XFILLER_17_148 VGND VGND VPWR VPWR sky130_fd_sc_hd__decap_3
XFILLER_26_660 VGND VGND VPWR VPWR sky130_fd_sc_hd__decap_3
XFILLER_26_693 VGND VGND VPWR VPWR sky130_fd_sc_hd__decap_3
XFILLER_60_416 VGND VGND VPWR VPWR sky130_fd_sc_hd__decap_3
XFILLER_60_427 VGND VGND VPWR VPWR sky130_fd_sc_hd__fill_1
XFILLER_72_265 VGND VGND VPWR VPWR sky130_fd_sc_hd__decap_3
XTAP_TAPCELL_ROW_56_986 VGND VPWR sky130_fd_sc_hd__tapvpwrvgnd_1
XFILLER_25_181 VGND VGND VPWR VPWR sky130_fd_sc_hd__decap_3
XFILLER_41_652 VGND VGND VPWR VPWR sky130_fd_sc_hd__decap_3
XFILLER_82_88 VGND VGND VPWR VPWR sky130_fd_sc_hd__decap_3
XFILLER_13_376 VGND VGND VPWR VPWR sky130_fd_sc_hd__decap_3
XFILLER_15_71 VGND VGND VPWR VPWR sky130_fd_sc_hd__decap_3
XFILLER_15_82 VGND VGND VPWR VPWR sky130_fd_sc_hd__fill_2
XFILLER_31_70 VGND VGND VPWR VPWR sky130_fd_sc_hd__decap_3
XFILLER_5_520 VGND VGND VPWR VPWR sky130_fd_sc_hd__decap_3
XFILLER_114_407 VGND VGND VPWR VPWR sky130_fd_sc_hd__decap_3
XFILLER_5_542 VGND VGND VPWR VPWR sky130_fd_sc_hd__decap_3
XFILLER_99_107 VGND VGND VPWR VPWR sky130_fd_sc_hd__decap_3
XFILLER_107_470 VGND VGND VPWR VPWR sky130_fd_sc_hd__decap_3
XFILLER_5_586 VGND VGND VPWR VPWR sky130_fd_sc_hd__decap_3
XFILLER_110_624 VGND VGND VPWR VPWR sky130_fd_sc_hd__decap_3
XFILLER_110_657 VGND VGND VPWR VPWR sky130_fd_sc_hd__decap_3
XFILLER_95_346 VGND VGND VPWR VPWR sky130_fd_sc_hd__decap_3
XFILLER_110_679 VGND VGND VPWR VPWR sky130_fd_sc_hd__fill_2
XFILLER_48_251 VGND VGND VPWR VPWR sky130_fd_sc_hd__fill_1
XFILLER_48_262 VGND VGND VPWR VPWR sky130_fd_sc_hd__decap_3
XFILLER_76_560 VGND VGND VPWR VPWR sky130_fd_sc_hd__decap_3
XFILLER_95_379 VGND VGND VPWR VPWR sky130_fd_sc_hd__decap_3
XFILLER_36_424 VGND VGND VPWR VPWR sky130_fd_sc_hd__decap_3
XFILLER_48_295 VGND VGND VPWR VPWR sky130_fd_sc_hd__decap_3
XFILLER_36_457 VGND VGND VPWR VPWR sky130_fd_sc_hd__decap_3
XFILLER_63_243 VGND VGND VPWR VPWR sky130_fd_sc_hd__decap_3
XFILLER_91_541 VGND VGND VPWR VPWR sky130_fd_sc_hd__decap_3
XFILLER_51_405 VGND VGND VPWR VPWR sky130_fd_sc_hd__decap_3
XFILLER_51_438 VGND VGND VPWR VPWR sky130_fd_sc_hd__fill_1
XFILLER_63_287 VGND VGND VPWR VPWR sky130_fd_sc_hd__fill_1
X_4981_ _7366_/B _4981_/B VGND VGND VPWR VPWR _4983_/B sky130_fd_sc_hd__or2_2
XFILLER_16_192 VGND VGND VPWR VPWR sky130_fd_sc_hd__decap_3
XFILLER_17_693 VGND VGND VPWR VPWR sky130_fd_sc_hd__fill_1
XFILLER_32_630 VGND VGND VPWR VPWR sky130_fd_sc_hd__fill_2
Xclkbuf_leaf_43_clk clkload0/A VGND VGND VPWR VPWR _8187_/CLK sky130_fd_sc_hd__clkbuf_8
X_6720_ _7193_/B _6710_/X _6716_/X _8195_/Q _6719_/Y VGND VGND VPWR VPWR _6722_/B
+ sky130_fd_sc_hd__a221o_2
X_6651_ _5244_/X _6649_/X _6650_/X _6109_/A VGND VGND VPWR VPWR _6662_/B sky130_fd_sc_hd__a31o_2
XFILLER_31_195 VGND VGND VPWR VPWR sky130_fd_sc_hd__decap_3
XFILLER_32_696 VGND VGND VPWR VPWR sky130_fd_sc_hd__decap_3
X_6582_ _8255_/Q _5398_/A _5338_/A VGND VGND VPWR VPWR _6582_/Y sky130_fd_sc_hd__o21ai_2
X_5602_ _8290_/Q _5562_/A _5601_/X VGND VGND VPWR VPWR _5602_/Y sky130_fd_sc_hd__a21oi_2
XFILLER_118_713 VGND VGND VPWR VPWR sky130_fd_sc_hd__decap_3
X_8321_ _8365_/CLK _8321_/D VGND VGND VPWR VPWR _8321_/Q sky130_fd_sc_hd__dfxtp_2
X_5533_ _8165_/Q _5584_/B VGND VGND VPWR VPWR _5533_/Y sky130_fd_sc_hd__xnor2_2
X_8252_ _8387_/CLK _8252_/D VGND VGND VPWR VPWR _8252_/Q sky130_fd_sc_hd__dfxtp_2
X_5464_ _5464_/A _5464_/B VGND VGND VPWR VPWR _5464_/Y sky130_fd_sc_hd__nand2_2
X_8183_ _8224_/CLK _8183_/D VGND VGND VPWR VPWR _8183_/Q sky130_fd_sc_hd__dfxtp_4
X_7203_ _6072_/X _7198_/X _7202_/Y _6109_/A VGND VGND VPWR VPWR _7204_/D sky130_fd_sc_hd__a31o_2
X_5395_ _5389_/X _5390_/X _5393_/X _5394_/X _5270_/X _6648_/A VGND VGND VPWR VPWR
+ _5395_/X sky130_fd_sc_hd__mux4_2
X_4415_ _4415_/A VGND VGND VPWR VPWR _8145_/D sky130_fd_sc_hd__buf_1
X_7134_ _8272_/Q _5292_/X _5111_/X VGND VGND VPWR VPWR _7134_/X sky130_fd_sc_hd__a21o_2
X_4346_ _7898_/B _4346_/B VGND VGND VPWR VPWR _4347_/A sky130_fd_sc_hd__and2_2
XFILLER_59_505 VGND VGND VPWR VPWR sky130_fd_sc_hd__decap_3
XFILLER_98_162 VGND VGND VPWR VPWR sky130_fd_sc_hd__decap_3
XTAP_TAPCELL_ROW_6_339 VGND VPWR sky130_fd_sc_hd__tapvpwrvgnd_1
XFILLER_86_324 VGND VGND VPWR VPWR sky130_fd_sc_hd__fill_2
XFILLER_86_335 VGND VGND VPWR VPWR sky130_fd_sc_hd__decap_3
X_7065_ _8202_/Q _8203_/Q _7065_/C VGND VGND VPWR VPWR _7066_/A sky130_fd_sc_hd__or3_2
X_4277_ _4277_/A VGND VGND VPWR VPWR _8076_/D sky130_fd_sc_hd__buf_1
XFILLER_67_571 VGND VGND VPWR VPWR sky130_fd_sc_hd__decap_3
XFILLER_86_368 VGND VGND VPWR VPWR sky130_fd_sc_hd__fill_1
X_6016_ _6784_/A _6014_/X _6015_/X VGND VGND VPWR VPWR _6017_/B sky130_fd_sc_hd__a21o_2
XFILLER_36_15 VGND VGND VPWR VPWR sky130_fd_sc_hd__decap_3
XFILLER_39_273 VGND VGND VPWR VPWR sky130_fd_sc_hd__decap_3
XFILLER_39_284 VGND VGND VPWR VPWR sky130_fd_sc_hd__decap_3
XFILLER_82_541 VGND VGND VPWR VPWR sky130_fd_sc_hd__decap_3
XFILLER_42_427 VGND VGND VPWR VPWR sky130_fd_sc_hd__decap_3
X_7967_ _8384_/CLK _7967_/D VGND VGND VPWR VPWR _7967_/Q sky130_fd_sc_hd__dfxtp_2
XFILLER_14_129 VGND VGND VPWR VPWR sky130_fd_sc_hd__decap_3
XFILLER_23_641 VGND VGND VPWR VPWR sky130_fd_sc_hd__decap_3
X_7898_ _8319_/Q _7898_/B VGND VGND VPWR VPWR _7899_/A sky130_fd_sc_hd__and2_2
Xclkbuf_leaf_34_clk clkbuf_2_2__f_clk/X VGND VGND VPWR VPWR _8377_/CLK sky130_fd_sc_hd__clkbuf_8
X_6918_ _6999_/A1 _6916_/X _6917_/X _5332_/X VGND VGND VPWR VPWR _6918_/X sky130_fd_sc_hd__a22o_2
XTAP_TAPCELL_ROW_53_945 VGND VPWR sky130_fd_sc_hd__tapvpwrvgnd_1
XFILLER_22_151 VGND VGND VPWR VPWR sky130_fd_sc_hd__fill_2
XFILLER_23_685 VGND VGND VPWR VPWR sky130_fd_sc_hd__decap_3
X_6849_ _6847_/X _6848_/X _6910_/A VGND VGND VPWR VPWR _6849_/Y sky130_fd_sc_hd__o21ai_2
XFILLER_10_302 VGND VGND VPWR VPWR sky130_fd_sc_hd__decap_3
XFILLER_22_173 VGND VGND VPWR VPWR sky130_fd_sc_hd__decap_3
XFILLER_22_184 VGND VGND VPWR VPWR sky130_fd_sc_hd__decap_3
XFILLER_50_493 VGND VGND VPWR VPWR sky130_fd_sc_hd__decap_3
XTAP_TAPCELL_ROW_33_691 VGND VPWR sky130_fd_sc_hd__tapvpwrvgnd_1
XFILLER_10_368 VGND VGND VPWR VPWR sky130_fd_sc_hd__decap_3
XFILLER_108_245 VGND VGND VPWR VPWR sky130_fd_sc_hd__decap_3
XFILLER_2_512 VGND VGND VPWR VPWR sky130_fd_sc_hd__fill_1
XFILLER_117_51 VGND VGND VPWR VPWR sky130_fd_sc_hd__decap_3
XFILLER_7_3 VGND VGND VPWR VPWR sky130_fd_sc_hd__fill_2
XFILLER_89_140 VGND VGND VPWR VPWR sky130_fd_sc_hd__decap_3
XFILLER_117_95 VGND VGND VPWR VPWR sky130_fd_sc_hd__fill_1
XFILLER_77_302 VGND VGND VPWR VPWR sky130_fd_sc_hd__decap_3
XFILLER_77_44 VGND VGND VPWR VPWR sky130_fd_sc_hd__decap_3
XFILLER_77_335 VGND VGND VPWR VPWR sky130_fd_sc_hd__fill_1
XFILLER_77_346 VGND VGND VPWR VPWR sky130_fd_sc_hd__decap_3
XFILLER_77_66 VGND VGND VPWR VPWR sky130_fd_sc_hd__decap_3
XFILLER_89_184 VGND VGND VPWR VPWR sky130_fd_sc_hd__decap_3
XFILLER_65_508 VGND VGND VPWR VPWR sky130_fd_sc_hd__decap_3
XTAP_TAPCELL_ROW_88_1409 VGND VPWR sky130_fd_sc_hd__tapvpwrvgnd_1
XFILLER_100_690 VGND VGND VPWR VPWR sky130_fd_sc_hd__decap_3
XFILLER_45_243 VGND VGND VPWR VPWR sky130_fd_sc_hd__decap_3
XFILLER_73_541 VGND VGND VPWR VPWR sky130_fd_sc_hd__fill_2
XFILLER_33_405 VGND VGND VPWR VPWR sky130_fd_sc_hd__decap_3
XFILLER_45_276 VGND VGND VPWR VPWR sky130_fd_sc_hd__decap_3
XFILLER_45_287 VGND VGND VPWR VPWR sky130_fd_sc_hd__decap_3
XFILLER_93_87 VGND VGND VPWR VPWR sky130_fd_sc_hd__decap_3
XFILLER_14_641 VGND VGND VPWR VPWR sky130_fd_sc_hd__decap_3
XFILLER_26_70 VGND VGND VPWR VPWR sky130_fd_sc_hd__decap_3
XFILLER_33_438 VGND VGND VPWR VPWR sky130_fd_sc_hd__decap_3
XFILLER_33_449 VGND VGND VPWR VPWR sky130_fd_sc_hd__decap_3
XFILLER_60_224 VGND VGND VPWR VPWR sky130_fd_sc_hd__decap_3
Xclkbuf_leaf_25_clk clkbuf_2_2__f_clk/X VGND VGND VPWR VPWR _8389_/CLK sky130_fd_sc_hd__clkbuf_8
XFILLER_9_122 VGND VGND VPWR VPWR sky130_fd_sc_hd__decap_3
XFILLER_42_80 VGND VGND VPWR VPWR sky130_fd_sc_hd__decap_3
XTAP_TAPCELL_ROW_99_1549 VGND VPWR sky130_fd_sc_hd__tapvpwrvgnd_1
XFILLER_42_91 VGND VGND VPWR VPWR sky130_fd_sc_hd__decap_3
XTAP_TAPCELL_ROW_11_396 VGND VPWR sky130_fd_sc_hd__tapvpwrvgnd_1
X_4200_ _7898_/B input9/X VGND VGND VPWR VPWR _4201_/A sky130_fd_sc_hd__and2_2
X_5180_ _6070_/A VGND VGND VPWR VPWR _6536_/A sky130_fd_sc_hd__clkbuf_2
XFILLER_110_421 VGND VGND VPWR VPWR sky130_fd_sc_hd__decap_3
XFILLER_3_52 VGND VGND VPWR VPWR sky130_fd_sc_hd__decap_3
XFILLER_3_63 VGND VGND VPWR VPWR sky130_fd_sc_hd__decap_3
XFILLER_68_324 VGND VGND VPWR VPWR sky130_fd_sc_hd__decap_3
XFILLER_96_633 VGND VGND VPWR VPWR sky130_fd_sc_hd__fill_2
X_4131_ _4131_/A VGND VGND VPWR VPWR _8003_/D sky130_fd_sc_hd__buf_1
XFILLER_3_96 VGND VGND VPWR VPWR sky130_fd_sc_hd__decap_3
XFILLER_56_508 VGND VGND VPWR VPWR sky130_fd_sc_hd__decap_3
XFILLER_68_368 VGND VGND VPWR VPWR sky130_fd_sc_hd__decap_3
XFILLER_95_154 VGND VGND VPWR VPWR sky130_fd_sc_hd__decap_3
XFILLER_96_666 VGND VGND VPWR VPWR sky130_fd_sc_hd__decap_3
XFILLER_96_677 VGND VGND VPWR VPWR sky130_fd_sc_hd__fill_2
X_4062_ _7930_/B _8372_/Q VGND VGND VPWR VPWR _4063_/A sky130_fd_sc_hd__and2_2
XFILLER_49_571 VGND VGND VPWR VPWR sky130_fd_sc_hd__decap_3
XFILLER_83_327 VGND VGND VPWR VPWR sky130_fd_sc_hd__decap_3
XFILLER_83_349 VGND VGND VPWR VPWR sky130_fd_sc_hd__decap_3
XFILLER_95_198 VGND VGND VPWR VPWR sky130_fd_sc_hd__decap_3
XFILLER_64_530 VGND VGND VPWR VPWR sky130_fd_sc_hd__fill_2
XFILLER_24_427 VGND VGND VPWR VPWR sky130_fd_sc_hd__fill_1
XFILLER_36_276 VGND VGND VPWR VPWR sky130_fd_sc_hd__fill_1
XFILLER_36_287 VGND VGND VPWR VPWR sky130_fd_sc_hd__decap_3
XFILLER_51_202 VGND VGND VPWR VPWR sky130_fd_sc_hd__decap_3
XFILLER_64_563 VGND VGND VPWR VPWR sky130_fd_sc_hd__decap_3
XFILLER_91_360 VGND VGND VPWR VPWR sky130_fd_sc_hd__decap_3
XTAP_TAPCELL_ROW_108_1667 VGND VPWR sky130_fd_sc_hd__tapvpwrvgnd_1
X_7821_ _5363_/X split/A _7655_/A _7819_/Y _7820_/X VGND VGND VPWR VPWR _7822_/C sky130_fd_sc_hd__a311o_2
XFILLER_24_438 VGND VGND VPWR VPWR sky130_fd_sc_hd__fill_2
XFILLER_91_393 VGND VGND VPWR VPWR sky130_fd_sc_hd__fill_2
X_7752_ _5785_/A _7750_/Y _7751_/X VGND VGND VPWR VPWR _7752_/Y sky130_fd_sc_hd__a21oi_2
Xclkbuf_leaf_16_clk clkload2/A VGND VGND VPWR VPWR _8390_/CLK sky130_fd_sc_hd__clkbuf_8
X_4964_ _5286_/A VGND VGND VPWR VPWR _5346_/A sky130_fd_sc_hd__inv_2
XFILLER_51_257 VGND VGND VPWR VPWR sky130_fd_sc_hd__decap_3
X_6703_ _6769_/A _6700_/X _6702_/X VGND VGND VPWR VPWR _6703_/Y sky130_fd_sc_hd__o21ai_2
XTAP_TAPCELL_ROW_50_915 VGND VPWR sky130_fd_sc_hd__tapvpwrvgnd_1
XTAP_TAPCELL_ROW_50_904 VGND VPWR sky130_fd_sc_hd__tapvpwrvgnd_1
XFILLER_20_622 VGND VGND VPWR VPWR sky130_fd_sc_hd__fill_1
XFILLER_20_633 VGND VGND VPWR VPWR sky130_fd_sc_hd__decap_3
X_7683_ _7754_/A _7679_/Y _7682_/Y _7796_/A VGND VGND VPWR VPWR _7683_/X sky130_fd_sc_hd__a22o_2
X_4895_ _8244_/Q _8180_/Q VGND VGND VPWR VPWR _4897_/A sky130_fd_sc_hd__or2b_2
X_6634_ _8256_/Q _6610_/B _8192_/Q VGND VGND VPWR VPWR _6634_/X sky130_fd_sc_hd__o21ba_4
XFILLER_20_699 VGND VGND VPWR VPWR sky130_fd_sc_hd__fill_1
X_6565_ _6565_/A _6565_/B VGND VGND VPWR VPWR _6567_/A sky130_fd_sc_hd__nor2_2
XTAP_TAPCELL_ROW_30_650 VGND VPWR sky130_fd_sc_hd__tapvpwrvgnd_1
XFILLER_3_309 VGND VGND VPWR VPWR sky130_fd_sc_hd__fill_2
X_8304_ _8365_/CLK _8304_/D VGND VGND VPWR VPWR _8304_/Q sky130_fd_sc_hd__dfxtp_2
X_6496_ _6712_/B VGND VGND VPWR VPWR _6496_/Y sky130_fd_sc_hd__inv_2
X_5516_ _5913_/B _5470_/X _5515_/X VGND VGND VPWR VPWR _5516_/X sky130_fd_sc_hd__a21o_2
XFILLER_118_587 VGND VGND VPWR VPWR sky130_fd_sc_hd__fill_1
X_8235_ clkload7/A _8235_/D VGND VGND VPWR VPWR _8235_/Q sky130_fd_sc_hd__dfxtp_2
X_5447_ _7825_/A _5447_/B VGND VGND VPWR VPWR _6721_/B sky130_fd_sc_hd__nand2_2
XFILLER_105_237 VGND VGND VPWR VPWR sky130_fd_sc_hd__decap_3
X_8166_ clkload7/A _8166_/D VGND VGND VPWR VPWR _8166_/Q sky130_fd_sc_hd__dfxtp_2
X_5378_ _5376_/X _5377_/X _5684_/S VGND VGND VPWR VPWR _5378_/X sky130_fd_sc_hd__mux2_2
XFILLER_113_281 VGND VGND VPWR VPWR sky130_fd_sc_hd__fill_2
XFILLER_86_132 VGND VGND VPWR VPWR sky130_fd_sc_hd__decap_3
X_8097_ clkload7/A _8097_/D VGND VGND VPWR VPWR _8097_/Q sky130_fd_sc_hd__dfxtp_2
X_7117_ _7070_/X _6099_/A _7228_/B VGND VGND VPWR VPWR _7118_/B sky130_fd_sc_hd__mux2_2
X_4329_ _4329_/A VGND VGND VPWR VPWR _8102_/D sky130_fd_sc_hd__buf_1
XFILLER_101_454 VGND VGND VPWR VPWR sky130_fd_sc_hd__decap_3
XFILLER_47_25 VGND VGND VPWR VPWR sky130_fd_sc_hd__decap_3
XFILLER_47_508 VGND VGND VPWR VPWR sky130_fd_sc_hd__decap_3
XFILLER_59_368 VGND VGND VPWR VPWR sky130_fd_sc_hd__fill_2
XFILLER_59_379 VGND VGND VPWR VPWR sky130_fd_sc_hd__decap_3
XFILLER_86_165 VGND VGND VPWR VPWR sky130_fd_sc_hd__decap_3
XFILLER_87_666 VGND VGND VPWR VPWR sky130_fd_sc_hd__decap_3
X_7048_ _5563_/X _7032_/Y _7033_/X _7047_/Y VGND VGND VPWR VPWR _7048_/X sky130_fd_sc_hd__a211o_2
XFILLER_74_327 VGND VGND VPWR VPWR sky130_fd_sc_hd__decap_3
XFILLER_87_699 VGND VGND VPWR VPWR sky130_fd_sc_hd__decap_3
XPHY_EDGE_ROW_114_Right_114 VGND VGND VPWR VPWR sky130_fd_sc_hd__decap_3
XFILLER_27_221 VGND VGND VPWR VPWR sky130_fd_sc_hd__decap_3
XFILLER_27_243 VGND VGND VPWR VPWR sky130_fd_sc_hd__decap_3
XFILLER_15_416 VGND VGND VPWR VPWR sky130_fd_sc_hd__decap_3
XFILLER_82_371 VGND VGND VPWR VPWR sky130_fd_sc_hd__decap_3
XTAP_TAPCELL_ROW_38_750 VGND VPWR sky130_fd_sc_hd__tapvpwrvgnd_1
XFILLER_15_449 VGND VGND VPWR VPWR sky130_fd_sc_hd__fill_2
XFILLER_27_287 VGND VGND VPWR VPWR sky130_fd_sc_hd__decap_3
XFILLER_42_246 VGND VGND VPWR VPWR sky130_fd_sc_hd__decap_3
XFILLER_63_35 VGND VGND VPWR VPWR sky130_fd_sc_hd__fill_2
XFILLER_63_57 VGND VGND VPWR VPWR sky130_fd_sc_hd__decap_3
XFILLER_70_533 VGND VGND VPWR VPWR sky130_fd_sc_hd__fill_1
XFILLER_70_544 VGND VGND VPWR VPWR sky130_fd_sc_hd__decap_3
XTAP_TAPCELL_ROW_83_1339 VGND VPWR sky130_fd_sc_hd__tapvpwrvgnd_1
XFILLER_30_408 VGND VGND VPWR VPWR sky130_fd_sc_hd__decap_3
XFILLER_70_566 VGND VGND VPWR VPWR sky130_fd_sc_hd__decap_3
XFILLER_23_493 VGND VGND VPWR VPWR sky130_fd_sc_hd__fill_2
XFILLER_7_615 VGND VGND VPWR VPWR sky130_fd_sc_hd__fill_1
XFILLER_109_532 VGND VGND VPWR VPWR sky130_fd_sc_hd__fill_1
XFILLER_11_699 VGND VGND VPWR VPWR sky130_fd_sc_hd__decap_3
XFILLER_6_114 VGND VGND VPWR VPWR sky130_fd_sc_hd__fill_1
XFILLER_6_147 VGND VGND VPWR VPWR sky130_fd_sc_hd__decap_3
XFILLER_6_158 VGND VGND VPWR VPWR sky130_fd_sc_hd__decap_3
XFILLER_109_598 VGND VGND VPWR VPWR sky130_fd_sc_hd__decap_3
XFILLER_2_331 VGND VGND VPWR VPWR sky130_fd_sc_hd__decap_3
XFILLER_88_54 VGND VGND VPWR VPWR sky130_fd_sc_hd__decap_3
XTAP_TAPCELL_ROW_94_1479 VGND VPWR sky130_fd_sc_hd__tapvpwrvgnd_1
XFILLER_65_305 VGND VGND VPWR VPWR sky130_fd_sc_hd__decap_3
XFILLER_77_165 VGND VGND VPWR VPWR sky130_fd_sc_hd__decap_3
XFILLER_93_603 VGND VGND VPWR VPWR sky130_fd_sc_hd__decap_3
XFILLER_77_187 VGND VGND VPWR VPWR sky130_fd_sc_hd__decap_3
XFILLER_92_113 VGND VGND VPWR VPWR sky130_fd_sc_hd__decap_3
XFILLER_93_636 VGND VGND VPWR VPWR sky130_fd_sc_hd__decap_3
XFILLER_18_243 VGND VGND VPWR VPWR sky130_fd_sc_hd__decap_3
XFILLER_65_349 VGND VGND VPWR VPWR sky130_fd_sc_hd__decap_3
XFILLER_92_157 VGND VGND VPWR VPWR sky130_fd_sc_hd__decap_3
XFILLER_18_265 VGND VGND VPWR VPWR sky130_fd_sc_hd__decap_3
XFILLER_34_714 VGND VGND VPWR VPWR sky130_fd_sc_hd__decap_3
XFILLER_61_511 VGND VGND VPWR VPWR sky130_fd_sc_hd__fill_1
XFILLER_73_371 VGND VGND VPWR VPWR sky130_fd_sc_hd__decap_3
XFILLER_80_319 VGND VGND VPWR VPWR sky130_fd_sc_hd__decap_3
XFILLER_92_179 VGND VGND VPWR VPWR sky130_fd_sc_hd__decap_3
XFILLER_18_298 VGND VGND VPWR VPWR sky130_fd_sc_hd__decap_3
XFILLER_33_213 VGND VGND VPWR VPWR sky130_fd_sc_hd__decap_3
XFILLER_73_393 VGND VGND VPWR VPWR sky130_fd_sc_hd__fill_1
XFILLER_21_419 VGND VGND VPWR VPWR sky130_fd_sc_hd__decap_3
XFILLER_61_555 VGND VGND VPWR VPWR sky130_fd_sc_hd__decap_3
XTAP_TAPCELL_ROW_16_466 VGND VPWR sky130_fd_sc_hd__tapvpwrvgnd_1
XFILLER_14_471 VGND VGND VPWR VPWR sky130_fd_sc_hd__decap_3
XFILLER_53_90 VGND VGND VPWR VPWR sky130_fd_sc_hd__decap_3
XTAP_TAPCELL_ROW_103_1597 VGND VPWR sky130_fd_sc_hd__tapvpwrvgnd_1
X_4680_ _7930_/B _8144_/Q VGND VGND VPWR VPWR _4681_/A sky130_fd_sc_hd__and2_2
XFILLER_119_329 VGND VGND VPWR VPWR sky130_fd_sc_hd__decap_3
X_6350_ _6620_/A _5750_/X _6349_/Y _6132_/A VGND VGND VPWR VPWR _6350_/X sky130_fd_sc_hd__a211o_2
XTAP_TAPCELL_ROW_58_1010 VGND VPWR sky130_fd_sc_hd__tapvpwrvgnd_1
XFILLER_6_670 VGND VGND VPWR VPWR sky130_fd_sc_hd__decap_3
X_5301_ _7613_/B VGND VGND VPWR VPWR _5407_/A sky130_fd_sc_hd__clkbuf_1
XFILLER_6_692 VGND VGND VPWR VPWR sky130_fd_sc_hd__decap_3
X_6281_ _7193_/A _6270_/X _6273_/Y _6278_/X _6280_/Y VGND VGND VPWR VPWR _6281_/X
+ sky130_fd_sc_hd__a32o_2
XFILLER_102_218 VGND VGND VPWR VPWR sky130_fd_sc_hd__decap_3
XFILLER_69_611 VGND VGND VPWR VPWR sky130_fd_sc_hd__decap_3
XFILLER_88_408 VGND VGND VPWR VPWR sky130_fd_sc_hd__decap_3
X_8020_ _8269_/CLK _8020_/D VGND VGND VPWR VPWR _8020_/Q sky130_fd_sc_hd__dfxtp_2
Xclkbuf_leaf_5_clk clkload1/A VGND VGND VPWR VPWR _8226_/CLK sky130_fd_sc_hd__clkbuf_8
X_5232_ _7228_/B _8208_/Q _6380_/S VGND VGND VPWR VPWR _5232_/X sky130_fd_sc_hd__mux2_2
XFILLER_69_633 VGND VGND VPWR VPWR sky130_fd_sc_hd__decap_3
XFILLER_96_430 VGND VGND VPWR VPWR sky130_fd_sc_hd__decap_3
X_5163_ _7725_/B _8183_/Q _5484_/S VGND VGND VPWR VPWR _5163_/X sky130_fd_sc_hd__mux2_2
XFILLER_110_251 VGND VGND VPWR VPWR sky130_fd_sc_hd__fill_1
XFILLER_29_508 VGND VGND VPWR VPWR sky130_fd_sc_hd__decap_3
XFILLER_69_666 VGND VGND VPWR VPWR sky130_fd_sc_hd__decap_3
XFILLER_84_603 VGND VGND VPWR VPWR sky130_fd_sc_hd__decap_3
XFILLER_96_463 VGND VGND VPWR VPWR sky130_fd_sc_hd__decap_3
X_4114_ _7930_/B _8398_/Q VGND VGND VPWR VPWR _4115_/A sky130_fd_sc_hd__and2_2
XFILLER_110_262 VGND VGND VPWR VPWR sky130_fd_sc_hd__decap_3
XFILLER_68_165 VGND VGND VPWR VPWR sky130_fd_sc_hd__decap_3
XFILLER_69_699 VGND VGND VPWR VPWR sky130_fd_sc_hd__decap_3
XFILLER_83_113 VGND VGND VPWR VPWR sky130_fd_sc_hd__decap_3
X_5094_ split/X _7631_/B _5400_/A _5333_/A VGND VGND VPWR VPWR _5094_/X sky130_fd_sc_hd__o22a_2
XFILLER_83_157 VGND VGND VPWR VPWR sky130_fd_sc_hd__fill_2
XFILLER_84_669 VGND VGND VPWR VPWR sky130_fd_sc_hd__decap_3
X_4045_ _4045_/A VGND VGND VPWR VPWR _7960_/D sky130_fd_sc_hd__buf_1
XFILLER_64_360 VGND VGND VPWR VPWR sky130_fd_sc_hd__decap_3
XFILLER_64_371 VGND VGND VPWR VPWR sky130_fd_sc_hd__decap_3
XTAP_TAPCELL_ROW_69_1161 VGND VPWR sky130_fd_sc_hd__tapvpwrvgnd_1
XTAP_TAPCELL_ROW_69_1150 VGND VPWR sky130_fd_sc_hd__tapvpwrvgnd_1
XFILLER_24_224 VGND VGND VPWR VPWR sky130_fd_sc_hd__decap_3
XFILLER_52_533 VGND VGND VPWR VPWR sky130_fd_sc_hd__decap_3
XFILLER_64_393 VGND VGND VPWR VPWR sky130_fd_sc_hd__decap_3
XFILLER_91_190 VGND VGND VPWR VPWR sky130_fd_sc_hd__decap_3
X_7804_ _7653_/X _8196_/Q _7655_/X _7802_/Y _7803_/X VGND VGND VPWR VPWR _7804_/X
+ sky130_fd_sc_hd__a311o_2
XTAP_TAPCELL_ROW_35_720 VGND VPWR sky130_fd_sc_hd__tapvpwrvgnd_1
XFILLER_12_419 VGND VGND VPWR VPWR sky130_fd_sc_hd__fill_1
XFILLER_33_16 VGND VGND VPWR VPWR sky130_fd_sc_hd__decap_3
X_5996_ _6445_/A1 _5993_/Y _5995_/X _5433_/A VGND VGND VPWR VPWR _5996_/X sky130_fd_sc_hd__a2bb2o_2
X_7735_ _7805_/A _8178_/Q _7656_/B _5596_/S VGND VGND VPWR VPWR _7735_/Y sky130_fd_sc_hd__a211oi_2
X_4947_ _4947_/A _4947_/B VGND VGND VPWR VPWR _5562_/A sky130_fd_sc_hd__nand2_2
XFILLER_20_430 VGND VGND VPWR VPWR sky130_fd_sc_hd__decap_3
XFILLER_32_290 VGND VGND VPWR VPWR sky130_fd_sc_hd__fill_2
X_7666_ _6380_/S _8218_/Q _5579_/S VGND VGND VPWR VPWR _7666_/Y sky130_fd_sc_hd__a21oi_2
X_4878_ _8185_/Q VGND VGND VPWR VPWR _4880_/A sky130_fd_sc_hd__inv_2
XFILLER_20_474 VGND VGND VPWR VPWR sky130_fd_sc_hd__fill_2
XPHY_EDGE_ROW_104_Left_224 VGND VGND VPWR VPWR sky130_fd_sc_hd__decap_3
X_6617_ _6616_/X _6530_/X _6451_/X _6380_/X _7812_/A _7670_/A VGND VGND VPWR VPWR
+ _6617_/X sky130_fd_sc_hd__mux4_2
X_7597_ _8286_/Q _5601_/A _5338_/X VGND VGND VPWR VPWR _7597_/Y sky130_fd_sc_hd__o21ai_2
XFILLER_106_502 VGND VGND VPWR VPWR sky130_fd_sc_hd__decap_3
XFILLER_4_629 VGND VGND VPWR VPWR sky130_fd_sc_hd__decap_3
X_6548_ _8188_/Q _7694_/B _6548_/C _6548_/D VGND VGND VPWR VPWR _6569_/B sky130_fd_sc_hd__and4_2
XFILLER_106_557 VGND VGND VPWR VPWR sky130_fd_sc_hd__decap_3
XFILLER_118_395 VGND VGND VPWR VPWR sky130_fd_sc_hd__fill_1
X_6479_ _4886_/B _6564_/C _6564_/B _8186_/Q VGND VGND VPWR VPWR _6479_/Y sky130_fd_sc_hd__a31oi_2
XFILLER_79_419 VGND VGND VPWR VPWR sky130_fd_sc_hd__decap_3
X_8218_ _8218_/CLK _8218_/D VGND VGND VPWR VPWR _8218_/Q sky130_fd_sc_hd__dfxtp_2
XFILLER_58_35 VGND VGND VPWR VPWR sky130_fd_sc_hd__decap_3
X_8149_ _8285_/CLK _8149_/D VGND VGND VPWR VPWR _8149_/Q sky130_fd_sc_hd__dfxtp_2
XFILLER_101_240 VGND VGND VPWR VPWR sky130_fd_sc_hd__decap_3
XFILLER_59_154 VGND VGND VPWR VPWR sky130_fd_sc_hd__decap_3
XFILLER_87_452 VGND VGND VPWR VPWR sky130_fd_sc_hd__decap_3
XFILLER_101_273 VGND VGND VPWR VPWR sky130_fd_sc_hd__decap_3
XFILLER_101_284 VGND VGND VPWR VPWR sky130_fd_sc_hd__fill_1
XFILLER_114_41 VGND VGND VPWR VPWR sky130_fd_sc_hd__decap_3
XFILLER_47_327 VGND VGND VPWR VPWR sky130_fd_sc_hd__decap_3
XFILLER_87_485 VGND VGND VPWR VPWR sky130_fd_sc_hd__decap_3
XPHY_EDGE_ROW_113_Left_233 VGND VGND VPWR VPWR sky130_fd_sc_hd__decap_3
XFILLER_114_85 VGND VGND VPWR VPWR sky130_fd_sc_hd__fill_1
XFILLER_59_198 VGND VGND VPWR VPWR sky130_fd_sc_hd__decap_3
XFILLER_74_23 VGND VGND VPWR VPWR sky130_fd_sc_hd__decap_3
XFILLER_75_669 VGND VGND VPWR VPWR sky130_fd_sc_hd__decap_3
XFILLER_28_585 VGND VGND VPWR VPWR sky130_fd_sc_hd__decap_3
XFILLER_90_628 VGND VGND VPWR VPWR sky130_fd_sc_hd__decap_3
XFILLER_43_533 VGND VGND VPWR VPWR sky130_fd_sc_hd__decap_3
XFILLER_55_371 VGND VGND VPWR VPWR sky130_fd_sc_hd__fill_2
XFILLER_55_393 VGND VGND VPWR VPWR sky130_fd_sc_hd__decap_3
XFILLER_70_330 VGND VGND VPWR VPWR sky130_fd_sc_hd__decap_3
XFILLER_74_78 VGND VGND VPWR VPWR sky130_fd_sc_hd__decap_3
XFILLER_15_246 VGND VGND VPWR VPWR sky130_fd_sc_hd__decap_3
XFILLER_31_717 VGND VGND VPWR VPWR sky130_fd_sc_hd__decap_3
XFILLER_70_363 VGND VGND VPWR VPWR sky130_fd_sc_hd__fill_1
XFILLER_70_374 VGND VGND VPWR VPWR sky130_fd_sc_hd__decap_3
XFILLER_70_396 VGND VGND VPWR VPWR sky130_fd_sc_hd__fill_2
XFILLER_90_44 VGND VGND VPWR VPWR sky130_fd_sc_hd__decap_3
XFILLER_11_441 VGND VGND VPWR VPWR sky130_fd_sc_hd__decap_3
XFILLER_90_88 VGND VGND VPWR VPWR sky130_fd_sc_hd__decap_3
XTAP_TAPCELL_ROW_13_425 VGND VPWR sky130_fd_sc_hd__tapvpwrvgnd_1
XFILLER_11_474 VGND VGND VPWR VPWR sky130_fd_sc_hd__fill_1
XTAP_TAPCELL_ROW_96_1508 VGND VPWR sky130_fd_sc_hd__tapvpwrvgnd_1
XTAP_TAPCELL_ROW_41_789 VGND VPWR sky130_fd_sc_hd__tapvpwrvgnd_1
XFILLER_109_340 VGND VGND VPWR VPWR sky130_fd_sc_hd__decap_3
XFILLER_7_445 VGND VGND VPWR VPWR sky130_fd_sc_hd__decap_3
XFILLER_7_456 VGND VGND VPWR VPWR sky130_fd_sc_hd__decap_3
XFILLER_109_373 VGND VGND VPWR VPWR sky130_fd_sc_hd__decap_3
XFILLER_7_478 VGND VGND VPWR VPWR sky130_fd_sc_hd__decap_3
XFILLER_99_53 VGND VGND VPWR VPWR sky130_fd_sc_hd__decap_3
XFILLER_99_86 VGND VGND VPWR VPWR sky130_fd_sc_hd__decap_3
XFILLER_2_150 VGND VGND VPWR VPWR sky130_fd_sc_hd__fill_2
XFILLER_78_430 VGND VGND VPWR VPWR sky130_fd_sc_hd__decap_3
XFILLER_2_194 VGND VGND VPWR VPWR sky130_fd_sc_hd__fill_2
XFILLER_65_102 VGND VGND VPWR VPWR sky130_fd_sc_hd__fill_1
XFILLER_65_113 VGND VGND VPWR VPWR sky130_fd_sc_hd__decap_3
XFILLER_78_496 VGND VGND VPWR VPWR sky130_fd_sc_hd__decap_3
XFILLER_93_411 VGND VGND VPWR VPWR sky130_fd_sc_hd__decap_3
XFILLER_93_422 VGND VGND VPWR VPWR sky130_fd_sc_hd__decap_3
XFILLER_19_541 VGND VGND VPWR VPWR sky130_fd_sc_hd__decap_3
XFILLER_93_455 VGND VGND VPWR VPWR sky130_fd_sc_hd__decap_3
XFILLER_0_53 VGND VGND VPWR VPWR sky130_fd_sc_hd__decap_3
XFILLER_93_488 VGND VGND VPWR VPWR sky130_fd_sc_hd__decap_3
XFILLER_0_75 VGND VGND VPWR VPWR sky130_fd_sc_hd__decap_3
XFILLER_34_522 VGND VGND VPWR VPWR sky130_fd_sc_hd__decap_3
XFILLER_46_382 VGND VGND VPWR VPWR sky130_fd_sc_hd__decap_3
XFILLER_80_138 VGND VGND VPWR VPWR sky130_fd_sc_hd__fill_2
XTAP_TAPCELL_ROW_105_1626 VGND VPWR sky130_fd_sc_hd__tapvpwrvgnd_1
XFILLER_0_97 VGND VGND VPWR VPWR sky130_fd_sc_hd__decap_3
XFILLER_34_577 VGND VGND VPWR VPWR sky130_fd_sc_hd__decap_3
XFILLER_61_330 VGND VGND VPWR VPWR sky130_fd_sc_hd__decap_3
XFILLER_61_352 VGND VGND VPWR VPWR sky130_fd_sc_hd__decap_3
XFILLER_73_190 VGND VGND VPWR VPWR sky130_fd_sc_hd__decap_3
X_5850_ _7475_/A VGND VGND VPWR VPWR _7195_/B sky130_fd_sc_hd__buf_1
XFILLER_61_396 VGND VGND VPWR VPWR sky130_fd_sc_hd__decap_3
X_5781_ _5780_/X _5678_/X _5594_/X _5484_/X _7812_/A _7670_/A VGND VGND VPWR VPWR
+ _5782_/A sky130_fd_sc_hd__mux4_2
X_4801_ _4801_/A _5061_/A VGND VGND VPWR VPWR _7166_/C sky130_fd_sc_hd__or2_2
XFILLER_14_290 VGND VGND VPWR VPWR sky130_fd_sc_hd__decap_3
XFILLER_21_249 VGND VGND VPWR VPWR sky130_fd_sc_hd__decap_3
X_7520_ _4736_/Y _4750_/A _4737_/A VGND VGND VPWR VPWR _7583_/D sky130_fd_sc_hd__a21oi_2
X_4732_ _8220_/Q _7582_/B VGND VGND VPWR VPWR _7633_/C sky130_fd_sc_hd__nand2_2
XTAP_TAPCELL_ROW_64_1091 VGND VPWR sky130_fd_sc_hd__tapvpwrvgnd_1
X_7451_ _5528_/A _7450_/X _7626_/A VGND VGND VPWR VPWR _7451_/Y sky130_fd_sc_hd__o21ai_2
X_4663_ _4663_/A VGND VGND VPWR VPWR _8269_/D sky130_fd_sc_hd__buf_1
X_6402_ _5929_/B _6395_/X _5929_/A _6401_/X VGND VGND VPWR VPWR _6564_/B sky130_fd_sc_hd__o31ai_4
X_7382_ _8279_/Q _5296_/X _7453_/A _7380_/Y _7381_/X VGND VGND VPWR VPWR _7396_/B
+ sky130_fd_sc_hd__a2111o_2
X_4594_ _7898_/B _8101_/Q VGND VGND VPWR VPWR _4595_/A sky130_fd_sc_hd__and2_2
XFILLER_115_343 VGND VGND VPWR VPWR sky130_fd_sc_hd__decap_3
XTAP_TAPCELL_ROW_116_1766 VGND VPWR sky130_fd_sc_hd__tapvpwrvgnd_1
X_6333_ _8184_/Q _6333_/B VGND VGND VPWR VPWR _6431_/C sky130_fd_sc_hd__or2_4
XFILLER_103_505 VGND VGND VPWR VPWR sky130_fd_sc_hd__decap_3
X_6264_ _8183_/Q _8247_/Q VGND VGND VPWR VPWR _6264_/X sky130_fd_sc_hd__and2_2
XFILLER_103_549 VGND VGND VPWR VPWR sky130_fd_sc_hd__decap_3
X_8003_ _8390_/CLK _8003_/D VGND VGND VPWR VPWR _8003_/Q sky130_fd_sc_hd__dfxtp_2
X_5215_ _5213_/X _5214_/X _5451_/S VGND VGND VPWR VPWR _5215_/X sky130_fd_sc_hd__mux2_2
XFILLER_69_452 VGND VGND VPWR VPWR sky130_fd_sc_hd__decap_3
X_6195_ _6099_/A _6548_/C _6232_/B _7195_/B _7732_/B VGND VGND VPWR VPWR _6195_/X
+ sky130_fd_sc_hd__o221a_2
XFILLER_28_38 VGND VGND VPWR VPWR sky130_fd_sc_hd__decap_3
XFILLER_29_305 VGND VGND VPWR VPWR sky130_fd_sc_hd__decap_3
XFILLER_57_636 VGND VGND VPWR VPWR sky130_fd_sc_hd__decap_3
XFILLER_69_485 VGND VGND VPWR VPWR sky130_fd_sc_hd__decap_3
X_5146_ _8192_/Q _8193_/Q _5484_/S VGND VGND VPWR VPWR _5146_/X sky130_fd_sc_hd__mux2_2
XFILLER_56_135 VGND VGND VPWR VPWR sky130_fd_sc_hd__decap_3
XFILLER_57_669 VGND VGND VPWR VPWR sky130_fd_sc_hd__decap_3
X_5077_ _5077_/A _6769_/B VGND VGND VPWR VPWR _6765_/B sky130_fd_sc_hd__nand2_2
XFILLER_56_168 VGND VGND VPWR VPWR sky130_fd_sc_hd__decap_3
XFILLER_72_639 VGND VGND VPWR VPWR sky130_fd_sc_hd__decap_3
XFILLER_84_466 VGND VGND VPWR VPWR sky130_fd_sc_hd__decap_3
XFILLER_84_477 VGND VGND VPWR VPWR sky130_fd_sc_hd__decap_3
X_4028_ _8295_/Q _8305_/Q _8304_/Q _8344_/Q VGND VGND VPWR VPWR _4031_/B sky130_fd_sc_hd__or4_2
XFILLER_25_511 VGND VGND VPWR VPWR sky130_fd_sc_hd__decap_3
XFILLER_37_382 VGND VGND VPWR VPWR sky130_fd_sc_hd__decap_3
XFILLER_37_393 VGND VGND VPWR VPWR sky130_fd_sc_hd__decap_3
XFILLER_71_116 VGND VGND VPWR VPWR sky130_fd_sc_hd__decap_3
XFILLER_44_37 VGND VGND VPWR VPWR sky130_fd_sc_hd__decap_3
XFILLER_52_341 VGND VGND VPWR VPWR sky130_fd_sc_hd__decap_3
XFILLER_40_536 VGND VGND VPWR VPWR sky130_fd_sc_hd__decap_3
XFILLER_52_374 VGND VGND VPWR VPWR sky130_fd_sc_hd__decap_3
XFILLER_80_672 VGND VGND VPWR VPWR sky130_fd_sc_hd__decap_3
XFILLER_80_694 VGND VGND VPWR VPWR sky130_fd_sc_hd__decap_3
X_5979_ _7182_/B _6494_/A _5942_/Y _5946_/B _7767_/B _5977_/A VGND VGND VPWR VPWR
+ _5979_/X sky130_fd_sc_hd__mux4_2
XFILLER_100_54 VGND VGND VPWR VPWR sky130_fd_sc_hd__decap_3
XFILLER_40_569 VGND VGND VPWR VPWR sky130_fd_sc_hd__decap_3
X_7718_ _6380_/S _7233_/S _7656_/B _5579_/S VGND VGND VPWR VPWR _7718_/X sky130_fd_sc_hd__o211a_2
XFILLER_100_76 VGND VGND VPWR VPWR sky130_fd_sc_hd__fill_1
X_7649_ _7649_/A _7649_/B VGND VGND VPWR VPWR _7649_/Y sky130_fd_sc_hd__nor2_2
XFILLER_109_30 VGND VGND VPWR VPWR sky130_fd_sc_hd__decap_3
XFILLER_119_660 VGND VGND VPWR VPWR sky130_fd_sc_hd__decap_3
XFILLER_107_3 VGND VGND VPWR VPWR sky130_fd_sc_hd__fill_2
XFILLER_109_74 VGND VGND VPWR VPWR sky130_fd_sc_hd__fill_2
XFILLER_106_343 VGND VGND VPWR VPWR sky130_fd_sc_hd__decap_3
XFILLER_106_365 VGND VGND VPWR VPWR sky130_fd_sc_hd__decap_3
XFILLER_109_85 VGND VGND VPWR VPWR sky130_fd_sc_hd__decap_3
XFILLER_79_205 VGND VGND VPWR VPWR sky130_fd_sc_hd__decap_3
XTAP_TAPCELL_ROW_91_1438 VGND VPWR sky130_fd_sc_hd__tapvpwrvgnd_1
XFILLER_106_398 VGND VGND VPWR VPWR sky130_fd_sc_hd__decap_3
XFILLER_0_643 VGND VGND VPWR VPWR sky130_fd_sc_hd__fill_1
XFILLER_47_102 VGND VGND VPWR VPWR sky130_fd_sc_hd__decap_3
XFILLER_47_113 VGND VGND VPWR VPWR sky130_fd_sc_hd__decap_3
XFILLER_48_636 VGND VGND VPWR VPWR sky130_fd_sc_hd__decap_3
XFILLER_75_411 VGND VGND VPWR VPWR sky130_fd_sc_hd__decap_3
XFILLER_87_260 VGND VGND VPWR VPWR sky130_fd_sc_hd__decap_3
XFILLER_94_219 VGND VGND VPWR VPWR sky130_fd_sc_hd__decap_3
XFILLER_48_669 VGND VGND VPWR VPWR sky130_fd_sc_hd__decap_3
XFILLER_75_455 VGND VGND VPWR VPWR sky130_fd_sc_hd__decap_3
XFILLER_85_66 VGND VGND VPWR VPWR sky130_fd_sc_hd__decap_3
XFILLER_87_293 VGND VGND VPWR VPWR sky130_fd_sc_hd__decap_3
XFILLER_16_500 VGND VGND VPWR VPWR sky130_fd_sc_hd__decap_3
XFILLER_63_617 VGND VGND VPWR VPWR sky130_fd_sc_hd__decap_3
XFILLER_85_99 VGND VGND VPWR VPWR sky130_fd_sc_hd__decap_3
XFILLER_18_82 VGND VGND VPWR VPWR sky130_fd_sc_hd__fill_2
XFILLER_18_93 VGND VGND VPWR VPWR sky130_fd_sc_hd__decap_3
XFILLER_28_371 VGND VGND VPWR VPWR sky130_fd_sc_hd__decap_3
XFILLER_56_691 VGND VGND VPWR VPWR sky130_fd_sc_hd__decap_3
XFILLER_62_127 VGND VGND VPWR VPWR sky130_fd_sc_hd__decap_3
XFILLER_75_499 VGND VGND VPWR VPWR sky130_fd_sc_hd__decap_3
XFILLER_90_436 VGND VGND VPWR VPWR sky130_fd_sc_hd__decap_3
XTAP_TAPCELL_ROW_46_859 VGND VPWR sky130_fd_sc_hd__tapvpwrvgnd_1
XFILLER_16_566 VGND VGND VPWR VPWR sky130_fd_sc_hd__decap_3
XFILLER_43_352 VGND VGND VPWR VPWR sky130_fd_sc_hd__decap_3
XFILLER_31_503 VGND VGND VPWR VPWR sky130_fd_sc_hd__fill_1
XFILLER_31_514 VGND VGND VPWR VPWR sky130_fd_sc_hd__decap_3
XFILLER_31_525 VGND VGND VPWR VPWR sky130_fd_sc_hd__fill_2
XFILLER_43_385 VGND VGND VPWR VPWR sky130_fd_sc_hd__fill_2
XFILLER_43_396 VGND VGND VPWR VPWR sky130_fd_sc_hd__decap_3
XTAP_TAPCELL_ROW_26_594 VGND VPWR sky130_fd_sc_hd__tapvpwrvgnd_1
XFILLER_8_710 VGND VGND VPWR VPWR sky130_fd_sc_hd__decap_3
XTAP_TAPCELL_ROW_100_1556 VGND VPWR sky130_fd_sc_hd__tapvpwrvgnd_1
XFILLER_7_275 VGND VGND VPWR VPWR sky130_fd_sc_hd__decap_3
XFILLER_109_181 VGND VGND VPWR VPWR sky130_fd_sc_hd__decap_3
XFILLER_50_91 VGND VGND VPWR VPWR sky130_fd_sc_hd__decap_3
XFILLER_7_297 VGND VGND VPWR VPWR sky130_fd_sc_hd__decap_3
XFILLER_98_547 VGND VGND VPWR VPWR sky130_fd_sc_hd__decap_3
XFILLER_112_346 VGND VGND VPWR VPWR sky130_fd_sc_hd__decap_3
XFILLER_112_368 VGND VGND VPWR VPWR sky130_fd_sc_hd__decap_3
X_5000_ _4998_/Y _6792_/A _4845_/B VGND VGND VPWR VPWR _5000_/X sky130_fd_sc_hd__o21a_2
XFILLER_100_519 VGND VGND VPWR VPWR sky130_fd_sc_hd__decap_3
XFILLER_39_603 VGND VGND VPWR VPWR sky130_fd_sc_hd__decap_3
XFILLER_78_271 VGND VGND VPWR VPWR sky130_fd_sc_hd__decap_3
XTAP_TAPCELL_ROW_111_1696 VGND VPWR sky130_fd_sc_hd__tapvpwrvgnd_1
XFILLER_39_647 VGND VGND VPWR VPWR sky130_fd_sc_hd__decap_3
XFILLER_66_433 VGND VGND VPWR VPWR sky130_fd_sc_hd__fill_2
XFILLER_78_282 VGND VGND VPWR VPWR sky130_fd_sc_hd__decap_3
XFILLER_38_179 VGND VGND VPWR VPWR sky130_fd_sc_hd__fill_2
XFILLER_53_105 VGND VGND VPWR VPWR sky130_fd_sc_hd__decap_3
XFILLER_54_606 VGND VGND VPWR VPWR sky130_fd_sc_hd__decap_3
XFILLER_66_477 VGND VGND VPWR VPWR sky130_fd_sc_hd__decap_3
XFILLER_81_414 VGND VGND VPWR VPWR sky130_fd_sc_hd__decap_3
XFILLER_93_252 VGND VGND VPWR VPWR sky130_fd_sc_hd__decap_3
XFILLER_19_393 VGND VGND VPWR VPWR sky130_fd_sc_hd__decap_3
XFILLER_53_116 VGND VGND VPWR VPWR sky130_fd_sc_hd__fill_2
XFILLER_81_447 VGND VGND VPWR VPWR sky130_fd_sc_hd__fill_1
X_6951_ _6381_/X _6950_/X _6105_/X _6677_/X _6536_/A _6818_/S VGND VGND VPWR VPWR
+ _6951_/X sky130_fd_sc_hd__mux4_2
XTAP_TAPCELL_ROW_66_1120 VGND VPWR sky130_fd_sc_hd__tapvpwrvgnd_1
XFILLER_34_330 VGND VGND VPWR VPWR sky130_fd_sc_hd__decap_3
XFILLER_62_661 VGND VGND VPWR VPWR sky130_fd_sc_hd__fill_1
XFILLER_81_469 VGND VGND VPWR VPWR sky130_fd_sc_hd__decap_3
X_6882_ _6885_/A _6882_/B VGND VGND VPWR VPWR _6882_/X sky130_fd_sc_hd__and2_2
X_5902_ _8237_/Q _5601_/A _6936_/A2 VGND VGND VPWR VPWR _5902_/X sky130_fd_sc_hd__o21a_2
XFILLER_22_525 VGND VGND VPWR VPWR sky130_fd_sc_hd__decap_3
XFILLER_34_363 VGND VGND VPWR VPWR sky130_fd_sc_hd__fill_1
XFILLER_34_385 VGND VGND VPWR VPWR sky130_fd_sc_hd__decap_3
X_5833_ _5393_/X _5394_/X _5450_/X _5389_/X _5182_/A _6648_/A VGND VGND VPWR VPWR
+ _5833_/X sky130_fd_sc_hd__mux4_2
XFILLER_22_536 VGND VGND VPWR VPWR sky130_fd_sc_hd__decap_3
X_7503_ _8219_/Q _8218_/Q _8217_/Q _8216_/Q _7796_/A _7765_/A VGND VGND VPWR VPWR
+ _7503_/X sky130_fd_sc_hd__mux4_2
X_5764_ _8170_/Q _8234_/Q VGND VGND VPWR VPWR _5765_/B sky130_fd_sc_hd__and2_2
Xrebuffer328 _7579_/X VGND VGND VPWR VPWR _7637_/B sky130_fd_sc_hd__buf_2
Xrebuffer317 _7559_/Y VGND VGND VPWR VPWR _7560_/B sky130_fd_sc_hd__buf_2
Xrebuffer306 rebuffer345/X VGND VGND VPWR VPWR _7536_/B2 sky130_fd_sc_hd__buf_2
X_5695_ _5691_/X _5693_/X _5695_/S VGND VGND VPWR VPWR _5695_/X sky130_fd_sc_hd__mux2_2
X_4715_ _6763_/B _5107_/B VGND VGND VPWR VPWR _6624_/A sky130_fd_sc_hd__nor2_2
X_7434_ _7437_/A _7434_/B VGND VGND VPWR VPWR _7434_/Y sky130_fd_sc_hd__xnor2_2
X_4646_ _7930_/B _8127_/Q VGND VGND VPWR VPWR _4647_/A sky130_fd_sc_hd__and2_2
XFILLER_116_641 VGND VGND VPWR VPWR sky130_fd_sc_hd__decap_3
X_7365_ _8278_/Q _7366_/B VGND VGND VPWR VPWR _7365_/Y sky130_fd_sc_hd__nand2_2
X_4577_ _4577_/A VGND VGND VPWR VPWR _8226_/D sky130_fd_sc_hd__buf_1
X_6316_ _8181_/Q _6490_/A _8183_/Q _6548_/C VGND VGND VPWR VPWR _6336_/B sky130_fd_sc_hd__and4_2
XTAP_TAPCELL_ROW_77_1260 VGND VPWR sky130_fd_sc_hd__tapvpwrvgnd_1
X_7296_ _8212_/Q _8211_/Q _7796_/A VGND VGND VPWR VPWR _7296_/X sky130_fd_sc_hd__mux2_2
XFILLER_103_335 VGND VGND VPWR VPWR sky130_fd_sc_hd__fill_1
XFILLER_103_346 VGND VGND VPWR VPWR sky130_fd_sc_hd__decap_3
XFILLER_39_26 VGND VGND VPWR VPWR sky130_fd_sc_hd__decap_3
XFILLER_89_569 VGND VGND VPWR VPWR sky130_fd_sc_hd__decap_3
X_6247_ _6353_/A _6247_/B VGND VGND VPWR VPWR _6571_/C sky130_fd_sc_hd__nor2_2
XFILLER_29_102 VGND VGND VPWR VPWR sky130_fd_sc_hd__decap_3
X_6178_ _6297_/C _6178_/B VGND VGND VPWR VPWR _6178_/X sky130_fd_sc_hd__xor2_2
XFILLER_29_113 VGND VGND VPWR VPWR sky130_fd_sc_hd__decap_3
XFILLER_57_444 VGND VGND VPWR VPWR sky130_fd_sc_hd__decap_3
XFILLER_69_293 VGND VGND VPWR VPWR sky130_fd_sc_hd__decap_3
X_5129_ _5444_/S VGND VGND VPWR VPWR _5451_/S sky130_fd_sc_hd__buf_1
XFILLER_45_628 VGND VGND VPWR VPWR sky130_fd_sc_hd__decap_3
XFILLER_55_14 VGND VGND VPWR VPWR sky130_fd_sc_hd__decap_3
XFILLER_57_455 VGND VGND VPWR VPWR sky130_fd_sc_hd__decap_3
XFILLER_57_477 VGND VGND VPWR VPWR sky130_fd_sc_hd__decap_3
XFILLER_72_403 VGND VGND VPWR VPWR sky130_fd_sc_hd__decap_3
XFILLER_84_241 VGND VGND VPWR VPWR sky130_fd_sc_hd__decap_3
XFILLER_38_691 VGND VGND VPWR VPWR sky130_fd_sc_hd__decap_3
XFILLER_44_105 VGND VGND VPWR VPWR sky130_fd_sc_hd__decap_3
XFILLER_44_127 VGND VGND VPWR VPWR sky130_fd_sc_hd__decap_3
XFILLER_84_274 VGND VGND VPWR VPWR sky130_fd_sc_hd__decap_3
XFILLER_111_20 VGND VGND VPWR VPWR sky130_fd_sc_hd__decap_3
XFILLER_25_330 VGND VGND VPWR VPWR sky130_fd_sc_hd__decap_3
XFILLER_37_190 VGND VGND VPWR VPWR sky130_fd_sc_hd__decap_3
XFILLER_53_650 VGND VGND VPWR VPWR sky130_fd_sc_hd__decap_3
XFILLER_72_458 VGND VGND VPWR VPWR sky130_fd_sc_hd__decap_3
XFILLER_25_374 VGND VGND VPWR VPWR sky130_fd_sc_hd__decap_3
XFILLER_52_160 VGND VGND VPWR VPWR sky130_fd_sc_hd__decap_3
XFILLER_80_480 VGND VGND VPWR VPWR sky130_fd_sc_hd__fill_1
XTAP_TAPCELL_ROW_43_818 VGND VPWR sky130_fd_sc_hd__tapvpwrvgnd_1
XFILLER_111_75 VGND VGND VPWR VPWR sky130_fd_sc_hd__decap_3
XFILLER_40_333 VGND VGND VPWR VPWR sky130_fd_sc_hd__decap_3
XFILLER_71_46 VGND VGND VPWR VPWR sky130_fd_sc_hd__decap_3
XFILLER_80_491 VGND VGND VPWR VPWR sky130_fd_sc_hd__decap_3
XFILLER_13_569 VGND VGND VPWR VPWR sky130_fd_sc_hd__decap_3
XFILLER_71_57 VGND VGND VPWR VPWR sky130_fd_sc_hd__decap_3
XTAP_TAPCELL_ROW_23_564 VGND VPWR sky130_fd_sc_hd__tapvpwrvgnd_1
XTAP_TAPCELL_ROW_23_553 VGND VPWR sky130_fd_sc_hd__tapvpwrvgnd_1
XFILLER_21_580 VGND VGND VPWR VPWR sky130_fd_sc_hd__decap_3
XFILLER_21_591 VGND VGND VPWR VPWR sky130_fd_sc_hd__decap_3
XFILLER_40_388 VGND VGND VPWR VPWR sky130_fd_sc_hd__decap_3
Xrebuffer840 _7255_/C VGND VGND VPWR VPWR _7254_/A2 sky130_fd_sc_hd__buf_2
XFILLER_107_630 VGND VGND VPWR VPWR sky130_fd_sc_hd__decap_3
XFILLER_5_724 VGND VGND VPWR VPWR sky130_fd_sc_hd__decap_3
XFILLER_107_663 VGND VGND VPWR VPWR sky130_fd_sc_hd__decap_3
XFILLER_4_256 VGND VGND VPWR VPWR sky130_fd_sc_hd__decap_3
XFILLER_106_162 VGND VGND VPWR VPWR sky130_fd_sc_hd__decap_3
XFILLER_106_195 VGND VGND VPWR VPWR sky130_fd_sc_hd__fill_1
XFILLER_96_32 VGND VGND VPWR VPWR sky130_fd_sc_hd__decap_3
XFILLER_67_219 VGND VGND VPWR VPWR sky130_fd_sc_hd__decap_3
XFILLER_96_54 VGND VGND VPWR VPWR sky130_fd_sc_hd__decap_3
XFILLER_48_433 VGND VGND VPWR VPWR sky130_fd_sc_hd__decap_3
XFILLER_29_81 VGND VGND VPWR VPWR sky130_fd_sc_hd__decap_3
XFILLER_36_628 VGND VGND VPWR VPWR sky130_fd_sc_hd__decap_3
XFILLER_48_477 VGND VGND VPWR VPWR sky130_fd_sc_hd__decap_3
XFILLER_75_296 VGND VGND VPWR VPWR sky130_fd_sc_hd__decap_3
XFILLER_63_469 VGND VGND VPWR VPWR sky130_fd_sc_hd__decap_3
XFILLER_90_233 VGND VGND VPWR VPWR sky130_fd_sc_hd__decap_3
XFILLER_90_244 VGND VGND VPWR VPWR sky130_fd_sc_hd__decap_3
XFILLER_90_266 VGND VGND VPWR VPWR sky130_fd_sc_hd__decap_3
XFILLER_31_333 VGND VGND VPWR VPWR sky130_fd_sc_hd__decap_3
XFILLER_43_182 VGND VGND VPWR VPWR sky130_fd_sc_hd__fill_1
XFILLER_71_491 VGND VGND VPWR VPWR sky130_fd_sc_hd__decap_3
XTAP_TAPCELL_ROW_61_1050 VGND VPWR sky130_fd_sc_hd__tapvpwrvgnd_1
XFILLER_31_388 VGND VGND VPWR VPWR sky130_fd_sc_hd__decap_3
XFILLER_61_90 VGND VGND VPWR VPWR sky130_fd_sc_hd__decap_3
XFILLER_8_551 VGND VGND VPWR VPWR sky130_fd_sc_hd__decap_3
X_5480_ _4960_/A _5480_/A2 _5651_/B VGND VGND VPWR VPWR _5481_/B sky130_fd_sc_hd__a21boi_2
X_4500_ _7898_/B _8054_/Q VGND VGND VPWR VPWR _4501_/A sky130_fd_sc_hd__and2_2
XANTENNA_1 _8344_/D VGND VGND VPWR VPWR sky130_fd_sc_hd__diode_2
XFILLER_8_595 VGND VGND VPWR VPWR sky130_fd_sc_hd__fill_2
X_4431_ _4431_/A VGND VGND VPWR VPWR _8153_/D sky130_fd_sc_hd__buf_1
XFILLER_6_63 VGND VGND VPWR VPWR sky130_fd_sc_hd__fill_2
XFILLER_6_85 VGND VGND VPWR VPWR sky130_fd_sc_hd__decap_3
XFILLER_98_300 VGND VGND VPWR VPWR sky130_fd_sc_hd__decap_3
XTAP_TAPCELL_ROW_113_1725 VGND VPWR sky130_fd_sc_hd__tapvpwrvgnd_1
X_7150_ _7102_/C _7147_/X _7149_/X _4805_/A VGND VGND VPWR VPWR _7151_/C sky130_fd_sc_hd__a22o_2
X_4362_ _7930_/B _4362_/B VGND VGND VPWR VPWR _4363_/A sky130_fd_sc_hd__and2_2
XFILLER_113_644 VGND VGND VPWR VPWR sky130_fd_sc_hd__fill_2
XFILLER_98_344 VGND VGND VPWR VPWR sky130_fd_sc_hd__decap_3
Xrebuffer1027 _7281_/C VGND VGND VPWR VPWR rebuffer308/A sky130_fd_sc_hd__buf_2
X_7081_ _8205_/Q _8269_/Q VGND VGND VPWR VPWR _7081_/Y sky130_fd_sc_hd__nand2_2
X_6101_ _5817_/A _6099_/B _6114_/B _6494_/A VGND VGND VPWR VPWR _6101_/X sky130_fd_sc_hd__a22o_2
X_4293_ _4293_/A VGND VGND VPWR VPWR _8084_/D sky130_fd_sc_hd__buf_1
XFILLER_100_305 VGND VGND VPWR VPWR sky130_fd_sc_hd__decap_3
XFILLER_113_688 VGND VGND VPWR VPWR sky130_fd_sc_hd__fill_2
XFILLER_39_411 VGND VGND VPWR VPWR sky130_fd_sc_hd__decap_3
XFILLER_86_539 VGND VGND VPWR VPWR sky130_fd_sc_hd__fill_1
XFILLER_98_399 VGND VGND VPWR VPWR sky130_fd_sc_hd__decap_3
X_6032_ _6097_/A _5701_/X _6031_/X _8288_/Q VGND VGND VPWR VPWR _6032_/X sky130_fd_sc_hd__o22a_2
XTAP_TAPCELL_ROW_72_1190 VGND VPWR sky130_fd_sc_hd__tapvpwrvgnd_1
XFILLER_27_617 VGND VGND VPWR VPWR sky130_fd_sc_hd__decap_3
XFILLER_39_455 VGND VGND VPWR VPWR sky130_fd_sc_hd__decap_3
XFILLER_54_403 VGND VGND VPWR VPWR sky130_fd_sc_hd__decap_3
XFILLER_82_701 VGND VGND VPWR VPWR sky130_fd_sc_hd__decap_3
XFILLER_39_488 VGND VGND VPWR VPWR sky130_fd_sc_hd__decap_3
XFILLER_66_274 VGND VGND VPWR VPWR sky130_fd_sc_hd__decap_3
XFILLER_81_200 VGND VGND VPWR VPWR sky130_fd_sc_hd__decap_3
X_7983_ _8384_/CLK _7983_/D VGND VGND VPWR VPWR _7983_/Q sky130_fd_sc_hd__dfxtp_2
XFILLER_54_458 VGND VGND VPWR VPWR sky130_fd_sc_hd__decap_3
XFILLER_81_255 VGND VGND VPWR VPWR sky130_fd_sc_hd__decap_3
X_6934_ _8265_/Q _6909_/B _6933_/X VGND VGND VPWR VPWR _6967_/B sky130_fd_sc_hd__a21oi_4
XFILLER_34_171 VGND VGND VPWR VPWR sky130_fd_sc_hd__decap_3
XFILLER_50_620 VGND VGND VPWR VPWR sky130_fd_sc_hd__decap_3
XFILLER_62_480 VGND VGND VPWR VPWR sky130_fd_sc_hd__decap_3
XFILLER_62_491 VGND VGND VPWR VPWR sky130_fd_sc_hd__decap_3
X_6865_ _8199_/Q _8198_/Q _8197_/Q _8196_/Q _6380_/S _5452_/S VGND VGND VPWR VPWR
+ _6865_/X sky130_fd_sc_hd__mux4_2
XFILLER_22_344 VGND VGND VPWR VPWR sky130_fd_sc_hd__decap_3
X_6796_ _6791_/A _4853_/B _5004_/B VGND VGND VPWR VPWR _6796_/Y sky130_fd_sc_hd__a21oi_2
X_5816_ _7783_/B _7776_/B _6023_/A _5896_/A VGND VGND VPWR VPWR _5816_/X sky130_fd_sc_hd__or4_2
XFILLER_10_528 VGND VGND VPWR VPWR sky130_fd_sc_hd__decap_3
XFILLER_50_697 VGND VGND VPWR VPWR sky130_fd_sc_hd__decap_3
X_5747_ _5828_/A2 _6095_/A _5747_/A2 _8166_/Q _5678_/S _5452_/S VGND VGND VPWR VPWR
+ _5747_/X sky130_fd_sc_hd__mux4_2
XTAP_TAPCELL_ROW_20_523 VGND VPWR sky130_fd_sc_hd__tapvpwrvgnd_1
XFILLER_108_449 VGND VGND VPWR VPWR sky130_fd_sc_hd__decap_3
X_7417_ _5627_/X _7412_/X _7416_/X _8290_/Q _6687_/X VGND VGND VPWR VPWR _7417_/X
+ sky130_fd_sc_hd__a221o_2
X_5678_ _6095_/A _8167_/Q _5678_/S VGND VGND VPWR VPWR _5678_/X sky130_fd_sc_hd__mux2_2
X_8397_ _8397_/CLK _8397_/D VGND VGND VPWR VPWR _8397_/Q sky130_fd_sc_hd__dfxtp_2
X_4629_ _4629_/A VGND VGND VPWR VPWR _8252_/D sky130_fd_sc_hd__buf_1
XFILLER_1_215 VGND VGND VPWR VPWR sky130_fd_sc_hd__fill_1
XFILLER_2_716 VGND VGND VPWR VPWR sky130_fd_sc_hd__decap_3
X_7348_ _8214_/Q _8213_/Q _7796_/A VGND VGND VPWR VPWR _7348_/X sky130_fd_sc_hd__mux2_2
XFILLER_104_666 VGND VGND VPWR VPWR sky130_fd_sc_hd__fill_2
XFILLER_106_20 VGND VGND VPWR VPWR sky130_fd_sc_hd__decap_3
XFILLER_116_493 VGND VGND VPWR VPWR sky130_fd_sc_hd__decap_3
X_7279_ _7255_/C _7255_/B _7257_/X _7278_/X VGND VGND VPWR VPWR _7280_/B sky130_fd_sc_hd__a31o_4
XFILLER_103_143 VGND VGND VPWR VPWR sky130_fd_sc_hd__decap_3
XFILLER_49_219 VGND VGND VPWR VPWR sky130_fd_sc_hd__decap_3
XFILLER_89_377 VGND VGND VPWR VPWR sky130_fd_sc_hd__decap_3
XFILLER_103_187 VGND VGND VPWR VPWR sky130_fd_sc_hd__decap_3
XFILLER_106_75 VGND VGND VPWR VPWR sky130_fd_sc_hd__decap_3
XFILLER_58_720 VGND VGND VPWR VPWR sky130_fd_sc_hd__decap_3
XFILLER_57_263 VGND VGND VPWR VPWR sky130_fd_sc_hd__decap_3
XFILLER_66_79 VGND VGND VPWR VPWR sky130_fd_sc_hd__decap_3
XFILLER_17_116 VGND VGND VPWR VPWR sky130_fd_sc_hd__decap_3
XFILLER_18_628 VGND VGND VPWR VPWR sky130_fd_sc_hd__decap_3
XFILLER_45_425 VGND VGND VPWR VPWR sky130_fd_sc_hd__decap_3
XFILLER_57_296 VGND VGND VPWR VPWR sky130_fd_sc_hd__decap_3
XFILLER_72_200 VGND VGND VPWR VPWR sky130_fd_sc_hd__decap_3
XTAP_TAPCELL_ROW_28_623 VGND VPWR sky130_fd_sc_hd__tapvpwrvgnd_1
XFILLER_45_447 VGND VGND VPWR VPWR sky130_fd_sc_hd__fill_1
XFILLER_72_233 VGND VGND VPWR VPWR sky130_fd_sc_hd__decap_3
XFILLER_72_244 VGND VGND VPWR VPWR sky130_fd_sc_hd__decap_3
XFILLER_60_406 VGND VGND VPWR VPWR sky130_fd_sc_hd__fill_2
XFILLER_72_277 VGND VGND VPWR VPWR sky130_fd_sc_hd__decap_3
XTAP_TAPCELL_ROW_56_987 VGND VPWR sky130_fd_sc_hd__tapvpwrvgnd_1
XFILLER_13_311 VGND VGND VPWR VPWR sky130_fd_sc_hd__fill_1
XFILLER_25_193 VGND VGND VPWR VPWR sky130_fd_sc_hd__decap_3
XFILLER_13_355 VGND VGND VPWR VPWR sky130_fd_sc_hd__decap_3
XFILLER_15_61 VGND VGND VPWR VPWR sky130_fd_sc_hd__fill_1
XFILLER_40_141 VGND VGND VPWR VPWR sky130_fd_sc_hd__decap_3
XFILLER_9_348 VGND VGND VPWR VPWR sky130_fd_sc_hd__decap_3
XFILLER_31_82 VGND VGND VPWR VPWR sky130_fd_sc_hd__decap_3
XFILLER_5_554 VGND VGND VPWR VPWR sky130_fd_sc_hd__decap_3
XFILLER_114_419 VGND VGND VPWR VPWR sky130_fd_sc_hd__fill_1
XFILLER_99_119 VGND VGND VPWR VPWR sky130_fd_sc_hd__decap_3
XFILLER_110_603 VGND VGND VPWR VPWR sky130_fd_sc_hd__decap_3
XFILLER_48_230 VGND VGND VPWR VPWR sky130_fd_sc_hd__decap_3
XFILLER_64_701 VGND VGND VPWR VPWR sky130_fd_sc_hd__decap_3
XFILLER_95_358 VGND VGND VPWR VPWR sky130_fd_sc_hd__decap_3
XFILLER_36_403 VGND VGND VPWR VPWR sky130_fd_sc_hd__decap_3
XFILLER_36_436 VGND VGND VPWR VPWR sky130_fd_sc_hd__decap_3
XFILLER_48_274 VGND VGND VPWR VPWR sky130_fd_sc_hd__decap_3
XFILLER_76_583 VGND VGND VPWR VPWR sky130_fd_sc_hd__decap_3
XFILLER_36_469 VGND VGND VPWR VPWR sky130_fd_sc_hd__decap_3
XFILLER_63_255 VGND VGND VPWR VPWR sky130_fd_sc_hd__decap_3
XFILLER_91_531 VGND VGND VPWR VPWR sky130_fd_sc_hd__decap_3
XFILLER_91_564 VGND VGND VPWR VPWR sky130_fd_sc_hd__decap_3
XFILLER_23_108 VGND VGND VPWR VPWR sky130_fd_sc_hd__decap_3
XFILLER_51_417 VGND VGND VPWR VPWR sky130_fd_sc_hd__decap_3
XFILLER_91_586 VGND VGND VPWR VPWR sky130_fd_sc_hd__decap_3
X_4980_ _4980_/A _4980_/B VGND VGND VPWR VPWR _4981_/B sky130_fd_sc_hd__nor2_2
XFILLER_16_171 VGND VGND VPWR VPWR sky130_fd_sc_hd__decap_3
XFILLER_32_642 VGND VGND VPWR VPWR sky130_fd_sc_hd__fill_2
XFILLER_44_480 VGND VGND VPWR VPWR sky130_fd_sc_hd__decap_3
XFILLER_31_152 VGND VGND VPWR VPWR sky130_fd_sc_hd__decap_3
XFILLER_32_675 VGND VGND VPWR VPWR sky130_fd_sc_hd__decap_3
X_6650_ _6784_/A _6650_/B _6650_/C VGND VGND VPWR VPWR _6650_/X sky130_fd_sc_hd__or3_2
X_6581_ _8255_/Q _5618_/A _5402_/A _6605_/A VGND VGND VPWR VPWR _6581_/X sky130_fd_sc_hd__a22o_2
X_5601_ _5601_/A VGND VGND VPWR VPWR _5601_/X sky130_fd_sc_hd__clkbuf_2
XFILLER_118_725 VGND VGND VPWR VPWR sky130_fd_sc_hd__decap_3
X_8320_ _8322_/CLK _8320_/D VGND VGND VPWR VPWR _8320_/Q sky130_fd_sc_hd__dfxtp_2
X_5532_ _8164_/Q _5532_/B VGND VGND VPWR VPWR _5584_/B sky130_fd_sc_hd__nand2_2
X_8251_ _8387_/CLK _8251_/D VGND VGND VPWR VPWR _8251_/Q sky130_fd_sc_hd__dfxtp_2
X_5463_ _5458_/X _5459_/X _5460_/X _5461_/X _7298_/S0 _7745_/A VGND VGND VPWR VPWR
+ _5464_/B sky130_fd_sc_hd__mux4_2
XFILLER_105_419 VGND VGND VPWR VPWR sky130_fd_sc_hd__decap_3
X_8182_ _8187_/CLK _8182_/D VGND VGND VPWR VPWR _8182_/Q sky130_fd_sc_hd__dfxtp_4
X_7202_ _7202_/A _7202_/B VGND VGND VPWR VPWR _7202_/Y sky130_fd_sc_hd__nand2_2
X_5394_ _5264_/X _5265_/X _5266_/X _5246_/X _7783_/A _5684_/S VGND VGND VPWR VPWR
+ _5394_/X sky130_fd_sc_hd__mux4_2
X_4414_ _7930_/B _4414_/B VGND VGND VPWR VPWR _4415_/A sky130_fd_sc_hd__and2_2
X_7133_ _5732_/X _7317_/C _7130_/Y _6494_/A _8208_/Q VGND VGND VPWR VPWR _7133_/X
+ sky130_fd_sc_hd__a221o_2
X_4345_ _4345_/A VGND VGND VPWR VPWR _8110_/D sky130_fd_sc_hd__buf_1
XFILLER_113_452 VGND VGND VPWR VPWR sky130_fd_sc_hd__decap_3
XFILLER_86_303 VGND VGND VPWR VPWR sky130_fd_sc_hd__decap_3
XFILLER_98_141 VGND VGND VPWR VPWR sky130_fd_sc_hd__decap_3
XFILLER_98_174 VGND VGND VPWR VPWR sky130_fd_sc_hd__decap_3
XFILLER_101_636 VGND VGND VPWR VPWR sky130_fd_sc_hd__decap_3
XFILLER_113_496 VGND VGND VPWR VPWR sky130_fd_sc_hd__decap_3
XFILLER_86_347 VGND VGND VPWR VPWR sky130_fd_sc_hd__decap_3
X_7064_ _8200_/Q _8201_/Q _8204_/Q _8205_/Q VGND VGND VPWR VPWR _7065_/C sky130_fd_sc_hd__or4_2
X_4276_ _7843_/A _4276_/B VGND VGND VPWR VPWR _4277_/A sky130_fd_sc_hd__and2_2
XFILLER_39_241 VGND VGND VPWR VPWR sky130_fd_sc_hd__fill_2
XFILLER_55_701 VGND VGND VPWR VPWR sky130_fd_sc_hd__fill_1
X_6015_ split/X _7825_/A _6571_/B VGND VGND VPWR VPWR _6015_/X sky130_fd_sc_hd__and3_2
XFILLER_100_179 VGND VGND VPWR VPWR sky130_fd_sc_hd__decap_3
XFILLER_27_403 VGND VGND VPWR VPWR sky130_fd_sc_hd__decap_3
XFILLER_54_200 VGND VGND VPWR VPWR sky130_fd_sc_hd__decap_3
XFILLER_94_380 VGND VGND VPWR VPWR sky130_fd_sc_hd__fill_2
XFILLER_27_447 VGND VGND VPWR VPWR sky130_fd_sc_hd__fill_1
XFILLER_27_458 VGND VGND VPWR VPWR sky130_fd_sc_hd__decap_3
XFILLER_39_296 VGND VGND VPWR VPWR sky130_fd_sc_hd__fill_2
XFILLER_54_233 VGND VGND VPWR VPWR sky130_fd_sc_hd__fill_1
XFILLER_70_704 VGND VGND VPWR VPWR sky130_fd_sc_hd__decap_3
XFILLER_42_406 VGND VGND VPWR VPWR sky130_fd_sc_hd__decap_3
XFILLER_54_277 VGND VGND VPWR VPWR sky130_fd_sc_hd__decap_3
X_7966_ _8384_/CLK _7966_/D VGND VGND VPWR VPWR _7966_/Q sky130_fd_sc_hd__dfxtp_2
XFILLER_23_620 VGND VGND VPWR VPWR sky130_fd_sc_hd__decap_3
XFILLER_35_491 VGND VGND VPWR VPWR sky130_fd_sc_hd__decap_3
XFILLER_42_439 VGND VGND VPWR VPWR sky130_fd_sc_hd__decap_3
X_7897_ _7897_/A VGND VGND VPWR VPWR _8385_/D sky130_fd_sc_hd__buf_1
X_6917_ _6462_/A _4823_/B _6956_/B VGND VGND VPWR VPWR _6917_/X sky130_fd_sc_hd__a21o_2
XTAP_TAPCELL_ROW_85_1370 VGND VPWR sky130_fd_sc_hd__tapvpwrvgnd_1
XTAP_TAPCELL_ROW_53_946 VGND VPWR sky130_fd_sc_hd__tapvpwrvgnd_1
XFILLER_23_653 VGND VGND VPWR VPWR sky130_fd_sc_hd__fill_2
X_6848_ _6874_/B _6848_/B _6848_/C _6848_/D VGND VGND VPWR VPWR _6848_/X sky130_fd_sc_hd__and4_2
XFILLER_50_472 VGND VGND VPWR VPWR sky130_fd_sc_hd__decap_3
XFILLER_109_725 VGND VGND VPWR VPWR sky130_fd_sc_hd__decap_3
XFILLER_10_347 VGND VGND VPWR VPWR sky130_fd_sc_hd__decap_3
X_6779_ _6494_/A _6839_/B _6778_/X VGND VGND VPWR VPWR _6779_/Y sky130_fd_sc_hd__a21oi_2
XTAP_TAPCELL_ROW_33_692 VGND VPWR sky130_fd_sc_hd__tapvpwrvgnd_1
XFILLER_108_224 VGND VGND VPWR VPWR sky130_fd_sc_hd__decap_3
XFILLER_6_318 VGND VGND VPWR VPWR sky130_fd_sc_hd__decap_3
XFILLER_108_268 VGND VGND VPWR VPWR sky130_fd_sc_hd__fill_1
XFILLER_117_30 VGND VGND VPWR VPWR sky130_fd_sc_hd__decap_3
XFILLER_104_430 VGND VGND VPWR VPWR sky130_fd_sc_hd__decap_3
XFILLER_77_314 VGND VGND VPWR VPWR sky130_fd_sc_hd__decap_3
XFILLER_89_196 VGND VGND VPWR VPWR sky130_fd_sc_hd__decap_3
XFILLER_46_701 VGND VGND VPWR VPWR sky130_fd_sc_hd__decap_3
XFILLER_77_369 VGND VGND VPWR VPWR sky130_fd_sc_hd__decap_3
XFILLER_45_211 VGND VGND VPWR VPWR sky130_fd_sc_hd__decap_3
XFILLER_46_712 VGND VGND VPWR VPWR sky130_fd_sc_hd__decap_3
XFILLER_58_572 VGND VGND VPWR VPWR sky130_fd_sc_hd__decap_3
XFILLER_85_380 VGND VGND VPWR VPWR sky130_fd_sc_hd__decap_3
XFILLER_92_328 VGND VGND VPWR VPWR sky130_fd_sc_hd__decap_3
XFILLER_18_469 VGND VGND VPWR VPWR sky130_fd_sc_hd__decap_3
XFILLER_73_553 VGND VGND VPWR VPWR sky130_fd_sc_hd__decap_3
XFILLER_93_44 VGND VGND VPWR VPWR sky130_fd_sc_hd__decap_3
XFILLER_93_66 VGND VGND VPWR VPWR sky130_fd_sc_hd__decap_3
XFILLER_33_417 VGND VGND VPWR VPWR sky130_fd_sc_hd__decap_3
XFILLER_45_255 VGND VGND VPWR VPWR sky130_fd_sc_hd__decap_3
XFILLER_60_203 VGND VGND VPWR VPWR sky130_fd_sc_hd__decap_3
XFILLER_73_564 VGND VGND VPWR VPWR sky130_fd_sc_hd__decap_3
XFILLER_73_575 VGND VGND VPWR VPWR sky130_fd_sc_hd__decap_3
XFILLER_26_480 VGND VGND VPWR VPWR sky130_fd_sc_hd__decap_3
XFILLER_26_82 VGND VGND VPWR VPWR sky130_fd_sc_hd__fill_2
XFILLER_60_236 VGND VGND VPWR VPWR sky130_fd_sc_hd__decap_3
XFILLER_73_597 VGND VGND VPWR VPWR sky130_fd_sc_hd__decap_3
XFILLER_13_141 VGND VGND VPWR VPWR sky130_fd_sc_hd__decap_3
XFILLER_14_697 VGND VGND VPWR VPWR sky130_fd_sc_hd__decap_3
XFILLER_41_461 VGND VGND VPWR VPWR sky130_fd_sc_hd__decap_3
XFILLER_41_483 VGND VGND VPWR VPWR sky130_fd_sc_hd__decap_3
XFILLER_9_178 VGND VGND VPWR VPWR sky130_fd_sc_hd__decap_3
XFILLER_5_340 VGND VGND VPWR VPWR sky130_fd_sc_hd__decap_3
XTAP_TAPCELL_ROW_11_397 VGND VPWR sky130_fd_sc_hd__tapvpwrvgnd_1
XFILLER_54_6 VGND VGND VPWR VPWR sky130_fd_sc_hd__fill_1
XFILLER_114_249 VGND VGND VPWR VPWR sky130_fd_sc_hd__decap_3
XFILLER_96_612 VGND VGND VPWR VPWR sky130_fd_sc_hd__decap_3
X_4130_ _7930_/B _7935_/Q VGND VGND VPWR VPWR _4131_/A sky130_fd_sc_hd__and2_2
XFILLER_110_433 VGND VGND VPWR VPWR sky130_fd_sc_hd__decap_3
XFILLER_68_347 VGND VGND VPWR VPWR sky130_fd_sc_hd__decap_3
XFILLER_95_111 VGND VGND VPWR VPWR sky130_fd_sc_hd__fill_1
XFILLER_96_645 VGND VGND VPWR VPWR sky130_fd_sc_hd__decap_3
XFILLER_110_455 VGND VGND VPWR VPWR sky130_fd_sc_hd__decap_3
XFILLER_3_75 VGND VGND VPWR VPWR sky130_fd_sc_hd__decap_3
XFILLER_83_306 VGND VGND VPWR VPWR sky130_fd_sc_hd__decap_3
XFILLER_95_133 VGND VGND VPWR VPWR sky130_fd_sc_hd__decap_3
XFILLER_95_166 VGND VGND VPWR VPWR sky130_fd_sc_hd__fill_2
X_4061_ _4061_/A VGND VGND VPWR VPWR _7968_/D sky130_fd_sc_hd__buf_1
XFILLER_110_488 VGND VGND VPWR VPWR sky130_fd_sc_hd__decap_3
XFILLER_95_188 VGND VGND VPWR VPWR sky130_fd_sc_hd__fill_1
XFILLER_64_542 VGND VGND VPWR VPWR sky130_fd_sc_hd__decap_3
XFILLER_76_380 VGND VGND VPWR VPWR sky130_fd_sc_hd__decap_3
XTAP_TAPCELL_ROW_108_1657 VGND VPWR sky130_fd_sc_hd__tapvpwrvgnd_1
X_7820_ _7820_/A _7820_/B VGND VGND VPWR VPWR _7820_/X sky130_fd_sc_hd__and2_2
XFILLER_24_406 VGND VGND VPWR VPWR sky130_fd_sc_hd__decap_3
XFILLER_91_372 VGND VGND VPWR VPWR sky130_fd_sc_hd__fill_1
XTAP_TAPCELL_ROW_108_1668 VGND VPWR sky130_fd_sc_hd__tapvpwrvgnd_1
XFILLER_51_214 VGND VGND VPWR VPWR sky130_fd_sc_hd__fill_1
XFILLER_51_225 VGND VGND VPWR VPWR sky130_fd_sc_hd__decap_3
X_7751_ _7796_/A _4817_/A _7747_/A _7670_/A VGND VGND VPWR VPWR _7751_/X sky130_fd_sc_hd__o211a_2
X_4963_ _5310_/A _5430_/B VGND VGND VPWR VPWR _4963_/X sky130_fd_sc_hd__and2b_2
XFILLER_51_269 VGND VGND VPWR VPWR sky130_fd_sc_hd__decap_3
X_7682_ _8223_/Q _7672_/X _7681_/X VGND VGND VPWR VPWR _7682_/Y sky130_fd_sc_hd__o21ai_2
X_6702_ _8288_/Q _4852_/A _6701_/X _5601_/A _4853_/B VGND VGND VPWR VPWR _6702_/X
+ sky130_fd_sc_hd__o32a_2
XTAP_TAPCELL_ROW_50_905 VGND VPWR sky130_fd_sc_hd__tapvpwrvgnd_1
XFILLER_20_601 VGND VGND VPWR VPWR sky130_fd_sc_hd__decap_3
XFILLER_32_461 VGND VGND VPWR VPWR sky130_fd_sc_hd__decap_3
XFILLER_32_472 VGND VGND VPWR VPWR sky130_fd_sc_hd__decap_3
XFILLER_32_483 VGND VGND VPWR VPWR sky130_fd_sc_hd__fill_1
X_6633_ _6636_/A _6667_/A VGND VGND VPWR VPWR _6633_/Y sky130_fd_sc_hd__xnor2_2
X_4894_ _6393_/B _4893_/X VGND VGND VPWR VPWR _6297_/B sky130_fd_sc_hd__or2b_2
XFILLER_20_645 VGND VGND VPWR VPWR sky130_fd_sc_hd__decap_3
XFILLER_20_667 VGND VGND VPWR VPWR sky130_fd_sc_hd__decap_3
XFILLER_22_29 VGND VGND VPWR VPWR sky130_fd_sc_hd__decap_3
X_6564_ _6563_/X _6564_/B _6564_/C VGND VGND VPWR VPWR _6565_/B sky130_fd_sc_hd__and3b_2
XTAP_TAPCELL_ROW_30_651 VGND VPWR sky130_fd_sc_hd__tapvpwrvgnd_1
X_8303_ _8385_/CLK _8303_/D VGND VGND VPWR VPWR _8303_/Q sky130_fd_sc_hd__dfxtp_2
X_6495_ _6334_/A _6489_/Y _6494_/Y _5614_/X VGND VGND VPWR VPWR _6495_/X sky130_fd_sc_hd__o22a_2
X_5515_ _6707_/S _5515_/B VGND VGND VPWR VPWR _5515_/X sky130_fd_sc_hd__and2b_2
XFILLER_105_205 VGND VGND VPWR VPWR sky130_fd_sc_hd__decap_3
X_8234_ clkload6/A _8234_/D VGND VGND VPWR VPWR _8234_/Q sky130_fd_sc_hd__dfxtp_2
X_5446_ _5440_/X _5442_/X _5445_/X _6648_/A VGND VGND VPWR VPWR _5447_/B sky130_fd_sc_hd__o2bb2ai_2
XFILLER_87_601 VGND VGND VPWR VPWR sky130_fd_sc_hd__fill_1
X_8165_ clkload3/A _8165_/D VGND VGND VPWR VPWR _8165_/Q sky130_fd_sc_hd__dfxtp_2
X_5377_ _8166_/Q _7809_/A1 _6095_/A _7783_/B _7805_/A _7783_/A VGND VGND VPWR VPWR
+ _5377_/X sky130_fd_sc_hd__mux4_2
XFILLER_101_422 VGND VGND VPWR VPWR sky130_fd_sc_hd__decap_3
XFILLER_113_260 VGND VGND VPWR VPWR sky130_fd_sc_hd__fill_1
XFILLER_59_314 VGND VGND VPWR VPWR sky130_fd_sc_hd__decap_3
XFILLER_59_325 VGND VGND VPWR VPWR sky130_fd_sc_hd__decap_3
XFILLER_86_100 VGND VGND VPWR VPWR sky130_fd_sc_hd__fill_1
XFILLER_87_634 VGND VGND VPWR VPWR sky130_fd_sc_hd__decap_3
XFILLER_99_494 VGND VGND VPWR VPWR sky130_fd_sc_hd__decap_3
X_8096_ clkload8/A _8096_/D VGND VGND VPWR VPWR _8096_/Q sky130_fd_sc_hd__dfxtp_2
X_7116_ _7193_/A _5987_/Y _7115_/Y _5983_/X VGND VGND VPWR VPWR _7119_/C sky130_fd_sc_hd__a22o_2
X_4328_ _7898_/B _4328_/B VGND VGND VPWR VPWR _4329_/A sky130_fd_sc_hd__and2_2
XFILLER_101_466 VGND VGND VPWR VPWR sky130_fd_sc_hd__decap_3
XFILLER_47_37 VGND VGND VPWR VPWR sky130_fd_sc_hd__decap_3
XFILLER_74_306 VGND VGND VPWR VPWR sky130_fd_sc_hd__fill_2
XFILLER_86_155 VGND VGND VPWR VPWR sky130_fd_sc_hd__decap_3
X_7047_ _7044_/B _7012_/B _7046_/X VGND VGND VPWR VPWR _7047_/Y sky130_fd_sc_hd__o21ai_2
X_4259_ _4259_/A VGND VGND VPWR VPWR _8067_/D sky130_fd_sc_hd__buf_1
XFILLER_27_200 VGND VGND VPWR VPWR sky130_fd_sc_hd__decap_3
XFILLER_28_701 VGND VGND VPWR VPWR sky130_fd_sc_hd__decap_3
XFILLER_74_339 VGND VGND VPWR VPWR sky130_fd_sc_hd__decap_3
XFILLER_86_177 VGND VGND VPWR VPWR sky130_fd_sc_hd__decap_3
XFILLER_67_391 VGND VGND VPWR VPWR sky130_fd_sc_hd__fill_1
XFILLER_15_406 VGND VGND VPWR VPWR sky130_fd_sc_hd__decap_3
XFILLER_27_266 VGND VGND VPWR VPWR sky130_fd_sc_hd__decap_3
XFILLER_42_203 VGND VGND VPWR VPWR sky130_fd_sc_hd__decap_3
XFILLER_70_501 VGND VGND VPWR VPWR sky130_fd_sc_hd__decap_3
XTAP_TAPCELL_ROW_38_751 VGND VPWR sky130_fd_sc_hd__tapvpwrvgnd_1
XFILLER_15_439 VGND VGND VPWR VPWR sky130_fd_sc_hd__fill_2
XFILLER_42_236 VGND VGND VPWR VPWR sky130_fd_sc_hd__fill_1
XFILLER_82_383 VGND VGND VPWR VPWR sky130_fd_sc_hd__decap_3
X_7949_ _8352_/CLK _7949_/D VGND VGND VPWR VPWR _7949_/Q sky130_fd_sc_hd__dfxtp_2
XFILLER_63_69 VGND VGND VPWR VPWR sky130_fd_sc_hd__decap_3
XFILLER_23_472 VGND VGND VPWR VPWR sky130_fd_sc_hd__decap_3
XFILLER_70_589 VGND VGND VPWR VPWR sky130_fd_sc_hd__decap_3
XFILLER_11_667 VGND VGND VPWR VPWR sky130_fd_sc_hd__decap_3
XFILLER_109_500 VGND VGND VPWR VPWR sky130_fd_sc_hd__decap_3
XFILLER_109_511 VGND VGND VPWR VPWR sky130_fd_sc_hd__decap_3
XFILLER_109_544 VGND VGND VPWR VPWR sky130_fd_sc_hd__decap_3
XFILLER_109_555 VGND VGND VPWR VPWR sky130_fd_sc_hd__decap_3
XFILLER_109_577 VGND VGND VPWR VPWR sky130_fd_sc_hd__decap_3
XFILLER_12_73 VGND VGND VPWR VPWR sky130_fd_sc_hd__decap_3
XFILLER_88_11 VGND VGND VPWR VPWR sky130_fd_sc_hd__fill_1
XFILLER_2_321 VGND VGND VPWR VPWR sky130_fd_sc_hd__fill_1
XFILLER_111_219 VGND VGND VPWR VPWR sky130_fd_sc_hd__decap_3
XFILLER_2_354 VGND VGND VPWR VPWR sky130_fd_sc_hd__decap_3
XFILLER_97_409 VGND VGND VPWR VPWR sky130_fd_sc_hd__decap_3
XFILLER_104_271 VGND VGND VPWR VPWR sky130_fd_sc_hd__decap_3
XFILLER_77_122 VGND VGND VPWR VPWR sky130_fd_sc_hd__decap_3
XFILLER_78_645 VGND VGND VPWR VPWR sky130_fd_sc_hd__fill_2
XFILLER_65_317 VGND VGND VPWR VPWR sky130_fd_sc_hd__decap_3
XFILLER_92_103 VGND VGND VPWR VPWR sky130_fd_sc_hd__fill_2
XFILLER_93_615 VGND VGND VPWR VPWR sky130_fd_sc_hd__fill_1
XFILLER_18_211 VGND VGND VPWR VPWR sky130_fd_sc_hd__fill_2
XFILLER_18_222 VGND VGND VPWR VPWR sky130_fd_sc_hd__decap_3
XFILLER_58_380 VGND VGND VPWR VPWR sky130_fd_sc_hd__decap_3
XFILLER_92_125 VGND VGND VPWR VPWR sky130_fd_sc_hd__decap_3
XFILLER_93_659 VGND VGND VPWR VPWR sky130_fd_sc_hd__decap_3
XFILLER_18_277 VGND VGND VPWR VPWR sky130_fd_sc_hd__decap_3
XFILLER_46_564 VGND VGND VPWR VPWR sky130_fd_sc_hd__decap_3
XFILLER_33_225 VGND VGND VPWR VPWR sky130_fd_sc_hd__decap_3
XFILLER_61_523 VGND VGND VPWR VPWR sky130_fd_sc_hd__decap_3
XFILLER_73_383 VGND VGND VPWR VPWR sky130_fd_sc_hd__decap_3
XFILLER_33_247 VGND VGND VPWR VPWR sky130_fd_sc_hd__fill_2
XFILLER_33_269 VGND VGND VPWR VPWR sky130_fd_sc_hd__fill_1
XFILLER_61_567 VGND VGND VPWR VPWR sky130_fd_sc_hd__fill_1
XFILLER_61_589 VGND VGND VPWR VPWR sky130_fd_sc_hd__decap_3
XTAP_TAPCELL_ROW_16_467 VGND VPWR sky130_fd_sc_hd__tapvpwrvgnd_1
XFILLER_14_494 VGND VGND VPWR VPWR sky130_fd_sc_hd__fill_2
XFILLER_41_291 VGND VGND VPWR VPWR sky130_fd_sc_hd__fill_1
XTAP_TAPCELL_ROW_103_1598 VGND VPWR sky130_fd_sc_hd__tapvpwrvgnd_1
XFILLER_115_503 VGND VGND VPWR VPWR sky130_fd_sc_hd__fill_1
X_5300_ _5415_/A _5700_/B VGND VGND VPWR VPWR _7613_/B sky130_fd_sc_hd__nor2_2
XTAP_TAPCELL_ROW_58_1011 VGND VPWR sky130_fd_sc_hd__tapvpwrvgnd_1
XFILLER_115_558 VGND VGND VPWR VPWR sky130_fd_sc_hd__fill_2
X_6280_ _7193_/A _6279_/X _5857_/A VGND VGND VPWR VPWR _6280_/Y sky130_fd_sc_hd__o21ai_2
X_5231_ _5229_/X _5230_/X _5451_/S VGND VGND VPWR VPWR _5231_/X sky130_fd_sc_hd__mux2_2
XFILLER_68_100 VGND VGND VPWR VPWR sky130_fd_sc_hd__decap_3
XFILLER_69_645 VGND VGND VPWR VPWR sky130_fd_sc_hd__decap_3
X_5162_ _5160_/X _5161_/X _7653_/A VGND VGND VPWR VPWR _5162_/X sky130_fd_sc_hd__mux2_2
XFILLER_96_442 VGND VGND VPWR VPWR sky130_fd_sc_hd__decap_3
X_5093_ _5338_/A VGND VGND VPWR VPWR _5093_/X sky130_fd_sc_hd__clkbuf_1
X_4113_ _4113_/A VGND VGND VPWR VPWR _7994_/D sky130_fd_sc_hd__buf_1
XFILLER_56_317 VGND VGND VPWR VPWR sky130_fd_sc_hd__decap_3
XFILLER_83_103 VGND VGND VPWR VPWR sky130_fd_sc_hd__decap_3
XFILLER_96_475 VGND VGND VPWR VPWR sky130_fd_sc_hd__fill_1
XFILLER_96_486 VGND VGND VPWR VPWR sky130_fd_sc_hd__decap_3
XFILLER_56_339 VGND VGND VPWR VPWR sky130_fd_sc_hd__decap_3
X_4044_ _7930_/B _8363_/Q VGND VGND VPWR VPWR _4045_/A sky130_fd_sc_hd__and2_2
XFILLER_83_169 VGND VGND VPWR VPWR sky130_fd_sc_hd__decap_3
XTAP_TAPCELL_ROW_69_1162 VGND VPWR sky130_fd_sc_hd__tapvpwrvgnd_1
XTAP_TAPCELL_ROW_69_1151 VGND VPWR sky130_fd_sc_hd__tapvpwrvgnd_1
XFILLER_24_203 VGND VGND VPWR VPWR sky130_fd_sc_hd__decap_3
XFILLER_24_236 VGND VGND VPWR VPWR sky130_fd_sc_hd__decap_3
XFILLER_37_586 VGND VGND VPWR VPWR sky130_fd_sc_hd__decap_3
XFILLER_92_692 VGND VGND VPWR VPWR sky130_fd_sc_hd__decap_3
X_7803_ _7812_/A _8197_/Q _7820_/B VGND VGND VPWR VPWR _7803_/X sky130_fd_sc_hd__and3_2
XTAP_TAPCELL_ROW_35_710 VGND VPWR sky130_fd_sc_hd__tapvpwrvgnd_1
X_7734_ _7776_/A _8178_/Q VGND VGND VPWR VPWR _7734_/Y sky130_fd_sc_hd__nand2_2
X_5995_ _8238_/Q _6042_/A1 _5994_/X VGND VGND VPWR VPWR _5995_/X sky130_fd_sc_hd__a21o_2
X_4946_ _8166_/Q _8230_/Q VGND VGND VPWR VPWR _4947_/B sky130_fd_sc_hd__or2_2
XFILLER_20_442 VGND VGND VPWR VPWR sky130_fd_sc_hd__decap_3
X_7665_ _8219_/Q _7660_/X _7664_/X VGND VGND VPWR VPWR _7665_/X sky130_fd_sc_hd__o21a_2
X_4877_ _6286_/A _4877_/B VGND VGND VPWR VPWR _4888_/B sky130_fd_sc_hd__or2_2
X_7596_ _7193_/A _6533_/Y _7595_/X VGND VGND VPWR VPWR _7596_/Y sky130_fd_sc_hd__a21oi_2
X_6616_ _8192_/Q _8191_/Q _7796_/A VGND VGND VPWR VPWR _6616_/X sky130_fd_sc_hd__mux2_2
X_6547_ _6769_/B _6543_/X _6546_/X _8289_/Q VGND VGND VPWR VPWR _6555_/B sky130_fd_sc_hd__a2bb2o_2
XFILLER_106_536 VGND VGND VPWR VPWR sky130_fd_sc_hd__decap_3
X_6478_ _7606_/A1 _6450_/X _6471_/X _6477_/X _7930_/B VGND VGND VPWR VPWR _8322_/D
+ sky130_fd_sc_hd__o221a_2
XFILLER_106_569 VGND VGND VPWR VPWR sky130_fd_sc_hd__decap_3
X_8217_ _8218_/CLK _8217_/D VGND VGND VPWR VPWR _8217_/Q sky130_fd_sc_hd__dfxtp_2
X_5429_ _5411_/B _5312_/B _5428_/X VGND VGND VPWR VPWR _5429_/X sky130_fd_sc_hd__o21a_2
XFILLER_58_25 VGND VGND VPWR VPWR sky130_fd_sc_hd__decap_3
XFILLER_59_111 VGND VGND VPWR VPWR sky130_fd_sc_hd__fill_1
X_8148_ _8287_/CLK _8148_/D VGND VGND VPWR VPWR _8148_/Q sky130_fd_sc_hd__dfxtp_2
XFILLER_59_122 VGND VGND VPWR VPWR sky130_fd_sc_hd__decap_3
XFILLER_101_252 VGND VGND VPWR VPWR sky130_fd_sc_hd__decap_3
XFILLER_47_306 VGND VGND VPWR VPWR sky130_fd_sc_hd__decap_3
XFILLER_59_166 VGND VGND VPWR VPWR sky130_fd_sc_hd__fill_2
XFILLER_75_615 VGND VGND VPWR VPWR sky130_fd_sc_hd__fill_1
X_8079_ _8218_/CLK _8079_/D VGND VGND VPWR VPWR _8079_/Q sky130_fd_sc_hd__dfxtp_2
XFILLER_28_531 VGND VGND VPWR VPWR sky130_fd_sc_hd__fill_1
XFILLER_74_147 VGND VGND VPWR VPWR sky130_fd_sc_hd__fill_2
XFILLER_75_648 VGND VGND VPWR VPWR sky130_fd_sc_hd__decap_3
XFILLER_16_704 VGND VGND VPWR VPWR sky130_fd_sc_hd__decap_3
XFILLER_62_309 VGND VGND VPWR VPWR sky130_fd_sc_hd__decap_3
XFILLER_74_158 VGND VGND VPWR VPWR sky130_fd_sc_hd__decap_3
XFILLER_74_35 VGND VGND VPWR VPWR sky130_fd_sc_hd__fill_1
XFILLER_74_57 VGND VGND VPWR VPWR sky130_fd_sc_hd__decap_3
XFILLER_83_670 VGND VGND VPWR VPWR sky130_fd_sc_hd__fill_2
XFILLER_90_607 VGND VGND VPWR VPWR sky130_fd_sc_hd__decap_3
XFILLER_15_225 VGND VGND VPWR VPWR sky130_fd_sc_hd__decap_3
XFILLER_15_258 VGND VGND VPWR VPWR sky130_fd_sc_hd__decap_3
XFILLER_82_191 VGND VGND VPWR VPWR sky130_fd_sc_hd__decap_3
XFILLER_30_206 VGND VGND VPWR VPWR sky130_fd_sc_hd__decap_3
XFILLER_31_729 VGND VGND VPWR VPWR sky130_fd_sc_hd__decap_3
XFILLER_90_23 VGND VGND VPWR VPWR sky130_fd_sc_hd__decap_3
XFILLER_90_56 VGND VGND VPWR VPWR sky130_fd_sc_hd__decap_3
XTAP_TAPCELL_ROW_13_426 VGND VPWR sky130_fd_sc_hd__tapvpwrvgnd_1
XFILLER_7_402 VGND VGND VPWR VPWR sky130_fd_sc_hd__fill_1
XFILLER_7_413 VGND VGND VPWR VPWR sky130_fd_sc_hd__decap_3
XFILLER_23_83 VGND VGND VPWR VPWR sky130_fd_sc_hd__decap_3
XTAP_TAPCELL_ROW_96_1509 VGND VPWR sky130_fd_sc_hd__tapvpwrvgnd_1
XFILLER_109_352 VGND VGND VPWR VPWR sky130_fd_sc_hd__decap_3
XFILLER_99_32 VGND VGND VPWR VPWR sky130_fd_sc_hd__decap_3
XFILLER_109_385 VGND VGND VPWR VPWR sky130_fd_sc_hd__decap_3
XFILLER_109_396 VGND VGND VPWR VPWR sky130_fd_sc_hd__decap_3
XFILLER_99_98 VGND VGND VPWR VPWR sky130_fd_sc_hd__decap_3
XFILLER_3_641 VGND VGND VPWR VPWR sky130_fd_sc_hd__decap_3
XFILLER_105_580 VGND VGND VPWR VPWR sky130_fd_sc_hd__decap_3
XFILLER_2_162 VGND VGND VPWR VPWR sky130_fd_sc_hd__decap_3
XFILLER_3_685 VGND VGND VPWR VPWR sky130_fd_sc_hd__decap_3
XFILLER_97_228 VGND VGND VPWR VPWR sky130_fd_sc_hd__decap_3
XFILLER_66_604 VGND VGND VPWR VPWR sky130_fd_sc_hd__fill_1
XFILLER_66_626 VGND VGND VPWR VPWR sky130_fd_sc_hd__decap_3
XFILLER_19_520 VGND VGND VPWR VPWR sky130_fd_sc_hd__fill_1
XFILLER_65_125 VGND VGND VPWR VPWR sky130_fd_sc_hd__decap_3
XFILLER_66_659 VGND VGND VPWR VPWR sky130_fd_sc_hd__decap_3
XFILLER_93_434 VGND VGND VPWR VPWR sky130_fd_sc_hd__decap_3
XFILLER_0_21 VGND VGND VPWR VPWR sky130_fd_sc_hd__decap_3
XFILLER_0_32 VGND VGND VPWR VPWR sky130_fd_sc_hd__decap_3
XFILLER_19_564 VGND VGND VPWR VPWR sky130_fd_sc_hd__decap_3
XFILLER_46_361 VGND VGND VPWR VPWR sky130_fd_sc_hd__decap_3
XFILLER_65_158 VGND VGND VPWR VPWR sky130_fd_sc_hd__decap_3
XFILLER_65_169 VGND VGND VPWR VPWR sky130_fd_sc_hd__decap_3
XFILLER_93_467 VGND VGND VPWR VPWR sky130_fd_sc_hd__decap_3
XTAP_TAPCELL_ROW_105_1627 VGND VPWR sky130_fd_sc_hd__tapvpwrvgnd_1
X_4800_ _8271_/Q _8207_/Q VGND VGND VPWR VPWR _5061_/A sky130_fd_sc_hd__and2b_2
XFILLER_21_206 VGND VGND VPWR VPWR sky130_fd_sc_hd__decap_3
XFILLER_21_217 VGND VGND VPWR VPWR sky130_fd_sc_hd__decap_3
XFILLER_21_228 VGND VGND VPWR VPWR sky130_fd_sc_hd__decap_3
XFILLER_61_375 VGND VGND VPWR VPWR sky130_fd_sc_hd__decap_3
X_5780_ _5943_/B _5943_/A _5780_/S VGND VGND VPWR VPWR _5780_/X sky130_fd_sc_hd__mux2_2
X_4731_ _8220_/Q _7582_/B VGND VGND VPWR VPWR _4733_/A sky130_fd_sc_hd__or2_2
XTAP_TAPCELL_ROW_64_1092 VGND VPWR sky130_fd_sc_hd__tapvpwrvgnd_1
X_7450_ _6921_/X _7449_/X _6647_/X _7200_/X _6070_/A _6507_/S VGND VGND VPWR VPWR
+ _7450_/X sky130_fd_sc_hd__mux4_2
X_4662_ _7930_/B _8135_/Q VGND VGND VPWR VPWR _4663_/A sky130_fd_sc_hd__and2_2
X_6401_ _6393_/A _6399_/Y _6395_/B _6138_/X _6400_/X VGND VGND VPWR VPWR _6401_/X
+ sky130_fd_sc_hd__o221a_2
XFILLER_115_300 VGND VGND VPWR VPWR sky130_fd_sc_hd__decap_3
X_7381_ _5492_/Y _5293_/Y _8215_/Q VGND VGND VPWR VPWR _7381_/X sky130_fd_sc_hd__mux2_2
X_4593_ _4593_/A VGND VGND VPWR VPWR _8234_/D sky130_fd_sc_hd__buf_1
XFILLER_115_322 VGND VGND VPWR VPWR sky130_fd_sc_hd__decap_3
XFILLER_115_333 VGND VGND VPWR VPWR sky130_fd_sc_hd__decap_3
XTAP_TAPCELL_ROW_116_1767 VGND VPWR sky130_fd_sc_hd__tapvpwrvgnd_1
X_6332_ _7305_/A1 _6304_/Y _6331_/X _7930_/B VGND VGND VPWR VPWR _8318_/D sky130_fd_sc_hd__o211a_2
XFILLER_115_355 VGND VGND VPWR VPWR sky130_fd_sc_hd__decap_3
XFILLER_115_366 VGND VGND VPWR VPWR sky130_fd_sc_hd__decap_3
XFILLER_88_206 VGND VGND VPWR VPWR sky130_fd_sc_hd__decap_3
XFILLER_89_707 VGND VGND VPWR VPWR sky130_fd_sc_hd__fill_1
XFILLER_89_729 VGND VGND VPWR VPWR sky130_fd_sc_hd__decap_3
X_6263_ _6462_/A _6260_/X _6262_/X VGND VGND VPWR VPWR _6263_/Y sky130_fd_sc_hd__o21ai_2
XFILLER_115_388 VGND VGND VPWR VPWR sky130_fd_sc_hd__decap_3
X_8002_ _8398_/CLK _8002_/D VGND VGND VPWR VPWR _8002_/Q sky130_fd_sc_hd__dfxtp_2
X_5214_ _8209_/Q _8210_/Q _6380_/S VGND VGND VPWR VPWR _5214_/X sky130_fd_sc_hd__mux2_2
XFILLER_69_431 VGND VGND VPWR VPWR sky130_fd_sc_hd__decap_3
X_6194_ _8180_/Q _6194_/B VGND VGND VPWR VPWR _6232_/B sky130_fd_sc_hd__nor2_4
XFILLER_111_561 VGND VGND VPWR VPWR sky130_fd_sc_hd__decap_3
XFILLER_29_317 VGND VGND VPWR VPWR sky130_fd_sc_hd__fill_2
XFILLER_29_328 VGND VGND VPWR VPWR sky130_fd_sc_hd__decap_3
XFILLER_56_103 VGND VGND VPWR VPWR sky130_fd_sc_hd__decap_3
XFILLER_69_464 VGND VGND VPWR VPWR sky130_fd_sc_hd__decap_3
X_5145_ _8194_/Q _8195_/Q _5484_/S VGND VGND VPWR VPWR _5145_/X sky130_fd_sc_hd__mux2_2
XFILLER_56_147 VGND VGND VPWR VPWR sky130_fd_sc_hd__decap_3
XFILLER_69_497 VGND VGND VPWR VPWR sky130_fd_sc_hd__decap_3
XFILLER_84_434 VGND VGND VPWR VPWR sky130_fd_sc_hd__decap_3
XFILLER_84_456 VGND VGND VPWR VPWR sky130_fd_sc_hd__fill_1
X_5076_ _7631_/B _6763_/A VGND VGND VPWR VPWR _5076_/Y sky130_fd_sc_hd__nand2_2
XFILLER_44_309 VGND VGND VPWR VPWR sky130_fd_sc_hd__decap_3
X_4027_ _8300_/Q _8303_/Q _8302_/Q _8307_/Q VGND VGND VPWR VPWR _4031_/A sky130_fd_sc_hd__or4_2
XFILLER_65_670 VGND VGND VPWR VPWR sky130_fd_sc_hd__fill_2
XFILLER_65_681 VGND VGND VPWR VPWR sky130_fd_sc_hd__decap_3
XFILLER_71_139 VGND VGND VPWR VPWR sky130_fd_sc_hd__decap_3
XFILLER_52_353 VGND VGND VPWR VPWR sky130_fd_sc_hd__decap_3
XFILLER_64_191 VGND VGND VPWR VPWR sky130_fd_sc_hd__decap_3
XFILLER_80_651 VGND VGND VPWR VPWR sky130_fd_sc_hd__decap_3
XFILLER_12_217 VGND VGND VPWR VPWR sky130_fd_sc_hd__decap_3
XFILLER_13_729 VGND VGND VPWR VPWR sky130_fd_sc_hd__decap_3
XFILLER_40_526 VGND VGND VPWR VPWR sky130_fd_sc_hd__decap_3
XFILLER_52_386 VGND VGND VPWR VPWR sky130_fd_sc_hd__decap_3
X_5978_ _8290_/Q _5974_/X _5976_/X _5812_/A _5977_/Y VGND VGND VPWR VPWR _5978_/X
+ sky130_fd_sc_hd__a221o_2
XFILLER_12_239 VGND VGND VPWR VPWR sky130_fd_sc_hd__decap_3
XFILLER_40_559 VGND VGND VPWR VPWR sky130_fd_sc_hd__decap_3
X_7717_ _6380_/S _8210_/Q _5579_/S VGND VGND VPWR VPWR _7717_/Y sky130_fd_sc_hd__a21oi_2
X_4929_ _4929_/A VGND VGND VPWR VPWR _5876_/A sky130_fd_sc_hd__buf_1
X_7648_ _7648_/A VGND VGND VPWR VPWR _7648_/Y sky130_fd_sc_hd__inv_2
XFILLER_60_59 VGND VGND VPWR VPWR sky130_fd_sc_hd__decap_3
XFILLER_109_20 VGND VGND VPWR VPWR sky130_fd_sc_hd__decap_3
XFILLER_4_416 VGND VGND VPWR VPWR sky130_fd_sc_hd__decap_3
X_7579_ _7579_/A _7579_/B _7579_/C _7579_/D VGND VGND VPWR VPWR _7579_/X sky130_fd_sc_hd__and4_4
XFILLER_119_694 VGND VGND VPWR VPWR sky130_fd_sc_hd__decap_3
XFILLER_106_355 VGND VGND VPWR VPWR sky130_fd_sc_hd__decap_3
XFILLER_109_97 VGND VGND VPWR VPWR sky130_fd_sc_hd__decap_3
XFILLER_69_57 VGND VGND VPWR VPWR sky130_fd_sc_hd__decap_3
XFILLER_79_217 VGND VGND VPWR VPWR sky130_fd_sc_hd__decap_3
XFILLER_79_228 VGND VGND VPWR VPWR sky130_fd_sc_hd__decap_3
XTAP_TAPCELL_ROW_91_1439 VGND VPWR sky130_fd_sc_hd__tapvpwrvgnd_1
XFILLER_102_561 VGND VGND VPWR VPWR sky130_fd_sc_hd__decap_3
XFILLER_85_23 VGND VGND VPWR VPWR sky130_fd_sc_hd__decap_3
XFILLER_48_648 VGND VGND VPWR VPWR sky130_fd_sc_hd__decap_3
XFILLER_75_423 VGND VGND VPWR VPWR sky130_fd_sc_hd__decap_3
XFILLER_75_445 VGND VGND VPWR VPWR sky130_fd_sc_hd__decap_3
XFILLER_85_45 VGND VGND VPWR VPWR sky130_fd_sc_hd__fill_2
XFILLER_18_61 VGND VGND VPWR VPWR sky130_fd_sc_hd__decap_3
XFILLER_28_350 VGND VGND VPWR VPWR sky130_fd_sc_hd__decap_3
XFILLER_47_169 VGND VGND VPWR VPWR sky130_fd_sc_hd__decap_3
XFILLER_75_467 VGND VGND VPWR VPWR sky130_fd_sc_hd__decap_3
XFILLER_85_78 VGND VGND VPWR VPWR sky130_fd_sc_hd__decap_3
XFILLER_90_404 VGND VGND VPWR VPWR sky130_fd_sc_hd__decap_3
XFILLER_16_512 VGND VGND VPWR VPWR sky130_fd_sc_hd__decap_3
XFILLER_28_383 VGND VGND VPWR VPWR sky130_fd_sc_hd__decap_3
XFILLER_62_106 VGND VGND VPWR VPWR sky130_fd_sc_hd__decap_3
XFILLER_62_139 VGND VGND VPWR VPWR sky130_fd_sc_hd__fill_1
XFILLER_90_448 VGND VGND VPWR VPWR sky130_fd_sc_hd__decap_3
XFILLER_43_331 VGND VGND VPWR VPWR sky130_fd_sc_hd__decap_3
XFILLER_16_578 VGND VGND VPWR VPWR sky130_fd_sc_hd__decap_3
XFILLER_43_364 VGND VGND VPWR VPWR sky130_fd_sc_hd__decap_3
XFILLER_70_150 VGND VGND VPWR VPWR sky130_fd_sc_hd__decap_3
XFILLER_71_673 VGND VGND VPWR VPWR sky130_fd_sc_hd__decap_3
XFILLER_31_548 VGND VGND VPWR VPWR sky130_fd_sc_hd__decap_3
XFILLER_70_183 VGND VGND VPWR VPWR sky130_fd_sc_hd__decap_3
XTAP_TAPCELL_ROW_26_595 VGND VPWR sky130_fd_sc_hd__tapvpwrvgnd_1
XFILLER_8_722 VGND VGND VPWR VPWR sky130_fd_sc_hd__decap_3
XTAP_TAPCELL_ROW_100_1557 VGND VPWR sky130_fd_sc_hd__tapvpwrvgnd_1
XFILLER_11_261 VGND VGND VPWR VPWR sky130_fd_sc_hd__decap_3
XFILLER_7_232 VGND VGND VPWR VPWR sky130_fd_sc_hd__fill_2
XFILLER_50_81 VGND VGND VPWR VPWR sky130_fd_sc_hd__decap_3
XFILLER_109_193 VGND VGND VPWR VPWR sky130_fd_sc_hd__decap_3
XFILLER_112_358 VGND VGND VPWR VPWR sky130_fd_sc_hd__decap_3
XFILLER_39_615 VGND VGND VPWR VPWR sky130_fd_sc_hd__fill_1
XFILLER_39_626 VGND VGND VPWR VPWR sky130_fd_sc_hd__decap_3
XFILLER_66_412 VGND VGND VPWR VPWR sky130_fd_sc_hd__decap_3
XFILLER_85_209 VGND VGND VPWR VPWR sky130_fd_sc_hd__decap_3
XTAP_TAPCELL_ROW_111_1697 VGND VPWR sky130_fd_sc_hd__tapvpwrvgnd_1
XFILLER_38_125 VGND VGND VPWR VPWR sky130_fd_sc_hd__decap_3
XFILLER_93_231 VGND VGND VPWR VPWR sky130_fd_sc_hd__decap_3
XFILLER_94_732 VGND VGND VPWR VPWR sky130_fd_sc_hd__fill_1
XFILLER_26_309 VGND VGND VPWR VPWR sky130_fd_sc_hd__decap_3
XFILLER_38_147 VGND VGND VPWR VPWR sky130_fd_sc_hd__fill_1
XFILLER_54_618 VGND VGND VPWR VPWR sky130_fd_sc_hd__decap_3
XFILLER_54_629 VGND VGND VPWR VPWR sky130_fd_sc_hd__decap_3
X_6950_ _6949_/X _6889_/X _6816_/X _6741_/X _7812_/A _7670_/A VGND VGND VPWR VPWR
+ _6950_/X sky130_fd_sc_hd__mux4_2
XFILLER_53_139 VGND VGND VPWR VPWR sky130_fd_sc_hd__decap_3
XFILLER_66_489 VGND VGND VPWR VPWR sky130_fd_sc_hd__decap_3
X_5901_ _8237_/Q _5718_/X _5399_/X _8173_/Q VGND VGND VPWR VPWR _5901_/X sky130_fd_sc_hd__o2bb2a_2
XFILLER_46_180 VGND VGND VPWR VPWR sky130_fd_sc_hd__fill_2
XFILLER_46_191 VGND VGND VPWR VPWR sky130_fd_sc_hd__decap_3
X_6881_ _6885_/A _6882_/B VGND VGND VPWR VPWR _6881_/Y sky130_fd_sc_hd__nor2_2
XTAP_TAPCELL_ROW_66_1121 VGND VPWR sky130_fd_sc_hd__tapvpwrvgnd_1
XFILLER_22_504 VGND VGND VPWR VPWR sky130_fd_sc_hd__decap_3
X_5832_ _5832_/A _5832_/B VGND VGND VPWR VPWR _5832_/X sky130_fd_sc_hd__or2_2
XFILLER_22_548 VGND VGND VPWR VPWR sky130_fd_sc_hd__decap_3
XFILLER_34_397 VGND VGND VPWR VPWR sky130_fd_sc_hd__decap_3
XFILLER_61_172 VGND VGND VPWR VPWR sky130_fd_sc_hd__decap_3
X_5763_ _7610_/B _5734_/X _5733_/X _7776_/B VGND VGND VPWR VPWR _5788_/A sky130_fd_sc_hd__o211a_2
X_7502_ _8283_/Q _5422_/A _7501_/X _8290_/Q _6642_/A VGND VGND VPWR VPWR _7502_/X
+ sky130_fd_sc_hd__a221o_2
X_4714_ _8290_/Q _6769_/B VGND VGND VPWR VPWR _5107_/B sky130_fd_sc_hd__or2_2
XFILLER_108_609 VGND VGND VPWR VPWR sky130_fd_sc_hd__fill_2
XFILLER_30_581 VGND VGND VPWR VPWR sky130_fd_sc_hd__fill_2
Xrebuffer318 _7565_/Y VGND VGND VPWR VPWR _7604_/A2 sky130_fd_sc_hd__buf_2
Xrebuffer307 rebuffer345/X VGND VGND VPWR VPWR _7559_/B sky130_fd_sc_hd__buf_6
X_5694_ _5702_/A VGND VGND VPWR VPWR _5695_/S sky130_fd_sc_hd__inv_2
XFILLER_107_119 VGND VGND VPWR VPWR sky130_fd_sc_hd__decap_3
X_7433_ _8280_/Q _7404_/B _7490_/B _7490_/D VGND VGND VPWR VPWR _7434_/B sky130_fd_sc_hd__o211ai_2
X_4645_ _4645_/A VGND VGND VPWR VPWR _8260_/D sky130_fd_sc_hd__buf_1
X_7364_ _7606_/A1 _7340_/X _7363_/X _7930_/B VGND VGND VPWR VPWR _8348_/D sky130_fd_sc_hd__o211a_2
X_4576_ _7898_/B _8092_/Q VGND VGND VPWR VPWR _4577_/A sky130_fd_sc_hd__and2_2
XFILLER_116_675 VGND VGND VPWR VPWR sky130_fd_sc_hd__decap_3
X_6315_ _6490_/A _8183_/Q _6232_/X VGND VGND VPWR VPWR _6333_/B sky130_fd_sc_hd__or3b_4
XTAP_TAPCELL_ROW_77_1261 VGND VPWR sky130_fd_sc_hd__tapvpwrvgnd_1
XFILLER_115_163 VGND VGND VPWR VPWR sky130_fd_sc_hd__decap_3
XFILLER_116_697 VGND VGND VPWR VPWR sky130_fd_sc_hd__decap_3
XFILLER_89_548 VGND VGND VPWR VPWR sky130_fd_sc_hd__decap_3
X_7295_ _6533_/A _6169_/B _5464_/A VGND VGND VPWR VPWR _7295_/X sky130_fd_sc_hd__a21o_2
XFILLER_39_38 VGND VGND VPWR VPWR sky130_fd_sc_hd__decap_3
X_6246_ _6353_/A _5607_/Y _6067_/Y VGND VGND VPWR VPWR _6246_/X sky130_fd_sc_hd__o21a_2
XFILLER_57_412 VGND VGND VPWR VPWR sky130_fd_sc_hd__decap_3
XFILLER_76_209 VGND VGND VPWR VPWR sky130_fd_sc_hd__decap_3
XFILLER_85_721 VGND VGND VPWR VPWR sky130_fd_sc_hd__fill_1
XFILLER_97_570 VGND VGND VPWR VPWR sky130_fd_sc_hd__decap_3
X_6177_ _4913_/B _6177_/A2 _6176_/X VGND VGND VPWR VPWR _6177_/X sky130_fd_sc_hd__o21a_4
XFILLER_111_391 VGND VGND VPWR VPWR sky130_fd_sc_hd__fill_1
XFILLER_29_125 VGND VGND VPWR VPWR sky130_fd_sc_hd__decap_3
XFILLER_85_732 VGND VGND VPWR VPWR sky130_fd_sc_hd__fill_1
XFILLER_97_592 VGND VGND VPWR VPWR sky130_fd_sc_hd__fill_2
X_5128_ _5365_/S VGND VGND VPWR VPWR _5444_/S sky130_fd_sc_hd__buf_1
XFILLER_29_169 VGND VGND VPWR VPWR sky130_fd_sc_hd__decap_3
XFILLER_57_467 VGND VGND VPWR VPWR sky130_fd_sc_hd__decap_3
XFILLER_84_253 VGND VGND VPWR VPWR sky130_fd_sc_hd__decap_3
XFILLER_38_670 VGND VGND VPWR VPWR sky130_fd_sc_hd__fill_1
XFILLER_55_37 VGND VGND VPWR VPWR sky130_fd_sc_hd__decap_3
XFILLER_72_415 VGND VGND VPWR VPWR sky130_fd_sc_hd__decap_3
XFILLER_84_286 VGND VGND VPWR VPWR sky130_fd_sc_hd__fill_2
X_5059_ _8270_/Q _5058_/Y _4805_/A VGND VGND VPWR VPWR _5059_/X sky130_fd_sc_hd__o21a_2
XFILLER_44_139 VGND VGND VPWR VPWR sky130_fd_sc_hd__fill_1
XFILLER_111_32 VGND VGND VPWR VPWR sky130_fd_sc_hd__decap_3
XFILLER_53_662 VGND VGND VPWR VPWR sky130_fd_sc_hd__decap_3
XFILLER_53_673 VGND VGND VPWR VPWR sky130_fd_sc_hd__decap_3
XFILLER_53_684 VGND VGND VPWR VPWR sky130_fd_sc_hd__decap_3
XFILLER_80_470 VGND VGND VPWR VPWR sky130_fd_sc_hd__decap_3
XTAP_TAPCELL_ROW_43_819 VGND VPWR sky130_fd_sc_hd__tapvpwrvgnd_1
XFILLER_40_312 VGND VGND VPWR VPWR sky130_fd_sc_hd__decap_3
XFILLER_52_194 VGND VGND VPWR VPWR sky130_fd_sc_hd__fill_2
XFILLER_71_14 VGND VGND VPWR VPWR sky130_fd_sc_hd__decap_3
XFILLER_9_508 VGND VGND VPWR VPWR sky130_fd_sc_hd__fill_1
XFILLER_71_69 VGND VGND VPWR VPWR sky130_fd_sc_hd__decap_3
XTAP_TAPCELL_ROW_23_554 VGND VPWR sky130_fd_sc_hd__tapvpwrvgnd_1
XPHY_EDGE_ROW_109_Right_109 VGND VGND VPWR VPWR sky130_fd_sc_hd__decap_3
XFILLER_5_703 VGND VGND VPWR VPWR sky130_fd_sc_hd__decap_3
Xrebuffer830 _7573_/B VGND VGND VPWR VPWR _7575_/B sky130_fd_sc_hd__buf_2
XFILLER_119_480 VGND VGND VPWR VPWR sky130_fd_sc_hd__decap_3
Xrebuffer863 _6988_/X VGND VGND VPWR VPWR _7005_/B sky130_fd_sc_hd__buf_4
XFILLER_106_141 VGND VGND VPWR VPWR sky130_fd_sc_hd__decap_3
XFILLER_107_642 VGND VGND VPWR VPWR sky130_fd_sc_hd__decap_3
XFILLER_106_174 VGND VGND VPWR VPWR sky130_fd_sc_hd__decap_3
XFILLER_4_268 VGND VGND VPWR VPWR sky130_fd_sc_hd__decap_3
XFILLER_0_430 VGND VGND VPWR VPWR sky130_fd_sc_hd__fill_1
XFILLER_76_710 VGND VGND VPWR VPWR sky130_fd_sc_hd__decap_3
XFILLER_96_66 VGND VGND VPWR VPWR sky130_fd_sc_hd__decap_3
XFILLER_0_485 VGND VGND VPWR VPWR sky130_fd_sc_hd__decap_3
XFILLER_102_380 VGND VGND VPWR VPWR sky130_fd_sc_hd__decap_3
XFILLER_88_592 VGND VGND VPWR VPWR sky130_fd_sc_hd__decap_3
XFILLER_29_93 VGND VGND VPWR VPWR sky130_fd_sc_hd__decap_3
XFILLER_48_467 VGND VGND VPWR VPWR sky130_fd_sc_hd__decap_3
XFILLER_75_231 VGND VGND VPWR VPWR sky130_fd_sc_hd__decap_3
XFILLER_75_253 VGND VGND VPWR VPWR sky130_fd_sc_hd__decap_3
XFILLER_75_264 VGND VGND VPWR VPWR sky130_fd_sc_hd__decap_3
XFILLER_35_106 VGND VGND VPWR VPWR sky130_fd_sc_hd__decap_3
XFILLER_48_489 VGND VGND VPWR VPWR sky130_fd_sc_hd__decap_3
XFILLER_63_437 VGND VGND VPWR VPWR sky130_fd_sc_hd__decap_3
XFILLER_16_342 VGND VGND VPWR VPWR sky130_fd_sc_hd__decap_3
XFILLER_28_191 VGND VGND VPWR VPWR sky130_fd_sc_hd__decap_3
XFILLER_44_651 VGND VGND VPWR VPWR sky130_fd_sc_hd__decap_3
XFILLER_16_375 VGND VGND VPWR VPWR sky130_fd_sc_hd__decap_3
XFILLER_43_150 VGND VGND VPWR VPWR sky130_fd_sc_hd__decap_3
XFILLER_90_278 VGND VGND VPWR VPWR sky130_fd_sc_hd__decap_3
XFILLER_31_312 VGND VGND VPWR VPWR sky130_fd_sc_hd__fill_2
XFILLER_43_172 VGND VGND VPWR VPWR sky130_fd_sc_hd__fill_1
XFILLER_44_695 VGND VGND VPWR VPWR sky130_fd_sc_hd__decap_3
XTAP_TAPCELL_ROW_61_1051 VGND VPWR sky130_fd_sc_hd__tapvpwrvgnd_1
XFILLER_12_592 VGND VGND VPWR VPWR sky130_fd_sc_hd__fill_1
XFILLER_8_563 VGND VGND VPWR VPWR sky130_fd_sc_hd__decap_3
XANTENNA_2 _4017_/A VGND VGND VPWR VPWR sky130_fd_sc_hd__diode_2
XFILLER_6_20 VGND VGND VPWR VPWR sky130_fd_sc_hd__fill_2
X_4430_ _7843_/A _4430_/B VGND VGND VPWR VPWR _4431_/A sky130_fd_sc_hd__and2_2
XFILLER_113_601 VGND VGND VPWR VPWR sky130_fd_sc_hd__decap_3
XTAP_TAPCELL_ROW_113_1726 VGND VPWR sky130_fd_sc_hd__tapvpwrvgnd_1
X_6100_ _6334_/A _6114_/B _6099_/Y VGND VGND VPWR VPWR _6100_/Y sky130_fd_sc_hd__o21bai_2
X_4361_ _4361_/A VGND VGND VPWR VPWR _8118_/D sky130_fd_sc_hd__buf_1
XFILLER_3_290 VGND VGND VPWR VPWR sky130_fd_sc_hd__fill_2
XFILLER_98_356 VGND VGND VPWR VPWR sky130_fd_sc_hd__decap_3
X_7080_ _8265_/Q _7078_/B _7079_/X _6880_/X VGND VGND VPWR VPWR _7080_/X sky130_fd_sc_hd__a22o_2
X_4292_ _7843_/A _4292_/B VGND VGND VPWR VPWR _4293_/A sky130_fd_sc_hd__and2_2
XFILLER_112_144 VGND VGND VPWR VPWR sky130_fd_sc_hd__decap_3
XFILLER_86_507 VGND VGND VPWR VPWR sky130_fd_sc_hd__decap_3
X_6031_ _8289_/Q _6003_/A _6030_/Y _8290_/Q VGND VGND VPWR VPWR _6031_/X sky130_fd_sc_hd__o22a_2
XFILLER_39_423 VGND VGND VPWR VPWR sky130_fd_sc_hd__decap_3
XFILLER_67_732 VGND VGND VPWR VPWR sky130_fd_sc_hd__fill_1
XTAP_TAPCELL_ROW_72_1191 VGND VPWR sky130_fd_sc_hd__tapvpwrvgnd_1
XFILLER_27_607 VGND VGND VPWR VPWR sky130_fd_sc_hd__fill_1
XFILLER_39_467 VGND VGND VPWR VPWR sky130_fd_sc_hd__decap_3
XFILLER_66_242 VGND VGND VPWR VPWR sky130_fd_sc_hd__decap_3
XFILLER_66_253 VGND VGND VPWR VPWR sky130_fd_sc_hd__decap_3
XFILLER_26_106 VGND VGND VPWR VPWR sky130_fd_sc_hd__decap_3
XFILLER_26_128 VGND VGND VPWR VPWR sky130_fd_sc_hd__decap_3
XFILLER_27_629 VGND VGND VPWR VPWR sky130_fd_sc_hd__decap_3
XFILLER_54_415 VGND VGND VPWR VPWR sky130_fd_sc_hd__decap_3
XFILLER_54_437 VGND VGND VPWR VPWR sky130_fd_sc_hd__decap_3
XFILLER_66_286 VGND VGND VPWR VPWR sky130_fd_sc_hd__decap_3
XFILLER_66_297 VGND VGND VPWR VPWR sky130_fd_sc_hd__decap_3
XFILLER_81_212 VGND VGND VPWR VPWR sky130_fd_sc_hd__decap_3
X_7982_ _8388_/CLK _7982_/D VGND VGND VPWR VPWR _7982_/Q sky130_fd_sc_hd__dfxtp_2
XFILLER_35_651 VGND VGND VPWR VPWR sky130_fd_sc_hd__decap_3
XFILLER_81_234 VGND VGND VPWR VPWR sky130_fd_sc_hd__decap_3
X_6933_ _8265_/Q _6907_/X _8201_/Q VGND VGND VPWR VPWR _6933_/X sky130_fd_sc_hd__o21a_4
XFILLER_22_301 VGND VGND VPWR VPWR sky130_fd_sc_hd__decap_3
XFILLER_35_673 VGND VGND VPWR VPWR sky130_fd_sc_hd__decap_3
XFILLER_81_267 VGND VGND VPWR VPWR sky130_fd_sc_hd__decap_3
X_6864_ _6686_/A _6861_/X _6863_/X VGND VGND VPWR VPWR _6864_/Y sky130_fd_sc_hd__a21oi_2
XFILLER_22_312 VGND VGND VPWR VPWR sky130_fd_sc_hd__decap_3
XFILLER_34_194 VGND VGND VPWR VPWR sky130_fd_sc_hd__fill_2
XFILLER_35_695 VGND VGND VPWR VPWR sky130_fd_sc_hd__decap_3
XFILLER_50_632 VGND VGND VPWR VPWR sky130_fd_sc_hd__decap_3
X_5815_ _5299_/X _5813_/X _5897_/C _6717_/A VGND VGND VPWR VPWR _5815_/X sky130_fd_sc_hd__a2bb2o_2
XFILLER_10_507 VGND VGND VPWR VPWR sky130_fd_sc_hd__decap_3
X_6795_ _6605_/A _8255_/Q _6792_/A _4842_/B VGND VGND VPWR VPWR _6795_/X sky130_fd_sc_hd__a31o_2
XFILLER_41_17 VGND VGND VPWR VPWR sky130_fd_sc_hd__fill_2
X_5746_ _6706_/S _6421_/S VGND VGND VPWR VPWR _5746_/X sky130_fd_sc_hd__or2b_2
XTAP_TAPCELL_ROW_20_524 VGND VPWR sky130_fd_sc_hd__tapvpwrvgnd_1
XTAP_TAPCELL_ROW_20_513 VGND VPWR sky130_fd_sc_hd__tapvpwrvgnd_1
XFILLER_108_417 VGND VGND VPWR VPWR sky130_fd_sc_hd__decap_3
X_5677_ _5671_/Y _5676_/Y _7135_/B VGND VGND VPWR VPWR _5677_/X sky130_fd_sc_hd__a21o_2
XFILLER_108_428 VGND VGND VPWR VPWR sky130_fd_sc_hd__decap_3
X_7416_ _7619_/A _7413_/X _7415_/X VGND VGND VPWR VPWR _7416_/X sky130_fd_sc_hd__a21o_2
X_4628_ _7930_/B _8118_/Q VGND VGND VPWR VPWR _4629_/A sky130_fd_sc_hd__and2_2
X_8396_ _8396_/CLK _8396_/D VGND VGND VPWR VPWR _8396_/Q sky130_fd_sc_hd__dfxtp_2
XFILLER_104_601 VGND VGND VPWR VPWR sky130_fd_sc_hd__decap_3
XFILLER_116_483 VGND VGND VPWR VPWR sky130_fd_sc_hd__decap_3
XFILLER_2_728 VGND VGND VPWR VPWR sky130_fd_sc_hd__decap_3
XFILLER_89_301 VGND VGND VPWR VPWR sky130_fd_sc_hd__decap_3
X_7347_ _7345_/X _7346_/X _8214_/Q VGND VGND VPWR VPWR _7347_/X sky130_fd_sc_hd__mux2_4
X_4559_ _4559_/A VGND VGND VPWR VPWR _8217_/D sky130_fd_sc_hd__buf_1
XFILLER_103_111 VGND VGND VPWR VPWR sky130_fd_sc_hd__fill_1
XFILLER_104_645 VGND VGND VPWR VPWR sky130_fd_sc_hd__decap_3
X_7278_ _8211_/Q _8275_/Q VGND VGND VPWR VPWR _7278_/X sky130_fd_sc_hd__and2_2
XFILLER_103_155 VGND VGND VPWR VPWR sky130_fd_sc_hd__decap_3
XFILLER_58_710 VGND VGND VPWR VPWR sky130_fd_sc_hd__fill_1
XFILLER_89_389 VGND VGND VPWR VPWR sky130_fd_sc_hd__decap_3
X_6229_ _6490_/A _8246_/Q VGND VGND VPWR VPWR _6229_/X sky130_fd_sc_hd__or2_2
XFILLER_103_199 VGND VGND VPWR VPWR sky130_fd_sc_hd__decap_3
XFILLER_58_732 VGND VGND VPWR VPWR sky130_fd_sc_hd__fill_1
XFILLER_57_231 VGND VGND VPWR VPWR sky130_fd_sc_hd__decap_3
XFILLER_85_551 VGND VGND VPWR VPWR sky130_fd_sc_hd__fill_1
XFILLER_72_212 VGND VGND VPWR VPWR sky130_fd_sc_hd__decap_3
XFILLER_85_573 VGND VGND VPWR VPWR sky130_fd_sc_hd__decap_3
XTAP_TAPCELL_ROW_28_624 VGND VPWR sky130_fd_sc_hd__tapvpwrvgnd_1
XFILLER_17_128 VGND VGND VPWR VPWR sky130_fd_sc_hd__fill_1
XFILLER_17_139 VGND VGND VPWR VPWR sky130_fd_sc_hd__decap_3
XFILLER_26_651 VGND VGND VPWR VPWR sky130_fd_sc_hd__decap_3
XFILLER_72_256 VGND VGND VPWR VPWR sky130_fd_sc_hd__fill_1
XFILLER_82_24 VGND VGND VPWR VPWR sky130_fd_sc_hd__decap_3
XFILLER_82_35 VGND VGND VPWR VPWR sky130_fd_sc_hd__decap_3
XTAP_TAPCELL_ROW_0_260 VGND VPWR sky130_fd_sc_hd__tapvpwrvgnd_1
XTAP_TAPCELL_ROW_56_988 VGND VPWR sky130_fd_sc_hd__tapvpwrvgnd_1
XFILLER_13_334 VGND VGND VPWR VPWR sky130_fd_sc_hd__fill_2
XFILLER_25_172 VGND VGND VPWR VPWR sky130_fd_sc_hd__decap_3
XFILLER_53_470 VGND VGND VPWR VPWR sky130_fd_sc_hd__decap_3
XFILLER_53_492 VGND VGND VPWR VPWR sky130_fd_sc_hd__decap_3
XFILLER_40_153 VGND VGND VPWR VPWR sky130_fd_sc_hd__fill_1
XFILLER_13_389 VGND VGND VPWR VPWR sky130_fd_sc_hd__decap_3
XFILLER_40_197 VGND VGND VPWR VPWR sky130_fd_sc_hd__decap_3
XFILLER_31_50 VGND VGND VPWR VPWR sky130_fd_sc_hd__decap_3
XFILLER_5_511 VGND VGND VPWR VPWR sky130_fd_sc_hd__decap_3
XFILLER_110_615 VGND VGND VPWR VPWR sky130_fd_sc_hd__decap_3
XFILLER_68_529 VGND VGND VPWR VPWR sky130_fd_sc_hd__decap_3
XFILLER_95_315 VGND VGND VPWR VPWR sky130_fd_sc_hd__decap_3
XTAP_TAPCELL_ROW_8_360 VGND VPWR sky130_fd_sc_hd__tapvpwrvgnd_1
XFILLER_0_271 VGND VGND VPWR VPWR sky130_fd_sc_hd__decap_3
XFILLER_110_648 VGND VGND VPWR VPWR sky130_fd_sc_hd__decap_3
XFILLER_49_732 VGND VGND VPWR VPWR sky130_fd_sc_hd__fill_1
XFILLER_95_337 VGND VGND VPWR VPWR sky130_fd_sc_hd__decap_3
XFILLER_48_242 VGND VGND VPWR VPWR sky130_fd_sc_hd__decap_3
XFILLER_48_253 VGND VGND VPWR VPWR sky130_fd_sc_hd__decap_3
XFILLER_76_551 VGND VGND VPWR VPWR sky130_fd_sc_hd__decap_3
XFILLER_36_415 VGND VGND VPWR VPWR sky130_fd_sc_hd__decap_3
XFILLER_48_286 VGND VGND VPWR VPWR sky130_fd_sc_hd__decap_3
XFILLER_63_201 VGND VGND VPWR VPWR sky130_fd_sc_hd__decap_3
XFILLER_76_573 VGND VGND VPWR VPWR sky130_fd_sc_hd__decap_3
XFILLER_76_595 VGND VGND VPWR VPWR sky130_fd_sc_hd__decap_3
XFILLER_36_448 VGND VGND VPWR VPWR sky130_fd_sc_hd__decap_3
XFILLER_56_91 VGND VGND VPWR VPWR sky130_fd_sc_hd__decap_3
XFILLER_63_223 VGND VGND VPWR VPWR sky130_fd_sc_hd__fill_1
XFILLER_63_234 VGND VGND VPWR VPWR sky130_fd_sc_hd__decap_3
XFILLER_16_150 VGND VGND VPWR VPWR sky130_fd_sc_hd__decap_3
XFILLER_17_673 VGND VGND VPWR VPWR sky130_fd_sc_hd__fill_1
XFILLER_51_429 VGND VGND VPWR VPWR sky130_fd_sc_hd__decap_3
XFILLER_63_267 VGND VGND VPWR VPWR sky130_fd_sc_hd__fill_2
XFILLER_91_576 VGND VGND VPWR VPWR sky130_fd_sc_hd__fill_2
XFILLER_16_183 VGND VGND VPWR VPWR sky130_fd_sc_hd__decap_3
XFILLER_32_621 VGND VGND VPWR VPWR sky130_fd_sc_hd__decap_3
XFILLER_44_492 VGND VGND VPWR VPWR sky130_fd_sc_hd__decap_3
XFILLER_32_654 VGND VGND VPWR VPWR sky130_fd_sc_hd__fill_1
XFILLER_31_175 VGND VGND VPWR VPWR sky130_fd_sc_hd__fill_2
XFILLER_32_687 VGND VGND VPWR VPWR sky130_fd_sc_hd__decap_3
X_6580_ _6578_/X _6579_/Y _6944_/A VGND VGND VPWR VPWR _6580_/Y sky130_fd_sc_hd__a21oi_2
X_5600_ _5600_/A VGND VGND VPWR VPWR _5601_/A sky130_fd_sc_hd__buf_1
XFILLER_118_704 VGND VGND VPWR VPWR sky130_fd_sc_hd__decap_3
X_5531_ _7619_/A _5561_/A _5530_/Y VGND VGND VPWR VPWR _5531_/X sky130_fd_sc_hd__a21o_2
XFILLER_8_371 VGND VGND VPWR VPWR sky130_fd_sc_hd__decap_3
X_8250_ _8365_/CLK _8250_/D VGND VGND VPWR VPWR _8250_/Q sky130_fd_sc_hd__dfxtp_2
XFILLER_105_409 VGND VGND VPWR VPWR sky130_fd_sc_hd__decap_3
XFILLER_8_393 VGND VGND VPWR VPWR sky130_fd_sc_hd__decap_3
X_7201_ _7200_/X _6921_/X _7745_/A VGND VGND VPWR VPWR _7202_/B sky130_fd_sc_hd__mux2_2
X_5462_ _6536_/A VGND VGND VPWR VPWR _5462_/X sky130_fd_sc_hd__clkbuf_1
X_8181_ clkload8/A _8181_/D VGND VGND VPWR VPWR _8181_/Q sky130_fd_sc_hd__dfxtp_4
X_5393_ _5391_/X _5392_/X _6706_/S VGND VGND VPWR VPWR _5393_/X sky130_fd_sc_hd__mux2_2
X_4413_ _4413_/A VGND VGND VPWR VPWR _8144_/D sky130_fd_sc_hd__buf_1
XTAP_TAPCELL_ROW_74_1220 VGND VPWR sky130_fd_sc_hd__tapvpwrvgnd_1
X_7132_ _8208_/Q _7132_/B VGND VGND VPWR VPWR _7132_/Y sky130_fd_sc_hd__nand2_2
X_4344_ _7898_/B _4344_/B VGND VGND VPWR VPWR _4345_/A sky130_fd_sc_hd__and2_2
XFILLER_101_604 VGND VGND VPWR VPWR sky130_fd_sc_hd__decap_3
XFILLER_59_529 VGND VGND VPWR VPWR sky130_fd_sc_hd__decap_3
XFILLER_98_153 VGND VGND VPWR VPWR sky130_fd_sc_hd__decap_3
XFILLER_99_676 VGND VGND VPWR VPWR sky130_fd_sc_hd__decap_3
X_7063_ _6109_/A _5959_/Y _7062_/Y _5955_/Y VGND VGND VPWR VPWR _7063_/X sky130_fd_sc_hd__a22o_2
XFILLER_100_114 VGND VGND VPWR VPWR sky130_fd_sc_hd__decap_3
XFILLER_101_626 VGND VGND VPWR VPWR sky130_fd_sc_hd__decap_3
XFILLER_101_648 VGND VGND VPWR VPWR sky130_fd_sc_hd__decap_3
XFILLER_86_315 VGND VGND VPWR VPWR sky130_fd_sc_hd__decap_3
XFILLER_98_197 VGND VGND VPWR VPWR sky130_fd_sc_hd__decap_3
X_6014_ _6013_/X _5680_/A _7745_/A VGND VGND VPWR VPWR _6014_/X sky130_fd_sc_hd__mux2_2
X_4275_ _4275_/A VGND VGND VPWR VPWR _8075_/D sky130_fd_sc_hd__buf_1
XFILLER_39_231 VGND VGND VPWR VPWR sky130_fd_sc_hd__fill_2
XFILLER_86_359 VGND VGND VPWR VPWR sky130_fd_sc_hd__decap_3
XFILLER_27_415 VGND VGND VPWR VPWR sky130_fd_sc_hd__decap_3
XFILLER_39_264 VGND VGND VPWR VPWR sky130_fd_sc_hd__fill_1
XFILLER_54_212 VGND VGND VPWR VPWR sky130_fd_sc_hd__decap_3
XFILLER_67_595 VGND VGND VPWR VPWR sky130_fd_sc_hd__decap_3
XFILLER_36_39 VGND VGND VPWR VPWR sky130_fd_sc_hd__decap_3
XFILLER_94_392 VGND VGND VPWR VPWR sky130_fd_sc_hd__decap_3
XFILLER_54_256 VGND VGND VPWR VPWR sky130_fd_sc_hd__decap_3
XFILLER_82_587 VGND VGND VPWR VPWR sky130_fd_sc_hd__fill_1
X_7965_ _8388_/CLK _7965_/D VGND VGND VPWR VPWR _7965_/Q sky130_fd_sc_hd__dfxtp_2
XTAP_TAPCELL_ROW_85_1360 VGND VPWR sky130_fd_sc_hd__tapvpwrvgnd_1
X_7896_ _8318_/Q _7930_/B VGND VGND VPWR VPWR _7897_/A sky130_fd_sc_hd__and2_2
X_6916_ _8201_/Q _5337_/A _5718_/A _8265_/Q VGND VGND VPWR VPWR _6916_/X sky130_fd_sc_hd__a2bb2o_2
XTAP_TAPCELL_ROW_53_947 VGND VPWR sky130_fd_sc_hd__tapvpwrvgnd_1
XFILLER_23_676 VGND VGND VPWR VPWR sky130_fd_sc_hd__decap_3
XFILLER_50_451 VGND VGND VPWR VPWR sky130_fd_sc_hd__decap_3
X_6847_ _8261_/Q _6807_/B _6829_/X _6845_/X _6852_/A VGND VGND VPWR VPWR _6847_/X
+ sky130_fd_sc_hd__o2111a_2
XFILLER_10_315 VGND VGND VPWR VPWR sky130_fd_sc_hd__fill_1
XFILLER_22_164 VGND VGND VPWR VPWR sky130_fd_sc_hd__decap_3
X_6778_ _6368_/B _6773_/X _6777_/X _6769_/A VGND VGND VPWR VPWR _6778_/X sky130_fd_sc_hd__a22o_2
XTAP_TAPCELL_ROW_33_682 VGND VPWR sky130_fd_sc_hd__tapvpwrvgnd_1
XFILLER_10_359 VGND VGND VPWR VPWR sky130_fd_sc_hd__decap_3
XFILLER_22_197 VGND VGND VPWR VPWR sky130_fd_sc_hd__decap_3
X_5729_ _6095_/A _5944_/C VGND VGND VPWR VPWR _5733_/B sky130_fd_sc_hd__nand2_2
XTAP_TAPCELL_ROW_33_693 VGND VPWR sky130_fd_sc_hd__tapvpwrvgnd_1
XFILLER_108_203 VGND VGND VPWR VPWR sky130_fd_sc_hd__decap_3
XFILLER_108_236 VGND VGND VPWR VPWR sky130_fd_sc_hd__decap_3
X_8379_ _8379_/CLK _8379_/D VGND VGND VPWR VPWR _8379_/Q sky130_fd_sc_hd__dfxtp_2
XFILLER_117_42 VGND VGND VPWR VPWR sky130_fd_sc_hd__decap_3
XFILLER_2_525 VGND VGND VPWR VPWR sky130_fd_sc_hd__decap_3
XFILLER_2_536 VGND VGND VPWR VPWR sky130_fd_sc_hd__fill_2
XFILLER_2_547 VGND VGND VPWR VPWR sky130_fd_sc_hd__decap_3
XFILLER_89_131 VGND VGND VPWR VPWR sky130_fd_sc_hd__decap_3
XFILLER_77_35 VGND VGND VPWR VPWR sky130_fd_sc_hd__decap_3
XFILLER_89_164 VGND VGND VPWR VPWR sky130_fd_sc_hd__decap_3
XFILLER_104_486 VGND VGND VPWR VPWR sky130_fd_sc_hd__fill_1
XFILLER_77_326 VGND VGND VPWR VPWR sky130_fd_sc_hd__decap_3
XFILLER_77_337 VGND VGND VPWR VPWR sky130_fd_sc_hd__decap_3
XFILLER_77_57 VGND VGND VPWR VPWR sky130_fd_sc_hd__decap_3
XFILLER_89_175 VGND VGND VPWR VPWR sky130_fd_sc_hd__decap_3
XTAP_TAPCELL_ROW_5_330 VGND VPWR sky130_fd_sc_hd__tapvpwrvgnd_1
XFILLER_77_359 VGND VGND VPWR VPWR sky130_fd_sc_hd__fill_2
XFILLER_92_307 VGND VGND VPWR VPWR sky130_fd_sc_hd__fill_1
XFILLER_100_681 VGND VGND VPWR VPWR sky130_fd_sc_hd__decap_3
XFILLER_58_595 VGND VGND VPWR VPWR sky130_fd_sc_hd__fill_2
XFILLER_93_23 VGND VGND VPWR VPWR sky130_fd_sc_hd__decap_3
XFILLER_18_437 VGND VGND VPWR VPWR sky130_fd_sc_hd__decap_3
XFILLER_45_223 VGND VGND VPWR VPWR sky130_fd_sc_hd__fill_1
XFILLER_45_234 VGND VGND VPWR VPWR sky130_fd_sc_hd__decap_3
XFILLER_73_532 VGND VGND VPWR VPWR sky130_fd_sc_hd__decap_3
XFILLER_61_705 VGND VGND VPWR VPWR sky130_fd_sc_hd__decap_3
XFILLER_73_587 VGND VGND VPWR VPWR sky130_fd_sc_hd__decap_3
XFILLER_93_78 VGND VGND VPWR VPWR sky130_fd_sc_hd__decap_3
XFILLER_14_621 VGND VGND VPWR VPWR sky130_fd_sc_hd__fill_1
XFILLER_33_429 VGND VGND VPWR VPWR sky130_fd_sc_hd__decap_3
XFILLER_26_94 VGND VGND VPWR VPWR sky130_fd_sc_hd__decap_3
XFILLER_60_259 VGND VGND VPWR VPWR sky130_fd_sc_hd__decap_3
XFILLER_13_164 VGND VGND VPWR VPWR sky130_fd_sc_hd__decap_3
XFILLER_9_113 VGND VGND VPWR VPWR sky130_fd_sc_hd__decap_3
XFILLER_41_495 VGND VGND VPWR VPWR sky130_fd_sc_hd__fill_2
XFILLER_115_707 VGND VGND VPWR VPWR sky130_fd_sc_hd__fill_1
XTAP_TAPCELL_ROW_11_398 VGND VPWR sky130_fd_sc_hd__tapvpwrvgnd_1
XFILLER_114_217 VGND VGND VPWR VPWR sky130_fd_sc_hd__decap_3
XFILLER_115_729 VGND VGND VPWR VPWR sky130_fd_sc_hd__decap_3
Xrebuffer490 _6711_/B VGND VGND VPWR VPWR _6194_/B sky130_fd_sc_hd__buf_2
XFILLER_107_291 VGND VGND VPWR VPWR sky130_fd_sc_hd__decap_3
XFILLER_47_6 VGND VGND VPWR VPWR sky130_fd_sc_hd__fill_1
XFILLER_3_21 VGND VGND VPWR VPWR sky130_fd_sc_hd__fill_2
XFILLER_68_304 VGND VGND VPWR VPWR sky130_fd_sc_hd__decap_3
XFILLER_110_412 VGND VGND VPWR VPWR sky130_fd_sc_hd__decap_3
XFILLER_3_43 VGND VGND VPWR VPWR sky130_fd_sc_hd__decap_3
XFILLER_68_315 VGND VGND VPWR VPWR sky130_fd_sc_hd__decap_3
XFILLER_96_624 VGND VGND VPWR VPWR sky130_fd_sc_hd__decap_3
XFILLER_3_87 VGND VGND VPWR VPWR sky130_fd_sc_hd__decap_3
XFILLER_95_145 VGND VGND VPWR VPWR sky130_fd_sc_hd__decap_3
XFILLER_96_657 VGND VGND VPWR VPWR sky130_fd_sc_hd__decap_3
X_4060_ _7930_/B _8371_/Q VGND VGND VPWR VPWR _4061_/A sky130_fd_sc_hd__and2_2
XFILLER_49_584 VGND VGND VPWR VPWR sky130_fd_sc_hd__decap_3
XFILLER_76_392 VGND VGND VPWR VPWR sky130_fd_sc_hd__decap_3
XFILLER_36_245 VGND VGND VPWR VPWR sky130_fd_sc_hd__decap_3
XFILLER_36_256 VGND VGND VPWR VPWR sky130_fd_sc_hd__decap_3
XFILLER_64_554 VGND VGND VPWR VPWR sky130_fd_sc_hd__decap_3
XFILLER_91_340 VGND VGND VPWR VPWR sky130_fd_sc_hd__decap_3
XTAP_TAPCELL_ROW_108_1658 VGND VPWR sky130_fd_sc_hd__tapvpwrvgnd_1
XTAP_TAPCELL_ROW_108_1669 VGND VPWR sky130_fd_sc_hd__tapvpwrvgnd_1
XFILLER_17_470 VGND VGND VPWR VPWR sky130_fd_sc_hd__decap_3
XFILLER_17_481 VGND VGND VPWR VPWR sky130_fd_sc_hd__fill_1
XFILLER_17_492 VGND VGND VPWR VPWR sky130_fd_sc_hd__fill_1
XFILLER_51_237 VGND VGND VPWR VPWR sky130_fd_sc_hd__fill_1
XFILLER_64_598 VGND VGND VPWR VPWR sky130_fd_sc_hd__decap_3
XFILLER_91_384 VGND VGND VPWR VPWR sky130_fd_sc_hd__decap_3
X_7750_ _7796_/A _8202_/Q _7670_/A VGND VGND VPWR VPWR _7750_/Y sky130_fd_sc_hd__a21oi_2
X_4962_ _5430_/A _7783_/A VGND VGND VPWR VPWR _5194_/A sky130_fd_sc_hd__nor2_2
X_7681_ _7681_/A VGND VGND VPWR VPWR _7681_/X sky130_fd_sc_hd__buf_1
X_6701_ _8259_/Q _5337_/A _5093_/X VGND VGND VPWR VPWR _6701_/X sky130_fd_sc_hd__o21a_2
X_4893_ _8245_/Q _8181_/Q VGND VGND VPWR VPWR _4893_/X sky130_fd_sc_hd__or2b_2
XTAP_TAPCELL_ROW_50_906 VGND VPWR sky130_fd_sc_hd__tapvpwrvgnd_1
X_6632_ _8256_/Q _6603_/B _6631_/X VGND VGND VPWR VPWR _6667_/A sky130_fd_sc_hd__o21a_2
XFILLER_9_680 VGND VGND VPWR VPWR sky130_fd_sc_hd__decap_3
X_6563_ _6563_/A _6563_/B _6561_/Y VGND VGND VPWR VPWR _6563_/X sky130_fd_sc_hd__or3b_2
XTAP_TAPCELL_ROW_30_652 VGND VPWR sky130_fd_sc_hd__tapvpwrvgnd_1
XFILLER_9_691 VGND VGND VPWR VPWR sky130_fd_sc_hd__fill_2
X_8302_ _8385_/CLK _8302_/D VGND VGND VPWR VPWR _8302_/Q sky130_fd_sc_hd__dfxtp_2
X_6494_ _6494_/A _6497_/C VGND VGND VPWR VPWR _6494_/Y sky130_fd_sc_hd__nor2_2
X_5514_ _5218_/X _5209_/B _7555_/S VGND VGND VPWR VPWR _5515_/B sky130_fd_sc_hd__mux2_2
XFILLER_105_217 VGND VGND VPWR VPWR sky130_fd_sc_hd__decap_3
XFILLER_118_589 VGND VGND VPWR VPWR sky130_fd_sc_hd__fill_1
X_8233_ clkload7/A _8233_/D VGND VGND VPWR VPWR _8233_/Q sky130_fd_sc_hd__dfxtp_4
X_5445_ _5443_/X _5444_/X _5579_/S VGND VGND VPWR VPWR _5445_/X sky130_fd_sc_hd__mux2_2
X_8164_ clkload3/A _8164_/D VGND VGND VPWR VPWR _8164_/Q sky130_fd_sc_hd__dfxtp_2
XFILLER_99_440 VGND VGND VPWR VPWR sky130_fd_sc_hd__fill_2
X_7115_ _7193_/A _7114_/X _6533_/A VGND VGND VPWR VPWR _7115_/Y sky130_fd_sc_hd__o21ai_2
X_5376_ _5491_/C _8163_/Q _8164_/Q _8165_/Q _7805_/A _7783_/A VGND VGND VPWR VPWR
+ _5376_/X sky130_fd_sc_hd__mux4_2
XFILLER_59_337 VGND VGND VPWR VPWR sky130_fd_sc_hd__decap_3
XFILLER_86_123 VGND VGND VPWR VPWR sky130_fd_sc_hd__decap_3
XFILLER_99_484 VGND VGND VPWR VPWR sky130_fd_sc_hd__decap_3
X_8095_ _8229_/CLK _8095_/D VGND VGND VPWR VPWR _8095_/Q sky130_fd_sc_hd__dfxtp_2
X_4327_ _4327_/A VGND VGND VPWR VPWR _8101_/D sky130_fd_sc_hd__buf_1
XFILLER_101_445 VGND VGND VPWR VPWR sky130_fd_sc_hd__decap_3
XFILLER_47_16 VGND VGND VPWR VPWR sky130_fd_sc_hd__decap_3
XFILLER_87_657 VGND VGND VPWR VPWR sky130_fd_sc_hd__decap_3
XFILLER_87_679 VGND VGND VPWR VPWR sky130_fd_sc_hd__decap_3
X_7046_ _8291_/Q _7036_/X _7041_/X _7044_/X _7045_/Y VGND VGND VPWR VPWR _7046_/X
+ sky130_fd_sc_hd__o2111a_2
X_4258_ _7898_/B _4258_/B VGND VGND VPWR VPWR _4259_/A sky130_fd_sc_hd__and2_2
XFILLER_101_478 VGND VGND VPWR VPWR sky130_fd_sc_hd__decap_3
XFILLER_47_49 VGND VGND VPWR VPWR sky130_fd_sc_hd__decap_3
XFILLER_67_370 VGND VGND VPWR VPWR sky130_fd_sc_hd__decap_3
XFILLER_74_318 VGND VGND VPWR VPWR sky130_fd_sc_hd__decap_3
XFILLER_103_22 VGND VGND VPWR VPWR sky130_fd_sc_hd__decap_3
XFILLER_27_212 VGND VGND VPWR VPWR sky130_fd_sc_hd__decap_3
XFILLER_27_234 VGND VGND VPWR VPWR sky130_fd_sc_hd__decap_3
XFILLER_55_532 VGND VGND VPWR VPWR sky130_fd_sc_hd__decap_3
X_4189_ _4189_/A VGND VGND VPWR VPWR _8032_/D sky130_fd_sc_hd__buf_1
XFILLER_55_554 VGND VGND VPWR VPWR sky130_fd_sc_hd__decap_3
XFILLER_82_340 VGND VGND VPWR VPWR sky130_fd_sc_hd__decap_3
XTAP_TAPCELL_ROW_38_752 VGND VPWR sky130_fd_sc_hd__tapvpwrvgnd_1
XFILLER_27_278 VGND VGND VPWR VPWR sky130_fd_sc_hd__fill_2
XFILLER_82_395 VGND VGND VPWR VPWR sky130_fd_sc_hd__decap_3
X_7948_ _8352_/CLK _7948_/D VGND VGND VPWR VPWR _7948_/Q sky130_fd_sc_hd__dfxtp_2
XFILLER_42_259 VGND VGND VPWR VPWR sky130_fd_sc_hd__fill_2
X_7879_ _7879_/A VGND VGND VPWR VPWR _8376_/D sky130_fd_sc_hd__buf_1
XFILLER_50_281 VGND VGND VPWR VPWR sky130_fd_sc_hd__decap_3
XFILLER_7_606 VGND VGND VPWR VPWR sky130_fd_sc_hd__decap_3
XFILLER_109_523 VGND VGND VPWR VPWR sky130_fd_sc_hd__decap_3
XFILLER_11_679 VGND VGND VPWR VPWR sky130_fd_sc_hd__decap_3
XFILLER_109_567 VGND VGND VPWR VPWR sky130_fd_sc_hd__fill_2
XFILLER_109_589 VGND VGND VPWR VPWR sky130_fd_sc_hd__decap_3
XFILLER_88_23 VGND VGND VPWR VPWR sky130_fd_sc_hd__decap_3
XFILLER_88_34 VGND VGND VPWR VPWR sky130_fd_sc_hd__fill_1
XFILLER_88_45 VGND VGND VPWR VPWR sky130_fd_sc_hd__decap_3
XFILLER_77_101 VGND VGND VPWR VPWR sky130_fd_sc_hd__fill_2
XFILLER_77_156 VGND VGND VPWR VPWR sky130_fd_sc_hd__decap_3
XFILLER_65_329 VGND VGND VPWR VPWR sky130_fd_sc_hd__decap_3
XFILLER_77_178 VGND VGND VPWR VPWR sky130_fd_sc_hd__decap_3
XFILLER_93_627 VGND VGND VPWR VPWR sky130_fd_sc_hd__decap_3
XFILLER_37_60 VGND VGND VPWR VPWR sky130_fd_sc_hd__fill_2
XFILLER_58_392 VGND VGND VPWR VPWR sky130_fd_sc_hd__decap_3
XFILLER_92_148 VGND VGND VPWR VPWR sky130_fd_sc_hd__decap_3
XFILLER_18_256 VGND VGND VPWR VPWR sky130_fd_sc_hd__decap_3
XFILLER_37_71 VGND VGND VPWR VPWR sky130_fd_sc_hd__decap_3
XFILLER_37_93 VGND VGND VPWR VPWR sky130_fd_sc_hd__fill_1
XFILLER_46_576 VGND VGND VPWR VPWR sky130_fd_sc_hd__decap_3
XFILLER_73_340 VGND VGND VPWR VPWR sky130_fd_sc_hd__decap_3
XPHY_EDGE_ROW_16_Right_16 VGND VGND VPWR VPWR sky130_fd_sc_hd__decap_3
XFILLER_18_289 VGND VGND VPWR VPWR sky130_fd_sc_hd__decap_3
XFILLER_33_204 VGND VGND VPWR VPWR sky130_fd_sc_hd__decap_3
XFILLER_61_546 VGND VGND VPWR VPWR sky130_fd_sc_hd__decap_3
XFILLER_14_462 VGND VGND VPWR VPWR sky130_fd_sc_hd__decap_3
XFILLER_53_81 VGND VGND VPWR VPWR sky130_fd_sc_hd__decap_3
XTAP_TAPCELL_ROW_16_468 VGND VPWR sky130_fd_sc_hd__tapvpwrvgnd_1
XFILLER_119_309 VGND VGND VPWR VPWR sky130_fd_sc_hd__decap_3
XTAP_TAPCELL_ROW_103_1599 VGND VPWR sky130_fd_sc_hd__tapvpwrvgnd_1
XPHY_EDGE_ROW_25_Right_25 VGND VGND VPWR VPWR sky130_fd_sc_hd__decap_3
XTAP_TAPCELL_ROW_58_1012 VGND VPWR sky130_fd_sc_hd__tapvpwrvgnd_1
XFILLER_5_160 VGND VGND VPWR VPWR sky130_fd_sc_hd__fill_2
XFILLER_5_182 VGND VGND VPWR VPWR sky130_fd_sc_hd__decap_3
XFILLER_6_683 VGND VGND VPWR VPWR sky130_fd_sc_hd__decap_3
X_5230_ _8201_/Q _8202_/Q _6380_/S VGND VGND VPWR VPWR _5230_/X sky130_fd_sc_hd__mux2_2
XFILLER_102_209 VGND VGND VPWR VPWR sky130_fd_sc_hd__decap_3
XFILLER_45_3 VGND VGND VPWR VPWR sky130_fd_sc_hd__fill_1
XFILLER_111_732 VGND VGND VPWR VPWR sky130_fd_sc_hd__fill_1
XFILLER_96_421 VGND VGND VPWR VPWR sky130_fd_sc_hd__decap_3
X_5161_ _6097_/A _8177_/Q _5484_/S VGND VGND VPWR VPWR _5161_/X sky130_fd_sc_hd__mux2_2
XFILLER_110_242 VGND VGND VPWR VPWR sky130_fd_sc_hd__decap_3
XFILLER_69_657 VGND VGND VPWR VPWR sky130_fd_sc_hd__decap_3
XFILLER_69_679 VGND VGND VPWR VPWR sky130_fd_sc_hd__decap_3
X_5092_ _5092_/A VGND VGND VPWR VPWR _5338_/A sky130_fd_sc_hd__buf_1
X_4112_ _7930_/B _8397_/Q VGND VGND VPWR VPWR _4113_/A sky130_fd_sc_hd__and2_2
XFILLER_110_253 VGND VGND VPWR VPWR sky130_fd_sc_hd__decap_3
XFILLER_56_307 VGND VGND VPWR VPWR sky130_fd_sc_hd__fill_1
X_4043_ _4043_/A VGND VGND VPWR VPWR _7959_/D sky130_fd_sc_hd__buf_1
XFILLER_110_286 VGND VGND VPWR VPWR sky130_fd_sc_hd__decap_3
XFILLER_110_297 VGND VGND VPWR VPWR sky130_fd_sc_hd__decap_3
XFILLER_49_370 VGND VGND VPWR VPWR sky130_fd_sc_hd__decap_3
XPHY_EDGE_ROW_34_Right_34 VGND VGND VPWR VPWR sky130_fd_sc_hd__decap_3
XFILLER_64_351 VGND VGND VPWR VPWR sky130_fd_sc_hd__decap_3
XTAP_TAPCELL_ROW_69_1152 VGND VPWR sky130_fd_sc_hd__tapvpwrvgnd_1
XFILLER_24_215 VGND VGND VPWR VPWR sky130_fd_sc_hd__decap_3
XFILLER_52_513 VGND VGND VPWR VPWR sky130_fd_sc_hd__decap_3
X_7802_ _7812_/A _7798_/X _7801_/X VGND VGND VPWR VPWR _7802_/Y sky130_fd_sc_hd__a21oi_2
X_5994_ _8238_/Q _6042_/A1 _7767_/B VGND VGND VPWR VPWR _5994_/X sky130_fd_sc_hd__o21ba_2
XTAP_TAPCELL_ROW_35_711 VGND VPWR sky130_fd_sc_hd__tapvpwrvgnd_1
XFILLER_24_248 VGND VGND VPWR VPWR sky130_fd_sc_hd__decap_3
X_7733_ _5363_/X _8180_/Q _7655_/A _7731_/Y _7732_/X VGND VGND VPWR VPWR _7743_/B
+ sky130_fd_sc_hd__a311o_2
X_4945_ _8166_/Q _8230_/Q VGND VGND VPWR VPWR _4947_/A sky130_fd_sc_hd__nand2_2
XTAP_TAPCELL_ROW_82_1330 VGND VPWR sky130_fd_sc_hd__tapvpwrvgnd_1
XFILLER_52_579 VGND VGND VPWR VPWR sky130_fd_sc_hd__decap_3
XFILLER_20_410 VGND VGND VPWR VPWR sky130_fd_sc_hd__decap_3
XFILLER_20_421 VGND VGND VPWR VPWR sky130_fd_sc_hd__decap_3
XFILLER_32_281 VGND VGND VPWR VPWR sky130_fd_sc_hd__decap_3
X_7664_ _7664_/A VGND VGND VPWR VPWR _7664_/X sky130_fd_sc_hd__buf_1
X_4876_ _6563_/A _4876_/B VGND VGND VPWR VPWR _4877_/B sky130_fd_sc_hd__or2_2
XFILLER_20_465 VGND VGND VPWR VPWR sky130_fd_sc_hd__decap_3
XPHY_EDGE_ROW_43_Right_43 VGND VGND VPWR VPWR sky130_fd_sc_hd__decap_3
X_7595_ _5574_/A _6355_/X _7594_/Y _6650_/B VGND VGND VPWR VPWR _7595_/X sky130_fd_sc_hd__o22a_2
X_6615_ _6008_/A _5159_/X _6819_/A VGND VGND VPWR VPWR _6615_/X sky130_fd_sc_hd__mux2_2
X_6546_ _5587_/X _6544_/X _6545_/X _5108_/X VGND VGND VPWR VPWR _6546_/X sky130_fd_sc_hd__a22o_2
XFILLER_106_515 VGND VGND VPWR VPWR sky130_fd_sc_hd__decap_3
XFILLER_116_9 VGND VGND VPWR VPWR sky130_fd_sc_hd__decap_3
XFILLER_3_108 VGND VGND VPWR VPWR sky130_fd_sc_hd__decap_3
XFILLER_106_548 VGND VGND VPWR VPWR sky130_fd_sc_hd__decap_3
XPHY_EDGE_ROW_18_Left_138 VGND VGND VPWR VPWR sky130_fd_sc_hd__decap_3
X_6477_ _6964_/A _6477_/B _6477_/C VGND VGND VPWR VPWR _6477_/X sky130_fd_sc_hd__and3_2
X_8216_ _8359_/CLK _8216_/D VGND VGND VPWR VPWR _8216_/Q sky130_fd_sc_hd__dfxtp_2
X_5428_ _5411_/B _5312_/B _6706_/S VGND VGND VPWR VPWR _5428_/X sky130_fd_sc_hd__a21o_2
XTAP_TAPCELL_ROW_93_1470 VGND VPWR sky130_fd_sc_hd__tapvpwrvgnd_1
XFILLER_99_281 VGND VGND VPWR VPWR sky130_fd_sc_hd__decap_3
X_8147_ _8287_/CLK _8147_/D VGND VGND VPWR VPWR _8147_/Q sky130_fd_sc_hd__dfxtp_2
X_5359_ _5355_/X _5358_/X _6818_/S VGND VGND VPWR VPWR _5359_/X sky130_fd_sc_hd__mux2_2
XFILLER_101_231 VGND VGND VPWR VPWR sky130_fd_sc_hd__decap_3
XFILLER_114_592 VGND VGND VPWR VPWR sky130_fd_sc_hd__decap_3
XFILLER_58_59 VGND VGND VPWR VPWR sky130_fd_sc_hd__decap_3
XFILLER_59_145 VGND VGND VPWR VPWR sky130_fd_sc_hd__decap_3
X_8078_ _8226_/CLK _8078_/D VGND VGND VPWR VPWR _8078_/Q sky130_fd_sc_hd__dfxtp_2
XFILLER_101_264 VGND VGND VPWR VPWR sky130_fd_sc_hd__fill_2
XFILLER_114_21 VGND VGND VPWR VPWR sky130_fd_sc_hd__decap_3
XFILLER_114_32 VGND VGND VPWR VPWR sky130_fd_sc_hd__decap_3
XFILLER_47_318 VGND VGND VPWR VPWR sky130_fd_sc_hd__decap_3
XFILLER_87_476 VGND VGND VPWR VPWR sky130_fd_sc_hd__decap_3
XPHY_EDGE_ROW_52_Right_52 VGND VGND VPWR VPWR sky130_fd_sc_hd__decap_3
X_7029_ _7028_/B _7028_/C _7166_/A VGND VGND VPWR VPWR _7029_/Y sky130_fd_sc_hd__a21oi_2
XFILLER_59_189 VGND VGND VPWR VPWR sky130_fd_sc_hd__decap_3
XFILLER_74_115 VGND VGND VPWR VPWR sky130_fd_sc_hd__decap_3
XFILLER_114_98 VGND VGND VPWR VPWR sky130_fd_sc_hd__decap_3
XFILLER_28_554 VGND VGND VPWR VPWR sky130_fd_sc_hd__decap_3
XFILLER_28_576 VGND VGND VPWR VPWR sky130_fd_sc_hd__decap_3
XFILLER_43_502 VGND VGND VPWR VPWR sky130_fd_sc_hd__fill_2
XFILLER_90_619 VGND VGND VPWR VPWR sky130_fd_sc_hd__decap_3
XPHY_EDGE_ROW_27_Left_147 VGND VGND VPWR VPWR sky130_fd_sc_hd__decap_3
XFILLER_15_204 VGND VGND VPWR VPWR sky130_fd_sc_hd__decap_3
XFILLER_16_727 VGND VGND VPWR VPWR sky130_fd_sc_hd__decap_3
XFILLER_28_598 VGND VGND VPWR VPWR sky130_fd_sc_hd__decap_3
XFILLER_43_513 VGND VGND VPWR VPWR sky130_fd_sc_hd__fill_1
XFILLER_43_524 VGND VGND VPWR VPWR sky130_fd_sc_hd__decap_3
XFILLER_55_384 VGND VGND VPWR VPWR sky130_fd_sc_hd__decap_3
XFILLER_70_321 VGND VGND VPWR VPWR sky130_fd_sc_hd__decap_3
XFILLER_15_237 VGND VGND VPWR VPWR sky130_fd_sc_hd__decap_3
XFILLER_70_343 VGND VGND VPWR VPWR sky130_fd_sc_hd__decap_3
XFILLER_70_354 VGND VGND VPWR VPWR sky130_fd_sc_hd__decap_3
XFILLER_43_579 VGND VGND VPWR VPWR sky130_fd_sc_hd__fill_1
XFILLER_70_365 VGND VGND VPWR VPWR sky130_fd_sc_hd__decap_3
XFILLER_70_387 VGND VGND VPWR VPWR sky130_fd_sc_hd__decap_3
XFILLER_90_35 VGND VGND VPWR VPWR sky130_fd_sc_hd__decap_3
XFILLER_23_281 VGND VGND VPWR VPWR sky130_fd_sc_hd__decap_3
XFILLER_90_79 VGND VGND VPWR VPWR sky130_fd_sc_hd__decap_3
XPHY_EDGE_ROW_61_Right_61 VGND VGND VPWR VPWR sky130_fd_sc_hd__decap_3
XTAP_TAPCELL_ROW_13_427 VGND VPWR sky130_fd_sc_hd__tapvpwrvgnd_1
XFILLER_23_40 VGND VGND VPWR VPWR sky130_fd_sc_hd__decap_3
XFILLER_23_73 VGND VGND VPWR VPWR sky130_fd_sc_hd__decap_3
XFILLER_11_487 VGND VGND VPWR VPWR sky130_fd_sc_hd__decap_3
XFILLER_23_95 VGND VGND VPWR VPWR sky130_fd_sc_hd__decap_3
XFILLER_7_469 VGND VGND VPWR VPWR sky130_fd_sc_hd__decap_3
XFILLER_99_44 VGND VGND VPWR VPWR sky130_fd_sc_hd__decap_3
XPHY_EDGE_ROW_36_Left_156 VGND VGND VPWR VPWR sky130_fd_sc_hd__decap_3
XFILLER_2_141 VGND VGND VPWR VPWR sky130_fd_sc_hd__decap_3
XFILLER_2_174 VGND VGND VPWR VPWR sky130_fd_sc_hd__fill_2
XFILLER_78_410 VGND VGND VPWR VPWR sky130_fd_sc_hd__decap_3
XFILLER_78_421 VGND VGND VPWR VPWR sky130_fd_sc_hd__decap_3
XFILLER_97_218 VGND VGND VPWR VPWR sky130_fd_sc_hd__decap_3
XPHY_EDGE_ROW_70_Right_70 VGND VGND VPWR VPWR sky130_fd_sc_hd__decap_3
XFILLER_105_592 VGND VGND VPWR VPWR sky130_fd_sc_hd__decap_3
XFILLER_78_454 VGND VGND VPWR VPWR sky130_fd_sc_hd__fill_1
XFILLER_38_307 VGND VGND VPWR VPWR sky130_fd_sc_hd__fill_1
XFILLER_48_70 VGND VGND VPWR VPWR sky130_fd_sc_hd__fill_1
XFILLER_93_402 VGND VGND VPWR VPWR sky130_fd_sc_hd__decap_3
XFILLER_19_532 VGND VGND VPWR VPWR sky130_fd_sc_hd__decap_3
XFILLER_66_638 VGND VGND VPWR VPWR sky130_fd_sc_hd__decap_3
XFILLER_93_446 VGND VGND VPWR VPWR sky130_fd_sc_hd__fill_2
XPHY_EDGE_ROW_45_Left_165 VGND VGND VPWR VPWR sky130_fd_sc_hd__decap_3
XFILLER_0_44 VGND VGND VPWR VPWR sky130_fd_sc_hd__decap_3
XFILLER_74_660 VGND VGND VPWR VPWR sky130_fd_sc_hd__decap_3
XFILLER_81_608 VGND VGND VPWR VPWR sky130_fd_sc_hd__decap_3
XFILLER_93_479 VGND VGND VPWR VPWR sky130_fd_sc_hd__decap_3
Xclone279 _6353_/B VGND VGND VPWR VPWR _7745_/A sky130_fd_sc_hd__clkbuf_16
XFILLER_0_66 VGND VGND VPWR VPWR sky130_fd_sc_hd__decap_3
XFILLER_19_576 VGND VGND VPWR VPWR sky130_fd_sc_hd__fill_2
XFILLER_34_513 VGND VGND VPWR VPWR sky130_fd_sc_hd__decap_3
XFILLER_61_310 VGND VGND VPWR VPWR sky130_fd_sc_hd__decap_3
XFILLER_74_693 VGND VGND VPWR VPWR sky130_fd_sc_hd__decap_3
XFILLER_80_129 VGND VGND VPWR VPWR sky130_fd_sc_hd__decap_3
XTAP_TAPCELL_ROW_105_1628 VGND VPWR sky130_fd_sc_hd__tapvpwrvgnd_1
XFILLER_0_88 VGND VGND VPWR VPWR sky130_fd_sc_hd__decap_3
XFILLER_34_557 VGND VGND VPWR VPWR sky130_fd_sc_hd__decap_3
XFILLER_61_343 VGND VGND VPWR VPWR sky130_fd_sc_hd__decap_3
XFILLER_64_91 VGND VGND VPWR VPWR sky130_fd_sc_hd__fill_1
XFILLER_9_20 VGND VGND VPWR VPWR sky130_fd_sc_hd__fill_2
XFILLER_14_281 VGND VGND VPWR VPWR sky130_fd_sc_hd__decap_3
X_4730_ _8284_/Q VGND VGND VPWR VPWR _7582_/B sky130_fd_sc_hd__inv_2
XTAP_TAPCELL_ROW_64_1093 VGND VPWR sky130_fd_sc_hd__tapvpwrvgnd_1
X_4661_ _4661_/A VGND VGND VPWR VPWR _8268_/D sky130_fd_sc_hd__buf_1
XPHY_EDGE_ROW_54_Left_174 VGND VGND VPWR VPWR sky130_fd_sc_hd__decap_3
X_7380_ _8291_/Q _7380_/B VGND VGND VPWR VPWR _7380_/Y sky130_fd_sc_hd__nor2_2
X_6400_ _6400_/A _6400_/B _6400_/C VGND VGND VPWR VPWR _6400_/X sky130_fd_sc_hd__and3_2
XTAP_TAPCELL_ROW_40_780 VGND VPWR sky130_fd_sc_hd__tapvpwrvgnd_1
X_6331_ _6307_/Y _6964_/A _6314_/X _6319_/X _6330_/Y VGND VGND VPWR VPWR _6331_/X
+ sky130_fd_sc_hd__a2111o_2
X_4592_ _7898_/B _8100_/Q VGND VGND VPWR VPWR _4593_/A sky130_fd_sc_hd__and2_2
XTAP_TAPCELL_ROW_116_1768 VGND VPWR sky130_fd_sc_hd__tapvpwrvgnd_1
X_6262_ _8288_/Q _5041_/Y _6261_/X _5337_/A _4900_/B VGND VGND VPWR VPWR _6262_/X
+ sky130_fd_sc_hd__o32a_2
X_8001_ _8401_/CLK _8001_/D VGND VGND VPWR VPWR _8001_/Q sky130_fd_sc_hd__dfxtp_2
X_6193_ _6825_/A _6825_/B VGND VGND VPWR VPWR _6548_/C sky130_fd_sc_hd__nor2_2
X_5213_ _8211_/Q _8212_/Q _6380_/S VGND VGND VPWR VPWR _5213_/X sky130_fd_sc_hd__mux2_2
XFILLER_111_540 VGND VGND VPWR VPWR sky130_fd_sc_hd__decap_3
X_5144_ _5136_/X _5673_/A _6421_/S VGND VGND VPWR VPWR _6008_/A sky130_fd_sc_hd__mux2_2
XFILLER_28_29 VGND VGND VPWR VPWR sky130_fd_sc_hd__decap_3
XFILLER_69_476 VGND VGND VPWR VPWR sky130_fd_sc_hd__decap_3
XFILLER_96_251 VGND VGND VPWR VPWR sky130_fd_sc_hd__fill_1
XFILLER_96_262 VGND VGND VPWR VPWR sky130_fd_sc_hd__decap_3
XPHY_EDGE_ROW_63_Left_183 VGND VGND VPWR VPWR sky130_fd_sc_hd__decap_3
XFILLER_111_584 VGND VGND VPWR VPWR sky130_fd_sc_hd__decap_3
XFILLER_56_115 VGND VGND VPWR VPWR sky130_fd_sc_hd__decap_3
X_5075_ _5077_/A VGND VGND VPWR VPWR _6763_/A sky130_fd_sc_hd__buf_1
XFILLER_37_351 VGND VGND VPWR VPWR sky130_fd_sc_hd__fill_2
XFILLER_56_159 VGND VGND VPWR VPWR sky130_fd_sc_hd__decap_3
XFILLER_72_608 VGND VGND VPWR VPWR sky130_fd_sc_hd__decap_3
X_4026_ _4026_/A _4026_/B _4026_/C _4026_/D VGND VGND VPWR VPWR _4032_/C sky130_fd_sc_hd__or4_2
XFILLER_25_502 VGND VGND VPWR VPWR sky130_fd_sc_hd__fill_2
XFILLER_37_373 VGND VGND VPWR VPWR sky130_fd_sc_hd__decap_3
XTAP_TAPCELL_ROW_48_880 VGND VPWR sky130_fd_sc_hd__tapvpwrvgnd_1
XFILLER_25_535 VGND VGND VPWR VPWR sky130_fd_sc_hd__decap_3
XFILLER_80_630 VGND VGND VPWR VPWR sky130_fd_sc_hd__decap_3
XFILLER_40_505 VGND VGND VPWR VPWR sky130_fd_sc_hd__decap_3
X_5977_ _5977_/A _5977_/B VGND VGND VPWR VPWR _5977_/Y sky130_fd_sc_hd__nor2_2
XFILLER_100_45 VGND VGND VPWR VPWR sky130_fd_sc_hd__decap_3
XFILLER_52_398 VGND VGND VPWR VPWR sky130_fd_sc_hd__decap_3
X_7716_ _8211_/Q _7660_/X _7664_/X VGND VGND VPWR VPWR _7716_/X sky130_fd_sc_hd__o21a_2
X_4928_ _4928_/A _4928_/B VGND VGND VPWR VPWR _4929_/A sky130_fd_sc_hd__or2_2
XFILLER_20_251 VGND VGND VPWR VPWR sky130_fd_sc_hd__fill_1
XPHY_EDGE_ROW_72_Left_192 VGND VGND VPWR VPWR sky130_fd_sc_hd__decap_3
X_7647_ _8222_/Q _7645_/X _7646_/Y _6148_/X VGND VGND VPWR VPWR _7831_/C sky130_fd_sc_hd__o22a_4
X_4859_ _6486_/A VGND VGND VPWR VPWR _6592_/A sky130_fd_sc_hd__inv_2
XFILLER_114_6 VGND VGND VPWR VPWR sky130_fd_sc_hd__decap_3
XFILLER_119_651 VGND VGND VPWR VPWR sky130_fd_sc_hd__decap_3
XFILLER_119_673 VGND VGND VPWR VPWR sky130_fd_sc_hd__decap_3
XFILLER_20_295 VGND VGND VPWR VPWR sky130_fd_sc_hd__fill_1
X_7578_ _7578_/A _7578_/B VGND VGND VPWR VPWR _7579_/D sky130_fd_sc_hd__and2_2
XFILLER_106_312 VGND VGND VPWR VPWR sky130_fd_sc_hd__fill_1
X_6529_ _6529_/A VGND VGND VPWR VPWR _6533_/A sky130_fd_sc_hd__buf_1
XFILLER_106_334 VGND VGND VPWR VPWR sky130_fd_sc_hd__decap_3
XFILLER_106_389 VGND VGND VPWR VPWR sky130_fd_sc_hd__fill_2
XFILLER_0_656 VGND VGND VPWR VPWR sky130_fd_sc_hd__decap_3
XFILLER_88_730 VGND VGND VPWR VPWR sky130_fd_sc_hd__decap_3
XFILLER_48_627 VGND VGND VPWR VPWR sky130_fd_sc_hd__decap_3
XFILLER_75_402 VGND VGND VPWR VPWR sky130_fd_sc_hd__decap_3
XFILLER_102_584 VGND VGND VPWR VPWR sky130_fd_sc_hd__decap_3
XFILLER_102_595 VGND VGND VPWR VPWR sky130_fd_sc_hd__decap_3
XFILLER_47_137 VGND VGND VPWR VPWR sky130_fd_sc_hd__decap_3
XFILLER_85_57 VGND VGND VPWR VPWR sky130_fd_sc_hd__decap_3
XFILLER_87_284 VGND VGND VPWR VPWR sky130_fd_sc_hd__decap_3
XFILLER_56_660 VGND VGND VPWR VPWR sky130_fd_sc_hd__fill_2
XFILLER_16_524 VGND VGND VPWR VPWR sky130_fd_sc_hd__decap_3
XFILLER_28_362 VGND VGND VPWR VPWR sky130_fd_sc_hd__fill_2
XFILLER_43_310 VGND VGND VPWR VPWR sky130_fd_sc_hd__decap_3
XFILLER_62_118 VGND VGND VPWR VPWR sky130_fd_sc_hd__decap_3
XFILLER_90_416 VGND VGND VPWR VPWR sky130_fd_sc_hd__decap_3
XFILLER_16_557 VGND VGND VPWR VPWR sky130_fd_sc_hd__decap_3
XFILLER_28_395 VGND VGND VPWR VPWR sky130_fd_sc_hd__decap_3
XFILLER_43_343 VGND VGND VPWR VPWR sky130_fd_sc_hd__decap_3
XFILLER_55_192 VGND VGND VPWR VPWR sky130_fd_sc_hd__fill_2
XFILLER_31_505 VGND VGND VPWR VPWR sky130_fd_sc_hd__fill_1
XFILLER_43_376 VGND VGND VPWR VPWR sky130_fd_sc_hd__decap_3
XFILLER_12_730 VGND VGND VPWR VPWR sky130_fd_sc_hd__decap_3
XFILLER_34_72 VGND VGND VPWR VPWR sky130_fd_sc_hd__fill_2
XFILLER_70_195 VGND VGND VPWR VPWR sky130_fd_sc_hd__fill_1
XTAP_TAPCELL_ROW_26_596 VGND VPWR sky130_fd_sc_hd__tapvpwrvgnd_1
XFILLER_11_240 VGND VGND VPWR VPWR sky130_fd_sc_hd__decap_3
XFILLER_34_83 VGND VGND VPWR VPWR sky130_fd_sc_hd__fill_1
XFILLER_8_701 VGND VGND VPWR VPWR sky130_fd_sc_hd__decap_3
XTAP_TAPCELL_ROW_100_1558 VGND VPWR sky130_fd_sc_hd__tapvpwrvgnd_1
XFILLER_11_284 VGND VGND VPWR VPWR sky130_fd_sc_hd__decap_3
XFILLER_7_266 VGND VGND VPWR VPWR sky130_fd_sc_hd__fill_2
XFILLER_109_172 VGND VGND VPWR VPWR sky130_fd_sc_hd__decap_3
XFILLER_3_461 VGND VGND VPWR VPWR sky130_fd_sc_hd__decap_3
XFILLER_98_527 VGND VGND VPWR VPWR sky130_fd_sc_hd__decap_3
XFILLER_112_337 VGND VGND VPWR VPWR sky130_fd_sc_hd__decap_3
XFILLER_78_251 VGND VGND VPWR VPWR sky130_fd_sc_hd__fill_1
XTAP_TAPCELL_ROW_111_1698 VGND VPWR sky130_fd_sc_hd__tapvpwrvgnd_1
XFILLER_38_115 VGND VGND VPWR VPWR sky130_fd_sc_hd__fill_1
XFILLER_39_638 VGND VGND VPWR VPWR sky130_fd_sc_hd__decap_3
XFILLER_66_424 VGND VGND VPWR VPWR sky130_fd_sc_hd__decap_3
XFILLER_93_221 VGND VGND VPWR VPWR sky130_fd_sc_hd__decap_3
XFILLER_94_722 VGND VGND VPWR VPWR sky130_fd_sc_hd__fill_1
XFILLER_19_340 VGND VGND VPWR VPWR sky130_fd_sc_hd__decap_3
XFILLER_38_159 VGND VGND VPWR VPWR sky130_fd_sc_hd__fill_2
XFILLER_66_468 VGND VGND VPWR VPWR sky130_fd_sc_hd__decap_3
XFILLER_81_405 VGND VGND VPWR VPWR sky130_fd_sc_hd__decap_3
XFILLER_93_265 VGND VGND VPWR VPWR sky130_fd_sc_hd__fill_2
XFILLER_47_671 VGND VGND VPWR VPWR sky130_fd_sc_hd__fill_1
XFILLER_75_90 VGND VGND VPWR VPWR sky130_fd_sc_hd__decap_3
XFILLER_81_438 VGND VGND VPWR VPWR sky130_fd_sc_hd__decap_3
XFILLER_93_287 VGND VGND VPWR VPWR sky130_fd_sc_hd__decap_3
X_5900_ _5898_/X _5899_/X _5900_/S VGND VGND VPWR VPWR _5900_/X sky130_fd_sc_hd__mux2_2
XTAP_TAPCELL_ROW_66_1111 VGND VPWR sky130_fd_sc_hd__tapvpwrvgnd_1
XFILLER_34_321 VGND VGND VPWR VPWR sky130_fd_sc_hd__decap_3
XFILLER_74_490 VGND VGND VPWR VPWR sky130_fd_sc_hd__decap_3
XFILLER_81_449 VGND VGND VPWR VPWR sky130_fd_sc_hd__decap_3
X_6880_ _6735_/B _6735_/A _6874_/X _6879_/X VGND VGND VPWR VPWR _6880_/X sky130_fd_sc_hd__a31o_4
XTAP_TAPCELL_ROW_66_1122 VGND VPWR sky130_fd_sc_hd__tapvpwrvgnd_1
XFILLER_22_516 VGND VGND VPWR VPWR sky130_fd_sc_hd__decap_3
XFILLER_34_354 VGND VGND VPWR VPWR sky130_fd_sc_hd__decap_3
XFILLER_34_376 VGND VGND VPWR VPWR sky130_fd_sc_hd__decap_3
XFILLER_61_162 VGND VGND VPWR VPWR sky130_fd_sc_hd__decap_3
X_5831_ _6130_/C _5470_/X _5830_/Y _6421_/S VGND VGND VPWR VPWR _5832_/B sky130_fd_sc_hd__o2bb2a_2
XTAP_TAPCELL_ROW_45_850 VGND VPWR sky130_fd_sc_hd__tapvpwrvgnd_1
X_5762_ _7844_/A VGND VGND VPWR VPWR _6076_/A sky130_fd_sc_hd__clkbuf_1
X_7501_ _7619_/A _7499_/X _7500_/Y _5402_/A VGND VGND VPWR VPWR _7501_/X sky130_fd_sc_hd__a22o_2
X_4713_ _5239_/B VGND VGND VPWR VPWR _6763_/B sky130_fd_sc_hd__buf_1
XFILLER_30_560 VGND VGND VPWR VPWR sky130_fd_sc_hd__decap_3
XFILLER_30_571 VGND VGND VPWR VPWR sky130_fd_sc_hd__decap_3
Xrebuffer308 rebuffer308/A VGND VGND VPWR VPWR _7231_/B sky130_fd_sc_hd__buf_6
X_5693_ _5817_/A _5944_/C _5727_/B _6944_/A VGND VGND VPWR VPWR _5693_/X sky130_fd_sc_hd__o2bb2a_2
XFILLER_107_109 VGND VGND VPWR VPWR sky130_fd_sc_hd__decap_3
X_7432_ _7398_/X _7280_/B _7402_/X _8216_/Q VGND VGND VPWR VPWR _7490_/B sky130_fd_sc_hd__a211o_4
X_4644_ _7930_/B _8126_/Q VGND VGND VPWR VPWR _4645_/A sky130_fd_sc_hd__and2_2
X_7363_ _7209_/A _7343_/X _7362_/X _7347_/X VGND VGND VPWR VPWR _7363_/X sky130_fd_sc_hd__a211o_4
X_4575_ _4575_/A VGND VGND VPWR VPWR _8225_/D sky130_fd_sc_hd__buf_1
XFILLER_116_654 VGND VGND VPWR VPWR sky130_fd_sc_hd__decap_3
XFILLER_89_505 VGND VGND VPWR VPWR sky130_fd_sc_hd__decap_3
X_7294_ _7619_/A _7291_/X _7293_/X VGND VGND VPWR VPWR _7294_/X sky130_fd_sc_hd__a21o_2
X_6314_ _6769_/B _6310_/X _6313_/X _8289_/Q VGND VGND VPWR VPWR _6314_/X sky130_fd_sc_hd__a2bb2o_2
XTAP_TAPCELL_ROW_77_1262 VGND VPWR sky130_fd_sc_hd__tapvpwrvgnd_1
XFILLER_116_687 VGND VGND VPWR VPWR sky130_fd_sc_hd__fill_1
X_6245_ _5528_/A _6244_/X _5857_/A VGND VGND VPWR VPWR _6245_/Y sky130_fd_sc_hd__o21ai_2
XFILLER_103_326 VGND VGND VPWR VPWR sky130_fd_sc_hd__decap_3
XFILLER_103_337 VGND VGND VPWR VPWR sky130_fd_sc_hd__decap_3
XFILLER_103_359 VGND VGND VPWR VPWR sky130_fd_sc_hd__decap_3
XFILLER_115_197 VGND VGND VPWR VPWR sky130_fd_sc_hd__fill_2
XFILLER_69_240 VGND VGND VPWR VPWR sky130_fd_sc_hd__fill_1
XFILLER_85_711 VGND VGND VPWR VPWR sky130_fd_sc_hd__fill_1
X_6176_ _4913_/B _6142_/X _8179_/Q VGND VGND VPWR VPWR _6176_/X sky130_fd_sc_hd__a21bo_2
XFILLER_57_424 VGND VGND VPWR VPWR sky130_fd_sc_hd__fill_2
XFILLER_57_435 VGND VGND VPWR VPWR sky130_fd_sc_hd__decap_3
XFILLER_69_273 VGND VGND VPWR VPWR sky130_fd_sc_hd__decap_3
XFILLER_69_284 VGND VGND VPWR VPWR sky130_fd_sc_hd__decap_3
XFILLER_84_221 VGND VGND VPWR VPWR sky130_fd_sc_hd__decap_3
X_5127_ _5127_/A VGND VGND VPWR VPWR _5365_/S sky130_fd_sc_hd__inv_2
XFILLER_45_608 VGND VGND VPWR VPWR sky130_fd_sc_hd__fill_2
XPHY_EDGE_ROW_2_Right_2 VGND VGND VPWR VPWR sky130_fd_sc_hd__decap_3
X_5058_ _7159_/A _7030_/A _4795_/B VGND VGND VPWR VPWR _5058_/Y sky130_fd_sc_hd__a21boi_2
XFILLER_44_118 VGND VGND VPWR VPWR sky130_fd_sc_hd__decap_3
XFILLER_72_427 VGND VGND VPWR VPWR sky130_fd_sc_hd__fill_1
XFILLER_84_265 VGND VGND VPWR VPWR sky130_fd_sc_hd__decap_3
XFILLER_84_298 VGND VGND VPWR VPWR sky130_fd_sc_hd__decap_3
X_4009_ _4009_/A VGND VGND VPWR VPWR _7953_/D sky130_fd_sc_hd__buf_1
XFILLER_53_641 VGND VGND VPWR VPWR sky130_fd_sc_hd__decap_3
XFILLER_65_490 VGND VGND VPWR VPWR sky130_fd_sc_hd__decap_3
XFILLER_72_449 VGND VGND VPWR VPWR sky130_fd_sc_hd__decap_3
XFILLER_111_55 VGND VGND VPWR VPWR sky130_fd_sc_hd__fill_1
XFILLER_13_505 VGND VGND VPWR VPWR sky130_fd_sc_hd__decap_3
XFILLER_25_354 VGND VGND VPWR VPWR sky130_fd_sc_hd__decap_3
XFILLER_40_302 VGND VGND VPWR VPWR sky130_fd_sc_hd__decap_3
XFILLER_52_151 VGND VGND VPWR VPWR sky130_fd_sc_hd__decap_3
XFILLER_111_66 VGND VGND VPWR VPWR sky130_fd_sc_hd__decap_3
XFILLER_40_324 VGND VGND VPWR VPWR sky130_fd_sc_hd__decap_3
XFILLER_71_37 VGND VGND VPWR VPWR sky130_fd_sc_hd__decap_3
XPHY_EDGE_ROW_80_Left_200 VGND VGND VPWR VPWR sky130_fd_sc_hd__decap_3
XTAP_TAPCELL_ROW_23_555 VGND VPWR sky130_fd_sc_hd__tapvpwrvgnd_1
Xrebuffer831 _8253_/Q VGND VGND VPWR VPWR _6521_/A1 sky130_fd_sc_hd__buf_2
Xrebuffer842 _7637_/Y VGND VGND VPWR VPWR _7640_/A2 sky130_fd_sc_hd__buf_2
XFILLER_112_3 VGND VGND VPWR VPWR sky130_fd_sc_hd__decap_3
XFILLER_4_203 VGND VGND VPWR VPWR sky130_fd_sc_hd__fill_1
XFILLER_5_715 VGND VGND VPWR VPWR sky130_fd_sc_hd__decap_3
XFILLER_107_654 VGND VGND VPWR VPWR sky130_fd_sc_hd__decap_3
XFILLER_119_492 VGND VGND VPWR VPWR sky130_fd_sc_hd__decap_3
XFILLER_106_153 VGND VGND VPWR VPWR sky130_fd_sc_hd__decap_3
XFILLER_107_676 VGND VGND VPWR VPWR sky130_fd_sc_hd__fill_2
XFILLER_106_186 VGND VGND VPWR VPWR sky130_fd_sc_hd__decap_3
XFILLER_106_197 VGND VGND VPWR VPWR sky130_fd_sc_hd__decap_3
XFILLER_48_402 VGND VGND VPWR VPWR sky130_fd_sc_hd__decap_3
XFILLER_95_508 VGND VGND VPWR VPWR sky130_fd_sc_hd__decap_3
XFILLER_0_475 VGND VGND VPWR VPWR sky130_fd_sc_hd__fill_1
XFILLER_48_424 VGND VGND VPWR VPWR sky130_fd_sc_hd__decap_3
XFILLER_75_210 VGND VGND VPWR VPWR sky130_fd_sc_hd__decap_3
XFILLER_102_392 VGND VGND VPWR VPWR sky130_fd_sc_hd__decap_3
XFILLER_29_671 VGND VGND VPWR VPWR sky130_fd_sc_hd__fill_1
XFILLER_29_682 VGND VGND VPWR VPWR sky130_fd_sc_hd__fill_2
XFILLER_35_129 VGND VGND VPWR VPWR sky130_fd_sc_hd__fill_1
XFILLER_63_416 VGND VGND VPWR VPWR sky130_fd_sc_hd__decap_3
XFILLER_75_276 VGND VGND VPWR VPWR sky130_fd_sc_hd__decap_3
XFILLER_75_287 VGND VGND VPWR VPWR sky130_fd_sc_hd__decap_3
XFILLER_29_693 VGND VGND VPWR VPWR sky130_fd_sc_hd__decap_3
XFILLER_90_224 VGND VGND VPWR VPWR sky130_fd_sc_hd__decap_3
XFILLER_44_674 VGND VGND VPWR VPWR sky130_fd_sc_hd__decap_3
XFILLER_45_60 VGND VGND VPWR VPWR sky130_fd_sc_hd__decap_3
XFILLER_45_82 VGND VGND VPWR VPWR sky130_fd_sc_hd__decap_3
XFILLER_43_162 VGND VGND VPWR VPWR sky130_fd_sc_hd__decap_3
XFILLER_31_379 VGND VGND VPWR VPWR sky130_fd_sc_hd__decap_3
XFILLER_8_531 VGND VGND VPWR VPWR sky130_fd_sc_hd__fill_1
XTAP_TAPCELL_ROW_61_1052 VGND VPWR sky130_fd_sc_hd__tapvpwrvgnd_1
XFILLER_61_81 VGND VGND VPWR VPWR sky130_fd_sc_hd__decap_3
XANTENNA_3 _4017_/A VGND VGND VPWR VPWR sky130_fd_sc_hd__diode_2
XFILLER_6_32 VGND VGND VPWR VPWR sky130_fd_sc_hd__decap_3
XFILLER_6_43 VGND VGND VPWR VPWR sky130_fd_sc_hd__decap_3
XFILLER_8_586 VGND VGND VPWR VPWR sky130_fd_sc_hd__fill_2
XFILLER_6_54 VGND VGND VPWR VPWR sky130_fd_sc_hd__fill_2
X_4360_ _7930_/B _4360_/B VGND VGND VPWR VPWR _4361_/A sky130_fd_sc_hd__and2_2
XTAP_TAPCELL_ROW_113_1727 VGND VPWR sky130_fd_sc_hd__tapvpwrvgnd_1
X_4291_ _4291_/A VGND VGND VPWR VPWR _8083_/D sky130_fd_sc_hd__buf_1
XFILLER_39_402 VGND VGND VPWR VPWR sky130_fd_sc_hd__decap_3
XFILLER_98_368 VGND VGND VPWR VPWR sky130_fd_sc_hd__decap_3
X_6030_ _6097_/A _8240_/Q _5585_/A VGND VGND VPWR VPWR _6030_/Y sky130_fd_sc_hd__a21oi_2
XFILLER_112_189 VGND VGND VPWR VPWR sky130_fd_sc_hd__decap_3
XFILLER_39_435 VGND VGND VPWR VPWR sky130_fd_sc_hd__decap_3
XTAP_TAPCELL_ROW_72_1192 VGND VPWR sky130_fd_sc_hd__tapvpwrvgnd_1
XFILLER_26_118 VGND VGND VPWR VPWR sky130_fd_sc_hd__fill_1
XFILLER_66_265 VGND VGND VPWR VPWR sky130_fd_sc_hd__decap_3
XFILLER_94_585 VGND VGND VPWR VPWR sky130_fd_sc_hd__decap_3
X_7981_ _8384_/CLK _7981_/D VGND VGND VPWR VPWR _7981_/Q sky130_fd_sc_hd__dfxtp_2
XFILLER_35_630 VGND VGND VPWR VPWR sky130_fd_sc_hd__decap_3
XFILLER_54_449 VGND VGND VPWR VPWR sky130_fd_sc_hd__decap_3
XFILLER_81_246 VGND VGND VPWR VPWR sky130_fd_sc_hd__decap_3
X_6932_ _6910_/X _6914_/Y _6931_/X _7930_/B VGND VGND VPWR VPWR _8335_/D sky130_fd_sc_hd__o31a_2
XFILLER_62_460 VGND VGND VPWR VPWR sky130_fd_sc_hd__decap_3
XFILLER_81_279 VGND VGND VPWR VPWR sky130_fd_sc_hd__fill_1
X_6863_ _8263_/Q _5296_/X _7453_/A _6862_/X VGND VGND VPWR VPWR _6863_/X sky130_fd_sc_hd__a211o_2
XFILLER_22_324 VGND VGND VPWR VPWR sky130_fd_sc_hd__decap_3
XFILLER_50_611 VGND VGND VPWR VPWR sky130_fd_sc_hd__decap_3
X_5814_ _6095_/A _7783_/B _7776_/B _5944_/C VGND VGND VPWR VPWR _5897_/C sky130_fd_sc_hd__and4_2
XFILLER_22_368 VGND VGND VPWR VPWR sky130_fd_sc_hd__decap_3
X_6794_ _6794_/A _6794_/B VGND VGND VPWR VPWR _6794_/Y sky130_fd_sc_hd__nand2_2
XFILLER_10_519 VGND VGND VPWR VPWR sky130_fd_sc_hd__decap_3
XFILLER_50_688 VGND VGND VPWR VPWR sky130_fd_sc_hd__decap_3
X_5745_ _7783_/A _5745_/B VGND VGND VPWR VPWR _5745_/X sky130_fd_sc_hd__or2_2
XTAP_TAPCELL_ROW_20_514 VGND VPWR sky130_fd_sc_hd__tapvpwrvgnd_1
XFILLER_108_407 VGND VGND VPWR VPWR sky130_fd_sc_hd__decap_3
XFILLER_30_390 VGND VGND VPWR VPWR sky130_fd_sc_hd__decap_3
X_5676_ _6321_/B _5673_/A _5675_/Y _6277_/A VGND VGND VPWR VPWR _5676_/Y sky130_fd_sc_hd__o211ai_2
XTAP_TAPCELL_ROW_20_525 VGND VPWR sky130_fd_sc_hd__tapvpwrvgnd_1
X_7415_ _6462_/A _8216_/Q _7414_/Y _5402_/X _4741_/A VGND VGND VPWR VPWR _7415_/X
+ sky130_fd_sc_hd__a32o_2
X_4627_ _4627_/A VGND VGND VPWR VPWR _8251_/D sky130_fd_sc_hd__buf_1
X_8395_ _8400_/CLK _8395_/D VGND VGND VPWR VPWR _8395_/Q sky130_fd_sc_hd__dfxtp_2
XFILLER_116_462 VGND VGND VPWR VPWR sky130_fd_sc_hd__decap_3
XFILLER_2_707 VGND VGND VPWR VPWR sky130_fd_sc_hd__decap_3
Xmax_cap250 _7555_/S VGND VGND VPWR VPWR _7670_/A sky130_fd_sc_hd__buf_12
X_7346_ _6497_/B _7424_/C _6494_/A _7383_/B VGND VGND VPWR VPWR _7346_/X sky130_fd_sc_hd__a2bb2o_2
X_4558_ _7843_/A _8083_/Q VGND VGND VPWR VPWR _4559_/A sky130_fd_sc_hd__and2_2
XFILLER_104_657 VGND VGND VPWR VPWR sky130_fd_sc_hd__decap_3
X_7277_ _7277_/A VGND VGND VPWR VPWR _8345_/D sky130_fd_sc_hd__buf_1
X_4489_ _4489_/A VGND VGND VPWR VPWR _8182_/D sky130_fd_sc_hd__buf_1
XFILLER_103_134 VGND VGND VPWR VPWR sky130_fd_sc_hd__decap_3
XFILLER_103_167 VGND VGND VPWR VPWR sky130_fd_sc_hd__fill_1
XFILLER_104_679 VGND VGND VPWR VPWR sky130_fd_sc_hd__fill_1
X_6228_ _7725_/B _8246_/Q _8288_/Q VGND VGND VPWR VPWR _6228_/X sky130_fd_sc_hd__mux2_2
XFILLER_106_55 VGND VGND VPWR VPWR sky130_fd_sc_hd__fill_1
XFILLER_57_210 VGND VGND VPWR VPWR sky130_fd_sc_hd__decap_3
X_6159_ _8180_/Q _8244_/Q VGND VGND VPWR VPWR _6159_/Y sky130_fd_sc_hd__nand2_2
XFILLER_106_88 VGND VGND VPWR VPWR sky130_fd_sc_hd__decap_3
XFILLER_57_254 VGND VGND VPWR VPWR sky130_fd_sc_hd__decap_3
XFILLER_66_37 VGND VGND VPWR VPWR sky130_fd_sc_hd__decap_3
XFILLER_85_530 VGND VGND VPWR VPWR sky130_fd_sc_hd__decap_3
XFILLER_18_619 VGND VGND VPWR VPWR sky130_fd_sc_hd__decap_3
XFILLER_45_405 VGND VGND VPWR VPWR sky130_fd_sc_hd__decap_3
XFILLER_45_416 VGND VGND VPWR VPWR sky130_fd_sc_hd__decap_3
XFILLER_57_287 VGND VGND VPWR VPWR sky130_fd_sc_hd__decap_3
XFILLER_38_490 VGND VGND VPWR VPWR sky130_fd_sc_hd__decap_3
XFILLER_45_438 VGND VGND VPWR VPWR sky130_fd_sc_hd__decap_3
XFILLER_45_449 VGND VGND VPWR VPWR sky130_fd_sc_hd__decap_3
XFILLER_72_224 VGND VGND VPWR VPWR sky130_fd_sc_hd__decap_3
XFILLER_82_14 VGND VGND VPWR VPWR sky130_fd_sc_hd__fill_1
Xclkbuf_leaf_37_clk clkload0/A VGND VGND VPWR VPWR clkload5/A sky130_fd_sc_hd__clkbuf_8
XTAP_TAPCELL_ROW_28_625 VGND VPWR sky130_fd_sc_hd__tapvpwrvgnd_1
XFILLER_26_663 VGND VGND VPWR VPWR sky130_fd_sc_hd__decap_3
XFILLER_41_600 VGND VGND VPWR VPWR sky130_fd_sc_hd__decap_3
XFILLER_60_419 VGND VGND VPWR VPWR sky130_fd_sc_hd__fill_1
XFILLER_72_268 VGND VGND VPWR VPWR sky130_fd_sc_hd__decap_3
XTAP_TAPCELL_ROW_0_250 VGND VPWR sky130_fd_sc_hd__tapvpwrvgnd_1
XTAP_TAPCELL_ROW_0_261 VGND VPWR sky130_fd_sc_hd__tapvpwrvgnd_1
XTAP_TAPCELL_ROW_56_989 VGND VPWR sky130_fd_sc_hd__tapvpwrvgnd_1
XFILLER_25_184 VGND VGND VPWR VPWR sky130_fd_sc_hd__decap_3
XFILLER_26_696 VGND VGND VPWR VPWR sky130_fd_sc_hd__decap_3
XFILLER_40_110 VGND VGND VPWR VPWR sky130_fd_sc_hd__decap_3
XFILLER_41_633 VGND VGND VPWR VPWR sky130_fd_sc_hd__decap_3
XFILLER_15_74 VGND VGND VPWR VPWR sky130_fd_sc_hd__decap_3
XFILLER_41_655 VGND VGND VPWR VPWR sky130_fd_sc_hd__decap_3
XFILLER_41_666 VGND VGND VPWR VPWR sky130_fd_sc_hd__decap_3
XFILLER_13_379 VGND VGND VPWR VPWR sky130_fd_sc_hd__decap_3
XFILLER_5_523 VGND VGND VPWR VPWR sky130_fd_sc_hd__fill_2
XFILLER_107_440 VGND VGND VPWR VPWR sky130_fd_sc_hd__decap_3
XFILLER_31_73 VGND VGND VPWR VPWR sky130_fd_sc_hd__decap_3
XFILLER_5_545 VGND VGND VPWR VPWR sky130_fd_sc_hd__decap_3
XFILLER_107_473 VGND VGND VPWR VPWR sky130_fd_sc_hd__decap_3
XFILLER_5_589 VGND VGND VPWR VPWR sky130_fd_sc_hd__decap_3
XTAP_TAPCELL_ROW_8_361 VGND VPWR sky130_fd_sc_hd__tapvpwrvgnd_1
XFILLER_48_221 VGND VGND VPWR VPWR sky130_fd_sc_hd__decap_3
XFILLER_95_349 VGND VGND VPWR VPWR sky130_fd_sc_hd__decap_3
XFILLER_36_427 VGND VGND VPWR VPWR sky130_fd_sc_hd__decap_3
XFILLER_48_265 VGND VGND VPWR VPWR sky130_fd_sc_hd__decap_3
XFILLER_76_563 VGND VGND VPWR VPWR sky130_fd_sc_hd__fill_1
XFILLER_48_298 VGND VGND VPWR VPWR sky130_fd_sc_hd__decap_3
XFILLER_56_70 VGND VGND VPWR VPWR sky130_fd_sc_hd__decap_3
XFILLER_63_246 VGND VGND VPWR VPWR sky130_fd_sc_hd__decap_3
XFILLER_91_522 VGND VGND VPWR VPWR sky130_fd_sc_hd__decap_3
XFILLER_91_544 VGND VGND VPWR VPWR sky130_fd_sc_hd__decap_3
Xclkbuf_leaf_28_clk clkbuf_2_2__f_clk/X VGND VGND VPWR VPWR _8365_/CLK sky130_fd_sc_hd__clkbuf_8
XFILLER_17_652 VGND VGND VPWR VPWR sky130_fd_sc_hd__fill_1
XFILLER_51_408 VGND VGND VPWR VPWR sky130_fd_sc_hd__decap_3
XFILLER_16_162 VGND VGND VPWR VPWR sky130_fd_sc_hd__decap_3
XFILLER_31_110 VGND VGND VPWR VPWR sky130_fd_sc_hd__fill_2
XFILLER_44_460 VGND VGND VPWR VPWR sky130_fd_sc_hd__decap_3
XFILLER_16_195 VGND VGND VPWR VPWR sky130_fd_sc_hd__fill_1
XFILLER_71_290 VGND VGND VPWR VPWR sky130_fd_sc_hd__decap_3
XFILLER_72_80 VGND VGND VPWR VPWR sky130_fd_sc_hd__decap_3
XFILLER_31_165 VGND VGND VPWR VPWR sky130_fd_sc_hd__decap_3
XFILLER_32_699 VGND VGND VPWR VPWR sky130_fd_sc_hd__fill_1
XFILLER_118_716 VGND VGND VPWR VPWR sky130_fd_sc_hd__decap_3
XFILLER_75_3 VGND VGND VPWR VPWR sky130_fd_sc_hd__decap_3
X_5530_ _6623_/A _5584_/A VGND VGND VPWR VPWR _5530_/Y sky130_fd_sc_hd__nor2_2
X_5461_ _5178_/X _5162_/X _5684_/S VGND VGND VPWR VPWR _5461_/X sky130_fd_sc_hd__mux2_2
X_7200_ _7199_/X _7037_/X _7670_/A VGND VGND VPWR VPWR _7200_/X sky130_fd_sc_hd__mux2_2
X_4412_ _7930_/B _4412_/B VGND VGND VPWR VPWR _4413_/A sky130_fd_sc_hd__and2_2
X_8180_ _8360_/CLK _8180_/D VGND VGND VPWR VPWR _8180_/Q sky130_fd_sc_hd__dfxtp_4
X_5392_ _5259_/X _5223_/X _5452_/S VGND VGND VPWR VPWR _5392_/X sky130_fd_sc_hd__mux2_2
XTAP_TAPCELL_ROW_74_1221 VGND VPWR sky130_fd_sc_hd__tapvpwrvgnd_1
XPHY_EDGE_ROW_99_Right_99 VGND VGND VPWR VPWR sky130_fd_sc_hd__decap_3
X_7131_ _5614_/X _7317_/C _7130_/Y _6334_/A VGND VGND VPWR VPWR _7132_/B sky130_fd_sc_hd__o22a_2
X_4343_ _4343_/A VGND VGND VPWR VPWR _8109_/D sky130_fd_sc_hd__buf_1
XFILLER_59_508 VGND VGND VPWR VPWR sky130_fd_sc_hd__decap_3
XFILLER_98_165 VGND VGND VPWR VPWR sky130_fd_sc_hd__decap_3
X_7062_ _8229_/Q _7061_/X _6454_/A VGND VGND VPWR VPWR _7062_/Y sky130_fd_sc_hd__o21ai_2
X_4274_ _7843_/A _4274_/B VGND VGND VPWR VPWR _4275_/A sky130_fd_sc_hd__and2_2
XFILLER_86_338 VGND VGND VPWR VPWR sky130_fd_sc_hd__decap_3
X_6013_ _6012_/X _5956_/X _5860_/X _5780_/X _7812_/A _7670_/A VGND VGND VPWR VPWR
+ _6013_/X sky130_fd_sc_hd__mux4_2
XFILLER_67_530 VGND VGND VPWR VPWR sky130_fd_sc_hd__decap_3
XFILLER_36_18 VGND VGND VPWR VPWR sky130_fd_sc_hd__decap_3
XFILLER_39_276 VGND VGND VPWR VPWR sky130_fd_sc_hd__decap_3
XFILLER_67_574 VGND VGND VPWR VPWR sky130_fd_sc_hd__decap_3
XFILLER_82_500 VGND VGND VPWR VPWR sky130_fd_sc_hd__decap_3
XFILLER_94_371 VGND VGND VPWR VPWR sky130_fd_sc_hd__decap_3
Xsplit270 _5780_/S VGND VGND VPWR VPWR _5678_/S sky130_fd_sc_hd__buf_6
Xsplit281 _6355_/A VGND VGND VPWR VPWR _6353_/B sky130_fd_sc_hd__clkbuf_8
XFILLER_27_427 VGND VGND VPWR VPWR sky130_fd_sc_hd__decap_3
XFILLER_27_449 VGND VGND VPWR VPWR sky130_fd_sc_hd__decap_3
XFILLER_39_287 VGND VGND VPWR VPWR sky130_fd_sc_hd__decap_3
XFILLER_82_522 VGND VGND VPWR VPWR sky130_fd_sc_hd__fill_2
XFILLER_82_544 VGND VGND VPWR VPWR sky130_fd_sc_hd__decap_3
X_7964_ _8385_/CLK _7964_/D VGND VGND VPWR VPWR _7964_/Q sky130_fd_sc_hd__dfxtp_2
Xclkbuf_leaf_19_clk clkload2/A VGND VGND VPWR VPWR _8401_/CLK sky130_fd_sc_hd__clkbuf_8
X_6915_ _8265_/Q _5292_/X _5111_/X VGND VGND VPWR VPWR _6915_/X sky130_fd_sc_hd__a21o_2
XFILLER_35_482 VGND VGND VPWR VPWR sky130_fd_sc_hd__fill_1
X_7895_ _7895_/A VGND VGND VPWR VPWR _8384_/D sky130_fd_sc_hd__buf_1
XTAP_TAPCELL_ROW_85_1361 VGND VPWR sky130_fd_sc_hd__tapvpwrvgnd_1
XTAP_TAPCELL_ROW_53_948 VGND VPWR sky130_fd_sc_hd__tapvpwrvgnd_1
XFILLER_22_121 VGND VGND VPWR VPWR sky130_fd_sc_hd__decap_3
XFILLER_23_644 VGND VGND VPWR VPWR sky130_fd_sc_hd__decap_3
XFILLER_50_430 VGND VGND VPWR VPWR sky130_fd_sc_hd__decap_3
XFILLER_52_39 VGND VGND VPWR VPWR sky130_fd_sc_hd__decap_3
X_6846_ _6956_/D _6846_/B VGND VGND VPWR VPWR _6852_/A sky130_fd_sc_hd__nor2_2
XFILLER_10_305 VGND VGND VPWR VPWR sky130_fd_sc_hd__decap_3
XFILLER_22_176 VGND VGND VPWR VPWR sky130_fd_sc_hd__fill_1
XFILLER_23_688 VGND VGND VPWR VPWR sky130_fd_sc_hd__decap_3
X_6777_ _8261_/Q _6775_/X _6776_/Y _7631_/B VGND VGND VPWR VPWR _6777_/X sky130_fd_sc_hd__a2bb2o_2
XFILLER_22_187 VGND VGND VPWR VPWR sky130_fd_sc_hd__decap_3
XFILLER_50_496 VGND VGND VPWR VPWR sky130_fd_sc_hd__fill_2
X_5728_ _7231_/A _5896_/A VGND VGND VPWR VPWR _5728_/Y sky130_fd_sc_hd__nor2_2
X_3989_ _3989_/A VGND VGND VPWR VPWR _7943_/D sky130_fd_sc_hd__buf_1
XTAP_TAPCELL_ROW_33_694 VGND VPWR sky130_fd_sc_hd__tapvpwrvgnd_1
XTAP_TAPCELL_ROW_33_683 VGND VPWR sky130_fd_sc_hd__tapvpwrvgnd_1
XFILLER_108_215 VGND VGND VPWR VPWR sky130_fd_sc_hd__decap_3
XFILLER_6_309 VGND VGND VPWR VPWR sky130_fd_sc_hd__decap_3
XFILLER_108_248 VGND VGND VPWR VPWR sky130_fd_sc_hd__decap_3
XFILLER_108_259 VGND VGND VPWR VPWR sky130_fd_sc_hd__decap_3
X_5659_ _5584_/A _8230_/Q _5017_/B VGND VGND VPWR VPWR _5659_/X sky130_fd_sc_hd__o21ba_2
XFILLER_117_21 VGND VGND VPWR VPWR sky130_fd_sc_hd__decap_3
X_8378_ _8380_/CLK _8378_/D VGND VGND VPWR VPWR _8378_/Q sky130_fd_sc_hd__dfxtp_2
XFILLER_104_421 VGND VGND VPWR VPWR sky130_fd_sc_hd__decap_3
XFILLER_117_54 VGND VGND VPWR VPWR sky130_fd_sc_hd__fill_2
X_7329_ _7619_/A _7327_/X _7328_/X VGND VGND VPWR VPWR _7329_/Y sky130_fd_sc_hd__a21oi_2
XFILLER_104_443 VGND VGND VPWR VPWR sky130_fd_sc_hd__decap_3
XFILLER_77_14 VGND VGND VPWR VPWR sky130_fd_sc_hd__decap_3
XFILLER_77_305 VGND VGND VPWR VPWR sky130_fd_sc_hd__decap_3
XFILLER_89_143 VGND VGND VPWR VPWR sky130_fd_sc_hd__decap_3
XFILLER_77_47 VGND VGND VPWR VPWR sky130_fd_sc_hd__decap_3
XFILLER_77_69 VGND VGND VPWR VPWR sky130_fd_sc_hd__decap_3
XFILLER_89_187 VGND VGND VPWR VPWR sky130_fd_sc_hd__decap_3
XTAP_TAPCELL_ROW_5_320 VGND VPWR sky130_fd_sc_hd__tapvpwrvgnd_1
XFILLER_58_552 VGND VGND VPWR VPWR sky130_fd_sc_hd__decap_3
XFILLER_77_349 VGND VGND VPWR VPWR sky130_fd_sc_hd__decap_3
XFILLER_100_660 VGND VGND VPWR VPWR sky130_fd_sc_hd__decap_3
XFILLER_18_405 VGND VGND VPWR VPWR sky130_fd_sc_hd__decap_3
XFILLER_85_360 VGND VGND VPWR VPWR sky130_fd_sc_hd__decap_3
XFILLER_100_693 VGND VGND VPWR VPWR sky130_fd_sc_hd__fill_1
XFILLER_85_393 VGND VGND VPWR VPWR sky130_fd_sc_hd__decap_3
XFILLER_93_57 VGND VGND VPWR VPWR sky130_fd_sc_hd__fill_1
XFILLER_33_408 VGND VGND VPWR VPWR sky130_fd_sc_hd__decap_3
XFILLER_45_246 VGND VGND VPWR VPWR sky130_fd_sc_hd__decap_3
XFILLER_26_471 VGND VGND VPWR VPWR sky130_fd_sc_hd__decap_3
XFILLER_26_73 VGND VGND VPWR VPWR sky130_fd_sc_hd__fill_2
XFILLER_45_279 VGND VGND VPWR VPWR sky130_fd_sc_hd__fill_1
XFILLER_60_227 VGND VGND VPWR VPWR sky130_fd_sc_hd__decap_3
XFILLER_13_132 VGND VGND VPWR VPWR sky130_fd_sc_hd__decap_3
XFILLER_14_666 VGND VGND VPWR VPWR sky130_fd_sc_hd__fill_2
XFILLER_41_430 VGND VGND VPWR VPWR sky130_fd_sc_hd__decap_3
XFILLER_41_452 VGND VGND VPWR VPWR sky130_fd_sc_hd__decap_3
XFILLER_41_474 VGND VGND VPWR VPWR sky130_fd_sc_hd__decap_3
XFILLER_9_125 VGND VGND VPWR VPWR sky130_fd_sc_hd__decap_3
XFILLER_9_147 VGND VGND VPWR VPWR sky130_fd_sc_hd__fill_1
XFILLER_42_83 VGND VGND VPWR VPWR sky130_fd_sc_hd__fill_1
XFILLER_42_94 VGND VGND VPWR VPWR sky130_fd_sc_hd__decap_3
XFILLER_9_169 VGND VGND VPWR VPWR sky130_fd_sc_hd__decap_3
XFILLER_5_331 VGND VGND VPWR VPWR sky130_fd_sc_hd__decap_3
XTAP_TAPCELL_ROW_11_399 VGND VPWR sky130_fd_sc_hd__tapvpwrvgnd_1
Xrebuffer491 _6550_/X VGND VGND VPWR VPWR _6578_/C sky130_fd_sc_hd__buf_4
XFILLER_107_281 VGND VGND VPWR VPWR sky130_fd_sc_hd__decap_3
XFILLER_3_11 VGND VGND VPWR VPWR sky130_fd_sc_hd__fill_1
XFILLER_96_603 VGND VGND VPWR VPWR sky130_fd_sc_hd__decap_3
XFILLER_110_424 VGND VGND VPWR VPWR sky130_fd_sc_hd__decap_3
XFILLER_3_55 VGND VGND VPWR VPWR sky130_fd_sc_hd__fill_1
XFILLER_68_327 VGND VGND VPWR VPWR sky130_fd_sc_hd__decap_3
XFILLER_95_102 VGND VGND VPWR VPWR sky130_fd_sc_hd__decap_3
XFILLER_95_113 VGND VGND VPWR VPWR sky130_fd_sc_hd__decap_3
XFILLER_3_66 VGND VGND VPWR VPWR sky130_fd_sc_hd__decap_3
XFILLER_95_124 VGND VGND VPWR VPWR sky130_fd_sc_hd__decap_3
XFILLER_95_157 VGND VGND VPWR VPWR sky130_fd_sc_hd__decap_3
XFILLER_96_669 VGND VGND VPWR VPWR sky130_fd_sc_hd__decap_3
XFILLER_3_99 VGND VGND VPWR VPWR sky130_fd_sc_hd__decap_3
XFILLER_49_574 VGND VGND VPWR VPWR sky130_fd_sc_hd__decap_3
XFILLER_36_235 VGND VGND VPWR VPWR sky130_fd_sc_hd__decap_3
XFILLER_64_533 VGND VGND VPWR VPWR sky130_fd_sc_hd__decap_3
XFILLER_76_371 VGND VGND VPWR VPWR sky130_fd_sc_hd__decap_3
XFILLER_64_566 VGND VGND VPWR VPWR sky130_fd_sc_hd__decap_3
XFILLER_91_363 VGND VGND VPWR VPWR sky130_fd_sc_hd__decap_3
XTAP_TAPCELL_ROW_108_1659 VGND VPWR sky130_fd_sc_hd__tapvpwrvgnd_1
XFILLER_24_419 VGND VGND VPWR VPWR sky130_fd_sc_hd__fill_1
XFILLER_51_205 VGND VGND VPWR VPWR sky130_fd_sc_hd__decap_3
X_4961_ _5310_/A VGND VGND VPWR VPWR _5430_/A sky130_fd_sc_hd__inv_2
XFILLER_32_430 VGND VGND VPWR VPWR sky130_fd_sc_hd__decap_3
X_7680_ _7812_/A _7680_/B VGND VGND VPWR VPWR _7681_/A sky130_fd_sc_hd__or2_2
X_6700_ _8259_/Q _5718_/A _5337_/X _8195_/Q VGND VGND VPWR VPWR _6700_/X sky130_fd_sc_hd__o2bb2a_2
X_4892_ _8181_/Q _8245_/Q VGND VGND VPWR VPWR _6393_/B sky130_fd_sc_hd__and2b_2
XTAP_TAPCELL_ROW_50_907 VGND VPWR sky130_fd_sc_hd__tapvpwrvgnd_1
XFILLER_32_452 VGND VGND VPWR VPWR sky130_fd_sc_hd__decap_3
X_6631_ _8256_/Q _6603_/B _8192_/Q VGND VGND VPWR VPWR _6631_/X sky130_fd_sc_hd__a21o_2
XFILLER_20_636 VGND VGND VPWR VPWR sky130_fd_sc_hd__fill_1
XFILLER_20_658 VGND VGND VPWR VPWR sky130_fd_sc_hd__decap_3
X_8301_ _8365_/CLK _8301_/D VGND VGND VPWR VPWR _8301_/Q sky130_fd_sc_hd__dfxtp_2
X_6562_ _6476_/C _6561_/Y _5054_/B VGND VGND VPWR VPWR _6565_/A sky130_fd_sc_hd__a21o_2
XTAP_TAPCELL_ROW_30_653 VGND VPWR sky130_fd_sc_hd__tapvpwrvgnd_1
X_6493_ _6548_/C _6548_/D VGND VGND VPWR VPWR _6497_/C sky130_fd_sc_hd__nand2_2
X_5513_ _8165_/Q _5513_/B VGND VGND VPWR VPWR _5513_/Y sky130_fd_sc_hd__xnor2_2
XFILLER_8_191 VGND VGND VPWR VPWR sky130_fd_sc_hd__decap_3
X_8232_ clkload7/A _8232_/D VGND VGND VPWR VPWR _8232_/Q sky130_fd_sc_hd__dfxtp_2
Xclkbuf_leaf_8_clk clkload1/A VGND VGND VPWR VPWR _8359_/CLK sky130_fd_sc_hd__clkbuf_8
X_5444_ _5206_/X _5216_/X _5444_/S VGND VGND VPWR VPWR _5444_/X sky130_fd_sc_hd__mux2_2
X_8163_ _8224_/CLK _8163_/D VGND VGND VPWR VPWR _8163_/Q sky130_fd_sc_hd__dfxtp_4
XFILLER_99_452 VGND VGND VPWR VPWR sky130_fd_sc_hd__fill_2
X_7114_ _6573_/X _7113_/X _6275_/X _6866_/X _5462_/X _6321_/B VGND VGND VPWR VPWR
+ _7114_/X sky130_fd_sc_hd__mux4_2
X_5375_ _5373_/X _5374_/X _5596_/S VGND VGND VPWR VPWR _5375_/X sky130_fd_sc_hd__mux2_2
XFILLER_113_251 VGND VGND VPWR VPWR sky130_fd_sc_hd__decap_3
XFILLER_59_305 VGND VGND VPWR VPWR sky130_fd_sc_hd__decap_3
X_8094_ _8228_/CLK _8094_/D VGND VGND VPWR VPWR _8094_/Q sky130_fd_sc_hd__dfxtp_2
X_4326_ _7898_/B _4326_/B VGND VGND VPWR VPWR _4327_/A sky130_fd_sc_hd__and2_2
XFILLER_101_457 VGND VGND VPWR VPWR sky130_fd_sc_hd__decap_3
XFILLER_47_28 VGND VGND VPWR VPWR sky130_fd_sc_hd__decap_3
XFILLER_59_349 VGND VGND VPWR VPWR sky130_fd_sc_hd__decap_3
XFILLER_86_135 VGND VGND VPWR VPWR sky130_fd_sc_hd__decap_3
XFILLER_87_669 VGND VGND VPWR VPWR sky130_fd_sc_hd__decap_3
X_7045_ _8269_/Q _5296_/X _6687_/X VGND VGND VPWR VPWR _7045_/Y sky130_fd_sc_hd__a21oi_2
X_4257_ _4257_/A VGND VGND VPWR VPWR _8066_/D sky130_fd_sc_hd__buf_1
XFILLER_86_168 VGND VGND VPWR VPWR sky130_fd_sc_hd__decap_3
X_4188_ _7898_/B _4188_/B VGND VGND VPWR VPWR _4189_/A sky130_fd_sc_hd__and2_2
XFILLER_55_511 VGND VGND VPWR VPWR sky130_fd_sc_hd__decap_3
XFILLER_67_382 VGND VGND VPWR VPWR sky130_fd_sc_hd__decap_3
XFILLER_67_393 VGND VGND VPWR VPWR sky130_fd_sc_hd__decap_3
XFILLER_27_246 VGND VGND VPWR VPWR sky130_fd_sc_hd__decap_3
XFILLER_82_352 VGND VGND VPWR VPWR sky130_fd_sc_hd__decap_3
XTAP_TAPCELL_ROW_38_753 VGND VPWR sky130_fd_sc_hd__tapvpwrvgnd_1
XFILLER_15_419 VGND VGND VPWR VPWR sky130_fd_sc_hd__decap_3
XFILLER_55_599 VGND VGND VPWR VPWR sky130_fd_sc_hd__decap_3
XFILLER_82_374 VGND VGND VPWR VPWR sky130_fd_sc_hd__decap_3
X_7947_ _8353_/CLK _7947_/D VGND VGND VPWR VPWR _7947_/Q sky130_fd_sc_hd__dfxtp_2
XFILLER_23_430 VGND VGND VPWR VPWR sky130_fd_sc_hd__decap_3
XFILLER_35_290 VGND VGND VPWR VPWR sky130_fd_sc_hd__decap_3
XFILLER_42_249 VGND VGND VPWR VPWR sky130_fd_sc_hd__decap_3
XFILLER_70_547 VGND VGND VPWR VPWR sky130_fd_sc_hd__decap_3
XFILLER_70_569 VGND VGND VPWR VPWR sky130_fd_sc_hd__fill_2
X_7878_ _8309_/Q _7898_/B VGND VGND VPWR VPWR _7879_/A sky130_fd_sc_hd__and2_2
XFILLER_11_614 VGND VGND VPWR VPWR sky130_fd_sc_hd__fill_2
XFILLER_23_452 VGND VGND VPWR VPWR sky130_fd_sc_hd__decap_3
X_6829_ _8198_/Q _8262_/Q VGND VGND VPWR VPWR _6829_/X sky130_fd_sc_hd__or2_2
XFILLER_10_102 VGND VGND VPWR VPWR sky130_fd_sc_hd__fill_2
XFILLER_11_658 VGND VGND VPWR VPWR sky130_fd_sc_hd__decap_3
XTAP_TAPCELL_ROW_98_1530 VGND VPWR sky130_fd_sc_hd__tapvpwrvgnd_1
XFILLER_6_139 VGND VGND VPWR VPWR sky130_fd_sc_hd__fill_1
XFILLER_2_334 VGND VGND VPWR VPWR sky130_fd_sc_hd__decap_3
XFILLER_88_57 VGND VGND VPWR VPWR sky130_fd_sc_hd__decap_3
XFILLER_104_251 VGND VGND VPWR VPWR sky130_fd_sc_hd__fill_1
XFILLER_104_262 VGND VGND VPWR VPWR sky130_fd_sc_hd__decap_3
XFILLER_77_113 VGND VGND VPWR VPWR sky130_fd_sc_hd__decap_3
XFILLER_78_636 VGND VGND VPWR VPWR sky130_fd_sc_hd__decap_3
XFILLER_58_360 VGND VGND VPWR VPWR sky130_fd_sc_hd__decap_3
XFILLER_65_308 VGND VGND VPWR VPWR sky130_fd_sc_hd__decap_3
XFILLER_93_606 VGND VGND VPWR VPWR sky130_fd_sc_hd__decap_3
XFILLER_93_617 VGND VGND VPWR VPWR sky130_fd_sc_hd__fill_2
XFILLER_93_639 VGND VGND VPWR VPWR sky130_fd_sc_hd__decap_3
XFILLER_18_202 VGND VGND VPWR VPWR sky130_fd_sc_hd__decap_3
XFILLER_92_116 VGND VGND VPWR VPWR sky130_fd_sc_hd__decap_3
XFILLER_18_246 VGND VGND VPWR VPWR sky130_fd_sc_hd__decap_3
XFILLER_18_268 VGND VGND VPWR VPWR sky130_fd_sc_hd__decap_3
XFILLER_46_544 VGND VGND VPWR VPWR sky130_fd_sc_hd__decap_3
XFILLER_33_216 VGND VGND VPWR VPWR sky130_fd_sc_hd__decap_3
XFILLER_61_536 VGND VGND VPWR VPWR sky130_fd_sc_hd__decap_3
XFILLER_73_374 VGND VGND VPWR VPWR sky130_fd_sc_hd__decap_3
XFILLER_61_558 VGND VGND VPWR VPWR sky130_fd_sc_hd__fill_2
XFILLER_14_474 VGND VGND VPWR VPWR sky130_fd_sc_hd__fill_2
XFILLER_53_60 VGND VGND VPWR VPWR sky130_fd_sc_hd__decap_3
XTAP_TAPCELL_ROW_16_469 VGND VPWR sky130_fd_sc_hd__tapvpwrvgnd_1
XFILLER_14_485 VGND VGND VPWR VPWR sky130_fd_sc_hd__decap_3
XFILLER_41_271 VGND VGND VPWR VPWR sky130_fd_sc_hd__decap_3
XFILLER_53_93 VGND VGND VPWR VPWR sky130_fd_sc_hd__decap_3
XFILLER_6_640 VGND VGND VPWR VPWR sky130_fd_sc_hd__decap_3
XTAP_TAPCELL_ROW_58_1013 VGND VPWR sky130_fd_sc_hd__tapvpwrvgnd_1
XFILLER_6_695 VGND VGND VPWR VPWR sky130_fd_sc_hd__decap_3
XFILLER_111_700 VGND VGND VPWR VPWR sky130_fd_sc_hd__decap_3
XFILLER_38_3 VGND VGND VPWR VPWR sky130_fd_sc_hd__fill_2
XFILLER_69_614 VGND VGND VPWR VPWR sky130_fd_sc_hd__fill_2
XFILLER_69_636 VGND VGND VPWR VPWR sky130_fd_sc_hd__decap_3
XFILLER_96_411 VGND VGND VPWR VPWR sky130_fd_sc_hd__decap_3
X_5160_ _8178_/Q _8179_/Q _5484_/S VGND VGND VPWR VPWR _5160_/X sky130_fd_sc_hd__mux2_2
XFILLER_110_221 VGND VGND VPWR VPWR sky130_fd_sc_hd__decap_3
XFILLER_68_146 VGND VGND VPWR VPWR sky130_fd_sc_hd__decap_3
XFILLER_96_433 VGND VGND VPWR VPWR sky130_fd_sc_hd__decap_3
X_5091_ _7631_/B _6769_/B VGND VGND VPWR VPWR _5092_/A sky130_fd_sc_hd__nand2_2
X_4111_ _4111_/A VGND VGND VPWR VPWR _7993_/D sky130_fd_sc_hd__buf_1
XFILLER_110_265 VGND VGND VPWR VPWR sky130_fd_sc_hd__decap_3
XFILLER_68_168 VGND VGND VPWR VPWR sky130_fd_sc_hd__decap_3
XFILLER_84_606 VGND VGND VPWR VPWR sky130_fd_sc_hd__decap_3
XFILLER_96_466 VGND VGND VPWR VPWR sky130_fd_sc_hd__fill_2
XFILLER_96_477 VGND VGND VPWR VPWR sky130_fd_sc_hd__decap_3
X_4042_ _7930_/B _8362_/Q VGND VGND VPWR VPWR _4043_/A sky130_fd_sc_hd__and2_2
XFILLER_37_511 VGND VGND VPWR VPWR sky130_fd_sc_hd__decap_3
XFILLER_49_382 VGND VGND VPWR VPWR sky130_fd_sc_hd__fill_2
XFILLER_83_116 VGND VGND VPWR VPWR sky130_fd_sc_hd__decap_3
XFILLER_64_330 VGND VGND VPWR VPWR sky130_fd_sc_hd__decap_3
XFILLER_76_190 VGND VGND VPWR VPWR sky130_fd_sc_hd__decap_3
XTAP_TAPCELL_ROW_69_1153 VGND VPWR sky130_fd_sc_hd__tapvpwrvgnd_1
XFILLER_24_227 VGND VGND VPWR VPWR sky130_fd_sc_hd__decap_3
XFILLER_52_536 VGND VGND VPWR VPWR sky130_fd_sc_hd__decap_3
XFILLER_64_363 VGND VGND VPWR VPWR sky130_fd_sc_hd__fill_1
XFILLER_64_374 VGND VGND VPWR VPWR sky130_fd_sc_hd__decap_3
XFILLER_92_683 VGND VGND VPWR VPWR sky130_fd_sc_hd__decap_3
X_7801_ _7754_/A _7799_/Y _7800_/Y _7796_/A VGND VGND VPWR VPWR _7801_/X sky130_fd_sc_hd__a22o_2
X_5993_ _5993_/A _5993_/B VGND VGND VPWR VPWR _5993_/Y sky130_fd_sc_hd__nand2_2
XTAP_TAPCELL_ROW_35_712 VGND VPWR sky130_fd_sc_hd__tapvpwrvgnd_1
XFILLER_17_290 VGND VGND VPWR VPWR sky130_fd_sc_hd__decap_3
XFILLER_64_396 VGND VGND VPWR VPWR sky130_fd_sc_hd__decap_3
XFILLER_91_193 VGND VGND VPWR VPWR sky130_fd_sc_hd__decap_3
X_7732_ _7812_/A _7732_/B _7812_/C VGND VGND VPWR VPWR _7732_/X sky130_fd_sc_hd__and3_2
X_4944_ _5888_/C _4944_/B VGND VGND VPWR VPWR _5886_/A sky130_fd_sc_hd__or2_4
XTAP_TAPCELL_ROW_82_1331 VGND VPWR sky130_fd_sc_hd__tapvpwrvgnd_1
XTAP_TAPCELL_ROW_82_1320 VGND VPWR sky130_fd_sc_hd__tapvpwrvgnd_1
XFILLER_33_19 VGND VGND VPWR VPWR sky130_fd_sc_hd__decap_3
XFILLER_20_433 VGND VGND VPWR VPWR sky130_fd_sc_hd__decap_3
X_7663_ _7812_/A _7663_/B VGND VGND VPWR VPWR _7664_/A sky130_fd_sc_hd__or2_2
X_4875_ _8251_/Q _8187_/Q VGND VGND VPWR VPWR _4876_/B sky130_fd_sc_hd__and2b_2
X_7594_ _8229_/Q _7594_/B VGND VGND VPWR VPWR _7594_/Y sky130_fd_sc_hd__nor2_2
X_6614_ _7619_/A _6611_/X _6613_/X VGND VGND VPWR VPWR _6614_/X sky130_fd_sc_hd__a21o_2
XFILLER_20_477 VGND VGND VPWR VPWR sky130_fd_sc_hd__decap_3
XFILLER_20_488 VGND VGND VPWR VPWR sky130_fd_sc_hd__fill_2
XFILLER_20_499 VGND VGND VPWR VPWR sky130_fd_sc_hd__decap_3
X_6545_ _8190_/Q _8254_/Q VGND VGND VPWR VPWR _6545_/X sky130_fd_sc_hd__or2_2
XFILLER_118_343 VGND VGND VPWR VPWR sky130_fd_sc_hd__fill_1
XFILLER_118_365 VGND VGND VPWR VPWR sky130_fd_sc_hd__fill_1
X_8215_ _8218_/CLK _8215_/D VGND VGND VPWR VPWR _8215_/Q sky130_fd_sc_hd__dfxtp_2
X_6476_ _6592_/B _6476_/B _6476_/C VGND VGND VPWR VPWR _6477_/C sky130_fd_sc_hd__or3_2
X_5427_ _5245_/Y _5395_/X _5406_/X _5426_/X VGND VGND VPWR VPWR _5427_/X sky130_fd_sc_hd__a211o_2
XFILLER_58_16 VGND VGND VPWR VPWR sky130_fd_sc_hd__decap_3
XFILLER_59_102 VGND VGND VPWR VPWR sky130_fd_sc_hd__decap_3
XFILLER_87_411 VGND VGND VPWR VPWR sky130_fd_sc_hd__fill_1
XFILLER_99_260 VGND VGND VPWR VPWR sky130_fd_sc_hd__decap_3
X_8146_ _8287_/CLK _8146_/D VGND VGND VPWR VPWR _8146_/Q sky130_fd_sc_hd__dfxtp_2
X_5358_ _5356_/X _5357_/X _5596_/S VGND VGND VPWR VPWR _5358_/X sky130_fd_sc_hd__mux2_2
XTAP_TAPCELL_ROW_93_1471 VGND VPWR sky130_fd_sc_hd__tapvpwrvgnd_1
XFILLER_101_221 VGND VGND VPWR VPWR sky130_fd_sc_hd__decap_3
XFILLER_87_455 VGND VGND VPWR VPWR sky130_fd_sc_hd__decap_3
X_8077_ _8228_/CLK _8077_/D VGND VGND VPWR VPWR _8077_/Q sky130_fd_sc_hd__dfxtp_2
X_4309_ _4309_/A VGND VGND VPWR VPWR _8092_/D sky130_fd_sc_hd__buf_1
XFILLER_101_243 VGND VGND VPWR VPWR sky130_fd_sc_hd__decap_3
XFILLER_59_157 VGND VGND VPWR VPWR sky130_fd_sc_hd__decap_3
XFILLER_87_488 VGND VGND VPWR VPWR sky130_fd_sc_hd__decap_3
X_7028_ _7166_/A _7028_/B _7028_/C VGND VGND VPWR VPWR _7028_/X sky130_fd_sc_hd__and3_2
X_5289_ _5289_/A _5289_/B VGND VGND VPWR VPWR _5289_/X sky130_fd_sc_hd__xor2_2
XFILLER_101_276 VGND VGND VPWR VPWR sky130_fd_sc_hd__decap_3
XFILLER_114_44 VGND VGND VPWR VPWR sky130_fd_sc_hd__decap_3
XFILLER_28_533 VGND VGND VPWR VPWR sky130_fd_sc_hd__fill_1
XFILLER_68_691 VGND VGND VPWR VPWR sky130_fd_sc_hd__decap_3
XFILLER_75_639 VGND VGND VPWR VPWR sky130_fd_sc_hd__decap_3
XFILLER_28_544 VGND VGND VPWR VPWR sky130_fd_sc_hd__fill_2
XFILLER_55_352 VGND VGND VPWR VPWR sky130_fd_sc_hd__decap_3
XFILLER_74_26 VGND VGND VPWR VPWR sky130_fd_sc_hd__fill_2
XFILLER_83_661 VGND VGND VPWR VPWR sky130_fd_sc_hd__decap_3
XFILLER_83_694 VGND VGND VPWR VPWR sky130_fd_sc_hd__decap_3
XFILLER_15_249 VGND VGND VPWR VPWR sky130_fd_sc_hd__decap_3
XFILLER_43_536 VGND VGND VPWR VPWR sky130_fd_sc_hd__decap_3
XFILLER_55_396 VGND VGND VPWR VPWR sky130_fd_sc_hd__decap_3
XFILLER_70_333 VGND VGND VPWR VPWR sky130_fd_sc_hd__decap_3
XFILLER_70_377 VGND VGND VPWR VPWR sky130_fd_sc_hd__fill_2
XFILLER_51_580 VGND VGND VPWR VPWR sky130_fd_sc_hd__decap_3
XFILLER_90_47 VGND VGND VPWR VPWR sky130_fd_sc_hd__decap_3
XTAP_TAPCELL_ROW_13_428 VGND VPWR sky130_fd_sc_hd__tapvpwrvgnd_1
XFILLER_11_444 VGND VGND VPWR VPWR sky130_fd_sc_hd__decap_3
XFILLER_109_310 VGND VGND VPWR VPWR sky130_fd_sc_hd__fill_2
XFILLER_109_343 VGND VGND VPWR VPWR sky130_fd_sc_hd__fill_1
XFILLER_7_459 VGND VGND VPWR VPWR sky130_fd_sc_hd__decap_3
XFILLER_109_376 VGND VGND VPWR VPWR sky130_fd_sc_hd__decap_3
XFILLER_99_89 VGND VGND VPWR VPWR sky130_fd_sc_hd__decap_3
XFILLER_78_433 VGND VGND VPWR VPWR sky130_fd_sc_hd__decap_3
XFILLER_66_617 VGND VGND VPWR VPWR sky130_fd_sc_hd__decap_3
XFILLER_78_477 VGND VGND VPWR VPWR sky130_fd_sc_hd__fill_2
XFILLER_93_414 VGND VGND VPWR VPWR sky130_fd_sc_hd__fill_1
XFILLER_19_511 VGND VGND VPWR VPWR sky130_fd_sc_hd__decap_3
XFILLER_59_691 VGND VGND VPWR VPWR sky130_fd_sc_hd__decap_3
XFILLER_65_116 VGND VGND VPWR VPWR sky130_fd_sc_hd__decap_3
XFILLER_78_499 VGND VGND VPWR VPWR sky130_fd_sc_hd__decap_3
XFILLER_93_425 VGND VGND VPWR VPWR sky130_fd_sc_hd__decap_3
XFILLER_0_12 VGND VGND VPWR VPWR sky130_fd_sc_hd__decap_3
XFILLER_19_544 VGND VGND VPWR VPWR sky130_fd_sc_hd__decap_3
XFILLER_46_330 VGND VGND VPWR VPWR sky130_fd_sc_hd__decap_3
XFILLER_46_352 VGND VGND VPWR VPWR sky130_fd_sc_hd__decap_3
XFILLER_65_149 VGND VGND VPWR VPWR sky130_fd_sc_hd__decap_3
XFILLER_93_458 VGND VGND VPWR VPWR sky130_fd_sc_hd__decap_3
XPHY_EDGE_ROW_100_Left_220 VGND VGND VPWR VPWR sky130_fd_sc_hd__decap_3
Xclone258 _7765_/A VGND VGND VPWR VPWR _7783_/A sky130_fd_sc_hd__clkbuf_16
XFILLER_34_525 VGND VGND VPWR VPWR sky130_fd_sc_hd__decap_3
XFILLER_46_385 VGND VGND VPWR VPWR sky130_fd_sc_hd__fill_1
XTAP_TAPCELL_ROW_105_1618 VGND VPWR sky130_fd_sc_hd__tapvpwrvgnd_1
XTAP_TAPCELL_ROW_105_1629 VGND VPWR sky130_fd_sc_hd__tapvpwrvgnd_1
XFILLER_46_396 VGND VGND VPWR VPWR sky130_fd_sc_hd__decap_3
XFILLER_61_322 VGND VGND VPWR VPWR sky130_fd_sc_hd__fill_2
XFILLER_61_333 VGND VGND VPWR VPWR sky130_fd_sc_hd__decap_3
XFILLER_73_193 VGND VGND VPWR VPWR sky130_fd_sc_hd__fill_1
XFILLER_61_355 VGND VGND VPWR VPWR sky130_fd_sc_hd__decap_3
XFILLER_61_366 VGND VGND VPWR VPWR sky130_fd_sc_hd__decap_3
XFILLER_30_731 VGND VGND VPWR VPWR sky130_fd_sc_hd__fill_2
XFILLER_42_580 VGND VGND VPWR VPWR sky130_fd_sc_hd__fill_1
XFILLER_61_399 VGND VGND VPWR VPWR sky130_fd_sc_hd__decap_3
XTAP_TAPCELL_ROW_64_1094 VGND VPWR sky130_fd_sc_hd__tapvpwrvgnd_1
XFILLER_14_293 VGND VGND VPWR VPWR sky130_fd_sc_hd__decap_3
XFILLER_9_65 VGND VGND VPWR VPWR sky130_fd_sc_hd__fill_1
X_4660_ _7930_/B _8134_/Q VGND VGND VPWR VPWR _4661_/A sky130_fd_sc_hd__and2_2
XTAP_TAPCELL_ROW_40_781 VGND VPWR sky130_fd_sc_hd__tapvpwrvgnd_1
X_6330_ _6330_/A VGND VGND VPWR VPWR _6330_/Y sky130_fd_sc_hd__inv_2
X_4591_ _4591_/A VGND VGND VPWR VPWR _8233_/D sky130_fd_sc_hd__buf_1
XFILLER_103_508 VGND VGND VPWR VPWR sky130_fd_sc_hd__decap_3
XFILLER_115_346 VGND VGND VPWR VPWR sky130_fd_sc_hd__decap_3
XFILLER_6_492 VGND VGND VPWR VPWR sky130_fd_sc_hd__fill_2
XTAP_TAPCELL_ROW_116_1769 VGND VPWR sky130_fd_sc_hd__tapvpwrvgnd_1
X_6261_ _8247_/Q _5397_/A _5092_/A VGND VGND VPWR VPWR _6261_/X sky130_fd_sc_hd__o21a_2
X_8000_ _8402_/CLK _8000_/D VGND VGND VPWR VPWR _8000_/Q sky130_fd_sc_hd__dfxtp_2
X_6192_ _6192_/A _6192_/B _6192_/C _6192_/D VGND VGND VPWR VPWR _6825_/B sky130_fd_sc_hd__or4_2
X_5212_ _5854_/B _6354_/A VGND VGND VPWR VPWR _5212_/X sky130_fd_sc_hd__or2_2
XFILLER_96_230 VGND VGND VPWR VPWR sky130_fd_sc_hd__decap_3
X_5143_ _5139_/X _5142_/X _5579_/S VGND VGND VPWR VPWR _5673_/A sky130_fd_sc_hd__mux2_2
XFILLER_111_552 VGND VGND VPWR VPWR sky130_fd_sc_hd__decap_3
XFILLER_29_308 VGND VGND VPWR VPWR sky130_fd_sc_hd__decap_3
XFILLER_57_617 VGND VGND VPWR VPWR sky130_fd_sc_hd__decap_3
XFILLER_56_138 VGND VGND VPWR VPWR sky130_fd_sc_hd__fill_2
XFILLER_57_639 VGND VGND VPWR VPWR sky130_fd_sc_hd__decap_3
XFILLER_69_488 VGND VGND VPWR VPWR sky130_fd_sc_hd__decap_3
XFILLER_96_274 VGND VGND VPWR VPWR sky130_fd_sc_hd__decap_3
XFILLER_96_296 VGND VGND VPWR VPWR sky130_fd_sc_hd__decap_3
X_5074_ _8290_/Q VGND VGND VPWR VPWR _5077_/A sky130_fd_sc_hd__inv_2
XFILLER_37_330 VGND VGND VPWR VPWR sky130_fd_sc_hd__decap_3
XFILLER_49_190 VGND VGND VPWR VPWR sky130_fd_sc_hd__decap_3
XFILLER_84_469 VGND VGND VPWR VPWR sky130_fd_sc_hd__decap_3
X_4025_ _8339_/Q _8342_/Q _8347_/Q _8351_/Q VGND VGND VPWR VPWR _4026_/D sky130_fd_sc_hd__or4_2
XFILLER_25_514 VGND VGND VPWR VPWR sky130_fd_sc_hd__decap_3
XFILLER_37_385 VGND VGND VPWR VPWR sky130_fd_sc_hd__decap_3
XFILLER_52_300 VGND VGND VPWR VPWR sky130_fd_sc_hd__decap_3
XFILLER_65_661 VGND VGND VPWR VPWR sky130_fd_sc_hd__decap_3
XFILLER_71_119 VGND VGND VPWR VPWR sky130_fd_sc_hd__fill_2
XTAP_TAPCELL_ROW_48_881 VGND VPWR sky130_fd_sc_hd__tapvpwrvgnd_1
XFILLER_37_396 VGND VGND VPWR VPWR sky130_fd_sc_hd__decap_3
XFILLER_52_344 VGND VGND VPWR VPWR sky130_fd_sc_hd__decap_3
XFILLER_64_182 VGND VGND VPWR VPWR sky130_fd_sc_hd__decap_3
XFILLER_52_377 VGND VGND VPWR VPWR sky130_fd_sc_hd__decap_3
XFILLER_80_675 VGND VGND VPWR VPWR sky130_fd_sc_hd__fill_2
X_5976_ _6022_/B _8239_/Q _5975_/X VGND VGND VPWR VPWR _5976_/X sky130_fd_sc_hd__a21o_2
XFILLER_40_539 VGND VGND VPWR VPWR sky130_fd_sc_hd__decap_3
X_7715_ _7653_/X _8212_/Q _7655_/X _7713_/Y _7714_/X VGND VGND VPWR VPWR _7715_/X
+ sky130_fd_sc_hd__a311o_2
X_4927_ _4927_/A _8236_/Q VGND VGND VPWR VPWR _4928_/B sky130_fd_sc_hd__and2_2
XFILLER_100_57 VGND VGND VPWR VPWR sky130_fd_sc_hd__decap_3
XFILLER_20_230 VGND VGND VPWR VPWR sky130_fd_sc_hd__decap_3
X_7646_ _7646_/A _7646_/B VGND VGND VPWR VPWR _7646_/Y sky130_fd_sc_hd__nor2_2
X_4858_ _6561_/B _4858_/B VGND VGND VPWR VPWR _6486_/A sky130_fd_sc_hd__or2_4
XFILLER_109_11 VGND VGND VPWR VPWR sky130_fd_sc_hd__decap_3
XFILLER_119_663 VGND VGND VPWR VPWR sky130_fd_sc_hd__decap_3
X_7577_ _8221_/Q _8285_/Q _8284_/Q _8220_/Q VGND VGND VPWR VPWR _7578_/B sky130_fd_sc_hd__a211o_2
X_4789_ _4789_/A _4974_/A VGND VGND VPWR VPWR _7255_/A sky130_fd_sc_hd__nor2_2
XTAP_TAPCELL_ROW_95_1500 VGND VPWR sky130_fd_sc_hd__tapvpwrvgnd_1
XFILLER_109_33 VGND VGND VPWR VPWR sky130_fd_sc_hd__decap_3
XFILLER_109_55 VGND VGND VPWR VPWR sky130_fd_sc_hd__fill_1
XFILLER_118_184 VGND VGND VPWR VPWR sky130_fd_sc_hd__fill_1
XFILLER_119_685 VGND VGND VPWR VPWR sky130_fd_sc_hd__decap_3
X_6528_ _6528_/A _6528_/B VGND VGND VPWR VPWR _6528_/X sky130_fd_sc_hd__or2_2
XFILLER_106_346 VGND VGND VPWR VPWR sky130_fd_sc_hd__decap_3
XFILLER_109_88 VGND VGND VPWR VPWR sky130_fd_sc_hd__fill_2
X_6459_ _6454_/Y _6456_/Y _6458_/Y _8229_/Q VGND VGND VPWR VPWR _6471_/A sky130_fd_sc_hd__a22oi_2
XFILLER_0_613 VGND VGND VPWR VPWR sky130_fd_sc_hd__decap_3
XFILLER_106_368 VGND VGND VPWR VPWR sky130_fd_sc_hd__decap_3
XFILLER_79_208 VGND VGND VPWR VPWR sky130_fd_sc_hd__decap_3
X_8129_ _8397_/CLK _8129_/D VGND VGND VPWR VPWR _8129_/Q sky130_fd_sc_hd__dfxtp_2
XFILLER_48_606 VGND VGND VPWR VPWR sky130_fd_sc_hd__decap_3
XFILLER_87_252 VGND VGND VPWR VPWR sky130_fd_sc_hd__decap_3
XFILLER_87_263 VGND VGND VPWR VPWR sky130_fd_sc_hd__decap_3
XFILLER_47_105 VGND VGND VPWR VPWR sky130_fd_sc_hd__decap_3
XFILLER_47_116 VGND VGND VPWR VPWR sky130_fd_sc_hd__decap_3
XFILLER_48_639 VGND VGND VPWR VPWR sky130_fd_sc_hd__decap_3
XFILLER_75_414 VGND VGND VPWR VPWR sky130_fd_sc_hd__decap_3
XFILLER_87_274 VGND VGND VPWR VPWR sky130_fd_sc_hd__decap_3
XFILLER_87_296 VGND VGND VPWR VPWR sky130_fd_sc_hd__decap_3
XFILLER_75_458 VGND VGND VPWR VPWR sky130_fd_sc_hd__decap_3
XFILLER_85_69 VGND VGND VPWR VPWR sky130_fd_sc_hd__decap_3
XFILLER_16_503 VGND VGND VPWR VPWR sky130_fd_sc_hd__decap_3
XFILLER_18_85 VGND VGND VPWR VPWR sky130_fd_sc_hd__fill_2
XFILLER_28_374 VGND VGND VPWR VPWR sky130_fd_sc_hd__decap_3
XFILLER_90_439 VGND VGND VPWR VPWR sky130_fd_sc_hd__decap_3
XFILLER_18_96 VGND VGND VPWR VPWR sky130_fd_sc_hd__decap_3
XFILLER_43_322 VGND VGND VPWR VPWR sky130_fd_sc_hd__decap_3
XFILLER_56_694 VGND VGND VPWR VPWR sky130_fd_sc_hd__decap_3
XFILLER_83_491 VGND VGND VPWR VPWR sky130_fd_sc_hd__decap_3
XFILLER_16_569 VGND VGND VPWR VPWR sky130_fd_sc_hd__decap_3
XFILLER_43_355 VGND VGND VPWR VPWR sky130_fd_sc_hd__fill_1
XFILLER_70_141 VGND VGND VPWR VPWR sky130_fd_sc_hd__decap_3
XFILLER_71_664 VGND VGND VPWR VPWR sky130_fd_sc_hd__decap_3
XFILLER_43_399 VGND VGND VPWR VPWR sky130_fd_sc_hd__decap_3
XFILLER_70_174 VGND VGND VPWR VPWR sky130_fd_sc_hd__decap_3
XTAP_TAPCELL_ROW_26_597 VGND VPWR sky130_fd_sc_hd__tapvpwrvgnd_1
XFILLER_8_713 VGND VGND VPWR VPWR sky130_fd_sc_hd__decap_3
XTAP_TAPCELL_ROW_100_1559 VGND VPWR sky130_fd_sc_hd__tapvpwrvgnd_1
XFILLER_50_50 VGND VGND VPWR VPWR sky130_fd_sc_hd__fill_1
XFILLER_109_162 VGND VGND VPWR VPWR sky130_fd_sc_hd__decap_3
XFILLER_50_72 VGND VGND VPWR VPWR sky130_fd_sc_hd__decap_3
XFILLER_50_94 VGND VGND VPWR VPWR sky130_fd_sc_hd__decap_3
XFILLER_7_278 VGND VGND VPWR VPWR sky130_fd_sc_hd__fill_2
XFILLER_109_184 VGND VGND VPWR VPWR sky130_fd_sc_hd__decap_3
XFILLER_112_349 VGND VGND VPWR VPWR sky130_fd_sc_hd__decap_3
XFILLER_3_495 VGND VGND VPWR VPWR sky130_fd_sc_hd__decap_3
XFILLER_39_606 VGND VGND VPWR VPWR sky130_fd_sc_hd__decap_3
XFILLER_39_617 VGND VGND VPWR VPWR sky130_fd_sc_hd__decap_3
XFILLER_78_230 VGND VGND VPWR VPWR sky130_fd_sc_hd__decap_3
XFILLER_94_701 VGND VGND VPWR VPWR sky130_fd_sc_hd__fill_1
XFILLER_78_274 VGND VGND VPWR VPWR sky130_fd_sc_hd__fill_1
XFILLER_78_285 VGND VGND VPWR VPWR sky130_fd_sc_hd__decap_3
XTAP_TAPCELL_ROW_111_1699 VGND VPWR sky130_fd_sc_hd__tapvpwrvgnd_1
XFILLER_54_609 VGND VGND VPWR VPWR sky130_fd_sc_hd__decap_3
XFILLER_19_352 VGND VGND VPWR VPWR sky130_fd_sc_hd__decap_3
XFILLER_53_108 VGND VGND VPWR VPWR sky130_fd_sc_hd__decap_3
XFILLER_19_396 VGND VGND VPWR VPWR sky130_fd_sc_hd__decap_3
XFILLER_34_333 VGND VGND VPWR VPWR sky130_fd_sc_hd__decap_3
XFILLER_46_171 VGND VGND VPWR VPWR sky130_fd_sc_hd__decap_3
XFILLER_62_631 VGND VGND VPWR VPWR sky130_fd_sc_hd__decap_3
XTAP_TAPCELL_ROW_66_1123 VGND VPWR sky130_fd_sc_hd__tapvpwrvgnd_1
XTAP_TAPCELL_ROW_66_1112 VGND VPWR sky130_fd_sc_hd__tapvpwrvgnd_1
X_5830_ _5830_/A VGND VGND VPWR VPWR _5830_/Y sky130_fd_sc_hd__inv_2
XTAP_TAPCELL_ROW_45_840 VGND VPWR sky130_fd_sc_hd__tapvpwrvgnd_1
XFILLER_22_528 VGND VGND VPWR VPWR sky130_fd_sc_hd__decap_3
XFILLER_22_539 VGND VGND VPWR VPWR sky130_fd_sc_hd__decap_3
XFILLER_34_388 VGND VGND VPWR VPWR sky130_fd_sc_hd__decap_3
X_5761_ _5737_/X _5754_/Y _5760_/X _7898_/B VGND VGND VPWR VPWR _8303_/D sky130_fd_sc_hd__o31a_2
X_7500_ _7619_/A _4736_/Y _4737_/A VGND VGND VPWR VPWR _7500_/Y sky130_fd_sc_hd__o21bai_2
X_4712_ _7619_/A _7631_/B VGND VGND VPWR VPWR _5239_/B sky130_fd_sc_hd__or2_2
X_7431_ _7606_/A1 _7404_/X _7430_/Y _7930_/B VGND VGND VPWR VPWR _8350_/D sky130_fd_sc_hd__o211a_4
Xrebuffer309 _7227_/C VGND VGND VPWR VPWR _7130_/A sky130_fd_sc_hd__buf_2
X_5692_ _6717_/A VGND VGND VPWR VPWR _6944_/A sky130_fd_sc_hd__buf_1
XFILLER_30_594 VGND VGND VPWR VPWR sky130_fd_sc_hd__decap_3
X_4643_ _4643_/A VGND VGND VPWR VPWR _8259_/D sky130_fd_sc_hd__buf_1
X_7362_ _6721_/A _7351_/X _7352_/Y _7361_/X VGND VGND VPWR VPWR _7362_/X sky130_fd_sc_hd__a211o_2
X_4574_ _7898_/B _8091_/Q VGND VGND VPWR VPWR _4575_/A sky130_fd_sc_hd__and2_2
X_7293_ _5396_/A _8212_/Q _7292_/Y _5402_/X _7366_/C VGND VGND VPWR VPWR _7293_/X
+ sky130_fd_sc_hd__a32o_2
X_6313_ _5587_/X _6311_/X _6312_/X _5108_/X VGND VGND VPWR VPWR _6313_/X sky130_fd_sc_hd__a22o_2
XTAP_TAPCELL_ROW_77_1263 VGND VPWR sky130_fd_sc_hd__tapvpwrvgnd_1
XFILLER_115_154 VGND VGND VPWR VPWR sky130_fd_sc_hd__decap_3
X_6244_ _5567_/X _5578_/X _5569_/X _5579_/X _6620_/A _6507_/S VGND VGND VPWR VPWR
+ _6244_/X sky130_fd_sc_hd__mux4_2
XFILLER_103_349 VGND VGND VPWR VPWR sky130_fd_sc_hd__decap_3
XFILLER_39_29 VGND VGND VPWR VPWR sky130_fd_sc_hd__decap_3
XTAP_TAPCELL_ROW_90_1430 VGND VPWR sky130_fd_sc_hd__tapvpwrvgnd_1
X_6175_ _6169_/Y _6171_/Y _7300_/A _7193_/A VGND VGND VPWR VPWR _6175_/X sky130_fd_sc_hd__a22o_2
XFILLER_111_360 VGND VGND VPWR VPWR sky130_fd_sc_hd__decap_3
XFILLER_29_105 VGND VGND VPWR VPWR sky130_fd_sc_hd__fill_2
XFILLER_29_116 VGND VGND VPWR VPWR sky130_fd_sc_hd__decap_3
XFILLER_69_296 VGND VGND VPWR VPWR sky130_fd_sc_hd__decap_3
XFILLER_84_200 VGND VGND VPWR VPWR sky130_fd_sc_hd__decap_3
X_5126_ _8208_/Q _8209_/Q _5484_/S VGND VGND VPWR VPWR _5126_/X sky130_fd_sc_hd__mux2_2
XFILLER_55_17 VGND VGND VPWR VPWR sky130_fd_sc_hd__decap_3
XFILLER_57_447 VGND VGND VPWR VPWR sky130_fd_sc_hd__fill_1
XFILLER_57_458 VGND VGND VPWR VPWR sky130_fd_sc_hd__decap_3
XFILLER_84_244 VGND VGND VPWR VPWR sky130_fd_sc_hd__decap_3
X_5057_ _4971_/C _5036_/X _5045_/X _4917_/A _5056_/X VGND VGND VPWR VPWR _5057_/X
+ sky130_fd_sc_hd__o221a_2
XFILLER_25_300 VGND VGND VPWR VPWR sky130_fd_sc_hd__decap_3
XFILLER_44_108 VGND VGND VPWR VPWR sky130_fd_sc_hd__fill_1
XFILLER_72_406 VGND VGND VPWR VPWR sky130_fd_sc_hd__decap_3
XFILLER_84_277 VGND VGND VPWR VPWR sky130_fd_sc_hd__decap_3
X_4008_ _7843_/A _8358_/Q VGND VGND VPWR VPWR _4009_/A sky130_fd_sc_hd__and2_2
XFILLER_25_333 VGND VGND VPWR VPWR sky130_fd_sc_hd__decap_3
XFILLER_37_193 VGND VGND VPWR VPWR sky130_fd_sc_hd__decap_3
XFILLER_38_694 VGND VGND VPWR VPWR sky130_fd_sc_hd__decap_3
XFILLER_53_620 VGND VGND VPWR VPWR sky130_fd_sc_hd__decap_3
XFILLER_111_23 VGND VGND VPWR VPWR sky130_fd_sc_hd__decap_3
XFILLER_52_130 VGND VGND VPWR VPWR sky130_fd_sc_hd__decap_3
XFILLER_52_141 VGND VGND VPWR VPWR sky130_fd_sc_hd__fill_2
XFILLER_53_653 VGND VGND VPWR VPWR sky130_fd_sc_hd__decap_3
XFILLER_80_461 VGND VGND VPWR VPWR sky130_fd_sc_hd__decap_3
XFILLER_25_377 VGND VGND VPWR VPWR sky130_fd_sc_hd__decap_3
XFILLER_25_388 VGND VGND VPWR VPWR sky130_fd_sc_hd__decap_3
XFILLER_52_163 VGND VGND VPWR VPWR sky130_fd_sc_hd__decap_3
XFILLER_80_494 VGND VGND VPWR VPWR sky130_fd_sc_hd__decap_3
X_5959_ _7202_/A _5959_/B VGND VGND VPWR VPWR _5959_/Y sky130_fd_sc_hd__nand2_2
XFILLER_40_336 VGND VGND VPWR VPWR sky130_fd_sc_hd__fill_2
XFILLER_40_358 VGND VGND VPWR VPWR sky130_fd_sc_hd__decap_3
XFILLER_71_49 VGND VGND VPWR VPWR sky130_fd_sc_hd__decap_3
XTAP_TAPCELL_ROW_23_556 VGND VPWR sky130_fd_sc_hd__tapvpwrvgnd_1
XFILLER_21_561 VGND VGND VPWR VPWR sky130_fd_sc_hd__fill_2
XFILLER_21_583 VGND VGND VPWR VPWR sky130_fd_sc_hd__fill_2
XFILLER_21_594 VGND VGND VPWR VPWR sky130_fd_sc_hd__decap_3
X_7629_ _7607_/X _7609_/Y _7611_/X _7614_/X _7628_/X VGND VGND VPWR VPWR _7630_/C
+ sky130_fd_sc_hd__o221a_4
Xrebuffer832 _8253_/Q VGND VGND VPWR VPWR _6596_/A2 sky130_fd_sc_hd__buf_2
Xrebuffer843 _7637_/Y VGND VGND VPWR VPWR _7834_/A1 sky130_fd_sc_hd__buf_2
XFILLER_5_727 VGND VGND VPWR VPWR sky130_fd_sc_hd__fill_1
XFILLER_107_633 VGND VGND VPWR VPWR sky130_fd_sc_hd__decap_3
Xrebuffer887 _6550_/A VGND VGND VPWR VPWR _6489_/B sky130_fd_sc_hd__buf_2
XFILLER_106_165 VGND VGND VPWR VPWR sky130_fd_sc_hd__decap_3
XFILLER_4_259 VGND VGND VPWR VPWR sky130_fd_sc_hd__decap_3
XFILLER_0_421 VGND VGND VPWR VPWR sky130_fd_sc_hd__decap_3
XFILLER_96_35 VGND VGND VPWR VPWR sky130_fd_sc_hd__decap_3
XFILLER_76_701 VGND VGND VPWR VPWR sky130_fd_sc_hd__decap_3
XFILLER_96_57 VGND VGND VPWR VPWR sky130_fd_sc_hd__decap_3
XFILLER_102_371 VGND VGND VPWR VPWR sky130_fd_sc_hd__decap_3
XFILLER_29_51 VGND VGND VPWR VPWR sky130_fd_sc_hd__decap_3
XFILLER_48_436 VGND VGND VPWR VPWR sky130_fd_sc_hd__decap_3
XFILLER_29_84 VGND VGND VPWR VPWR sky130_fd_sc_hd__decap_3
XFILLER_75_222 VGND VGND VPWR VPWR sky130_fd_sc_hd__fill_2
XFILLER_91_715 VGND VGND VPWR VPWR sky130_fd_sc_hd__decap_3
XFILLER_16_300 VGND VGND VPWR VPWR sky130_fd_sc_hd__decap_3
XFILLER_44_620 VGND VGND VPWR VPWR sky130_fd_sc_hd__decap_3
XFILLER_56_480 VGND VGND VPWR VPWR sky130_fd_sc_hd__decap_3
XFILLER_75_299 VGND VGND VPWR VPWR sky130_fd_sc_hd__decap_3
XFILLER_90_236 VGND VGND VPWR VPWR sky130_fd_sc_hd__fill_2
XFILLER_90_247 VGND VGND VPWR VPWR sky130_fd_sc_hd__decap_3
XTAP_TAPCELL_ROW_3_292 VGND VPWR sky130_fd_sc_hd__tapvpwrvgnd_1
XFILLER_43_141 VGND VGND VPWR VPWR sky130_fd_sc_hd__decap_3
XFILLER_90_269 VGND VGND VPWR VPWR sky130_fd_sc_hd__fill_1
XFILLER_71_494 VGND VGND VPWR VPWR sky130_fd_sc_hd__decap_3
XTAP_TAPCELL_ROW_42_810 VGND VPWR sky130_fd_sc_hd__tapvpwrvgnd_1
XFILLER_8_510 VGND VGND VPWR VPWR sky130_fd_sc_hd__fill_2
XTAP_TAPCELL_ROW_61_1053 VGND VPWR sky130_fd_sc_hd__tapvpwrvgnd_1
XFILLER_12_583 VGND VGND VPWR VPWR sky130_fd_sc_hd__decap_3
XFILLER_61_93 VGND VGND VPWR VPWR sky130_fd_sc_hd__decap_3
XFILLER_8_554 VGND VGND VPWR VPWR sky130_fd_sc_hd__decap_3
XFILLER_8_576 VGND VGND VPWR VPWR sky130_fd_sc_hd__decap_3
XANTENNA_4 _4017_/A VGND VGND VPWR VPWR sky130_fd_sc_hd__diode_2
XFILLER_6_88 VGND VGND VPWR VPWR sky130_fd_sc_hd__decap_3
XFILLER_98_303 VGND VGND VPWR VPWR sky130_fd_sc_hd__fill_2
XTAP_TAPCELL_ROW_113_1728 VGND VPWR sky130_fd_sc_hd__tapvpwrvgnd_1
XFILLER_3_281 VGND VGND VPWR VPWR sky130_fd_sc_hd__decap_3
XFILLER_98_325 VGND VGND VPWR VPWR sky130_fd_sc_hd__decap_3
XFILLER_98_347 VGND VGND VPWR VPWR sky130_fd_sc_hd__decap_3
X_4290_ _7843_/A _4290_/B VGND VGND VPWR VPWR _4291_/A sky130_fd_sc_hd__and2_2
XFILLER_100_319 VGND VGND VPWR VPWR sky130_fd_sc_hd__decap_3
XFILLER_39_414 VGND VGND VPWR VPWR sky130_fd_sc_hd__decap_3
XFILLER_66_200 VGND VGND VPWR VPWR sky130_fd_sc_hd__decap_3
XFILLER_79_572 VGND VGND VPWR VPWR sky130_fd_sc_hd__fill_2
Xsplit441 _6490_/A VGND VGND VPWR VPWR _7725_/B sky130_fd_sc_hd__buf_6
XTAP_TAPCELL_ROW_72_1193 VGND VPWR sky130_fd_sc_hd__tapvpwrvgnd_1
XFILLER_39_458 VGND VGND VPWR VPWR sky130_fd_sc_hd__decap_3
XFILLER_94_531 VGND VGND VPWR VPWR sky130_fd_sc_hd__fill_1
XFILLER_94_542 VGND VGND VPWR VPWR sky130_fd_sc_hd__decap_3
XFILLER_54_406 VGND VGND VPWR VPWR sky130_fd_sc_hd__decap_3
XFILLER_66_277 VGND VGND VPWR VPWR sky130_fd_sc_hd__decap_3
XFILLER_81_203 VGND VGND VPWR VPWR sky130_fd_sc_hd__decap_3
XFILLER_82_704 VGND VGND VPWR VPWR sky130_fd_sc_hd__decap_3
XFILLER_82_726 VGND VGND VPWR VPWR sky130_fd_sc_hd__decap_3
XFILLER_94_564 VGND VGND VPWR VPWR sky130_fd_sc_hd__decap_3
X_7980_ _8384_/CLK _7980_/D VGND VGND VPWR VPWR _7980_/Q sky130_fd_sc_hd__dfxtp_2
XFILLER_35_642 VGND VGND VPWR VPWR sky130_fd_sc_hd__decap_3
XFILLER_81_225 VGND VGND VPWR VPWR sky130_fd_sc_hd__decap_3
X_6931_ _8201_/Q _6915_/X _6919_/X _6925_/Y _6930_/X VGND VGND VPWR VPWR _6931_/X
+ sky130_fd_sc_hd__a2111o_2
XFILLER_34_141 VGND VGND VPWR VPWR sky130_fd_sc_hd__decap_3
XFILLER_81_258 VGND VGND VPWR VPWR sky130_fd_sc_hd__decap_3
X_6862_ _5492_/Y _5293_/Y _8199_/Q VGND VGND VPWR VPWR _6862_/X sky130_fd_sc_hd__mux2_2
XFILLER_34_174 VGND VGND VPWR VPWR sky130_fd_sc_hd__fill_2
XFILLER_35_686 VGND VGND VPWR VPWR sky130_fd_sc_hd__decap_3
XFILLER_50_623 VGND VGND VPWR VPWR sky130_fd_sc_hd__decap_3
XFILLER_62_472 VGND VGND VPWR VPWR sky130_fd_sc_hd__decap_3
XFILLER_62_483 VGND VGND VPWR VPWR sky130_fd_sc_hd__decap_3
XFILLER_62_494 VGND VGND VPWR VPWR sky130_fd_sc_hd__fill_1
X_5813_ _7783_/B _7776_/B _5896_/A _5407_/A VGND VGND VPWR VPWR _5813_/X sky130_fd_sc_hd__o31a_2
XFILLER_22_347 VGND VGND VPWR VPWR sky130_fd_sc_hd__decap_3
X_6793_ _4858_/B _6794_/B _8254_/Q VGND VGND VPWR VPWR _6793_/X sky130_fd_sc_hd__and3b_2
X_5744_ _6008_/B _5739_/X _5743_/X VGND VGND VPWR VPWR _5744_/Y sky130_fd_sc_hd__a21oi_2
XTAP_TAPCELL_ROW_20_515 VGND VPWR sky130_fd_sc_hd__tapvpwrvgnd_1
X_5675_ _6321_/B _7646_/A VGND VGND VPWR VPWR _5675_/Y sky130_fd_sc_hd__nand2_2
X_7414_ _8280_/Q _5600_/A _5400_/A VGND VGND VPWR VPWR _7414_/Y sky130_fd_sc_hd__o21ai_2
X_8394_ _8397_/CLK _8394_/D VGND VGND VPWR VPWR _8394_/Q sky130_fd_sc_hd__dfxtp_2
X_4626_ _7930_/B _8117_/Q VGND VGND VPWR VPWR _4627_/A sky130_fd_sc_hd__and2_2
X_7345_ _6944_/A _7383_/B _7424_/C _5732_/X VGND VGND VPWR VPWR _7345_/X sky130_fd_sc_hd__a2bb2o_2
XFILLER_116_452 VGND VGND VPWR VPWR sky130_fd_sc_hd__fill_1
XFILLER_116_474 VGND VGND VPWR VPWR sky130_fd_sc_hd__fill_2
XFILLER_2_719 VGND VGND VPWR VPWR sky130_fd_sc_hd__decap_3
Xmax_cap251 _5127_/A VGND VGND VPWR VPWR _7812_/A sky130_fd_sc_hd__buf_12
Xmax_cap240 _8291_/Q VGND VGND VPWR VPWR _6769_/B sky130_fd_sc_hd__buf_12
X_4557_ _4557_/A VGND VGND VPWR VPWR _8216_/D sky130_fd_sc_hd__buf_1
XFILLER_104_625 VGND VGND VPWR VPWR sky130_fd_sc_hd__decap_3
XFILLER_116_496 VGND VGND VPWR VPWR sky130_fd_sc_hd__decap_3
X_7276_ _7930_/B _7276_/B VGND VGND VPWR VPWR _7277_/A sky130_fd_sc_hd__and2_2
X_4488_ _7898_/B _8048_/Q VGND VGND VPWR VPWR _4489_/A sky130_fd_sc_hd__and2_2
XFILLER_103_146 VGND VGND VPWR VPWR sky130_fd_sc_hd__decap_3
XFILLER_106_23 VGND VGND VPWR VPWR sky130_fd_sc_hd__decap_3
XFILLER_58_701 VGND VGND VPWR VPWR sky130_fd_sc_hd__decap_3
X_6227_ _7725_/B _5701_/X _6226_/X _8288_/Q VGND VGND VPWR VPWR _6227_/X sky130_fd_sc_hd__o22a_2
XFILLER_106_78 VGND VGND VPWR VPWR sky130_fd_sc_hd__decap_3
XFILLER_112_680 VGND VGND VPWR VPWR sky130_fd_sc_hd__decap_3
XFILLER_58_723 VGND VGND VPWR VPWR sky130_fd_sc_hd__decap_3
X_6158_ _5587_/X _6156_/X _6157_/X _5108_/X VGND VGND VPWR VPWR _6158_/X sky130_fd_sc_hd__a22o_2
XFILLER_57_222 VGND VGND VPWR VPWR sky130_fd_sc_hd__fill_2
XFILLER_85_542 VGND VGND VPWR VPWR sky130_fd_sc_hd__decap_3
XFILLER_97_391 VGND VGND VPWR VPWR sky130_fd_sc_hd__fill_1
X_5109_ _8290_/Q _6769_/B VGND VGND VPWR VPWR _5415_/A sky130_fd_sc_hd__nand2_2
XFILLER_17_108 VGND VGND VPWR VPWR sky130_fd_sc_hd__decap_3
XFILLER_57_266 VGND VGND VPWR VPWR sky130_fd_sc_hd__decap_3
XFILLER_72_203 VGND VGND VPWR VPWR sky130_fd_sc_hd__decap_3
XFILLER_73_715 VGND VGND VPWR VPWR sky130_fd_sc_hd__fill_2
X_6089_ _8178_/Q _8242_/Q _8288_/Q VGND VGND VPWR VPWR _6089_/X sky130_fd_sc_hd__mux2_2
XFILLER_17_119 VGND VGND VPWR VPWR sky130_fd_sc_hd__decap_3
XFILLER_26_620 VGND VGND VPWR VPWR sky130_fd_sc_hd__fill_2
XFILLER_57_299 VGND VGND VPWR VPWR sky130_fd_sc_hd__decap_3
XFILLER_72_236 VGND VGND VPWR VPWR sky130_fd_sc_hd__fill_1
XTAP_TAPCELL_ROW_28_626 VGND VPWR sky130_fd_sc_hd__tapvpwrvgnd_1
XFILLER_72_247 VGND VGND VPWR VPWR sky130_fd_sc_hd__decap_3
XTAP_TAPCELL_ROW_0_240 VGND VPWR sky130_fd_sc_hd__tapvpwrvgnd_1
XTAP_TAPCELL_ROW_0_251 VGND VPWR sky130_fd_sc_hd__tapvpwrvgnd_1
XTAP_TAPCELL_ROW_0_262 VGND VPWR sky130_fd_sc_hd__tapvpwrvgnd_1
XFILLER_13_325 VGND VGND VPWR VPWR sky130_fd_sc_hd__decap_3
XFILLER_25_152 VGND VGND VPWR VPWR sky130_fd_sc_hd__decap_3
XFILLER_53_461 VGND VGND VPWR VPWR sky130_fd_sc_hd__decap_3
XFILLER_25_196 VGND VGND VPWR VPWR sky130_fd_sc_hd__decap_3
XFILLER_40_144 VGND VGND VPWR VPWR sky130_fd_sc_hd__decap_3
XFILLER_80_280 VGND VGND VPWR VPWR sky130_fd_sc_hd__decap_3
XFILLER_9_307 VGND VGND VPWR VPWR sky130_fd_sc_hd__decap_3
XFILLER_21_391 VGND VGND VPWR VPWR sky130_fd_sc_hd__fill_1
XFILLER_31_85 VGND VGND VPWR VPWR sky130_fd_sc_hd__decap_3
XFILLER_107_452 VGND VGND VPWR VPWR sky130_fd_sc_hd__decap_3
XFILLER_5_557 VGND VGND VPWR VPWR sky130_fd_sc_hd__decap_3
XTAP_TAPCELL_ROW_8_362 VGND VPWR sky130_fd_sc_hd__tapvpwrvgnd_1
XFILLER_0_262 VGND VGND VPWR VPWR sky130_fd_sc_hd__decap_3
XFILLER_48_233 VGND VGND VPWR VPWR sky130_fd_sc_hd__decap_3
XFILLER_76_531 VGND VGND VPWR VPWR sky130_fd_sc_hd__fill_1
XFILLER_76_542 VGND VGND VPWR VPWR sky130_fd_sc_hd__decap_3
XFILLER_88_391 VGND VGND VPWR VPWR sky130_fd_sc_hd__fill_2
Xinput130 operand_b[6] VGND VGND VPWR VPWR _4316_/B sky130_fd_sc_hd__clkdlybuf4s25_1
XFILLER_36_406 VGND VGND VPWR VPWR sky130_fd_sc_hd__decap_3
XFILLER_48_277 VGND VGND VPWR VPWR sky130_fd_sc_hd__decap_3
XFILLER_64_704 VGND VGND VPWR VPWR sky130_fd_sc_hd__fill_2
XFILLER_64_715 VGND VGND VPWR VPWR sky130_fd_sc_hd__fill_2
XFILLER_76_586 VGND VGND VPWR VPWR sky130_fd_sc_hd__fill_2
XFILLER_17_620 VGND VGND VPWR VPWR sky130_fd_sc_hd__fill_1
XFILLER_36_439 VGND VGND VPWR VPWR sky130_fd_sc_hd__decap_3
XFILLER_56_82 VGND VGND VPWR VPWR sky130_fd_sc_hd__fill_2
XFILLER_63_214 VGND VGND VPWR VPWR sky130_fd_sc_hd__decap_3
XFILLER_63_225 VGND VGND VPWR VPWR sky130_fd_sc_hd__decap_3
XFILLER_16_141 VGND VGND VPWR VPWR sky130_fd_sc_hd__decap_3
XFILLER_63_258 VGND VGND VPWR VPWR sky130_fd_sc_hd__decap_3
XFILLER_16_174 VGND VGND VPWR VPWR sky130_fd_sc_hd__decap_3
XFILLER_32_601 VGND VGND VPWR VPWR sky130_fd_sc_hd__decap_3
XFILLER_44_472 VGND VGND VPWR VPWR sky130_fd_sc_hd__decap_3
XFILLER_44_483 VGND VGND VPWR VPWR sky130_fd_sc_hd__decap_3
XFILLER_91_589 VGND VGND VPWR VPWR sky130_fd_sc_hd__decap_3
XFILLER_32_645 VGND VGND VPWR VPWR sky130_fd_sc_hd__decap_3
XFILLER_31_155 VGND VGND VPWR VPWR sky130_fd_sc_hd__decap_3
XFILLER_32_678 VGND VGND VPWR VPWR sky130_fd_sc_hd__decap_3
XFILLER_12_391 VGND VGND VPWR VPWR sky130_fd_sc_hd__decap_3
XFILLER_117_205 VGND VGND VPWR VPWR sky130_fd_sc_hd__fill_1
XFILLER_118_728 VGND VGND VPWR VPWR sky130_fd_sc_hd__decap_3
XFILLER_8_362 VGND VGND VPWR VPWR sky130_fd_sc_hd__fill_2
X_5460_ _5172_/X _5147_/X _5596_/S VGND VGND VPWR VPWR _5460_/X sky130_fd_sc_hd__mux2_2
XFILLER_68_3 VGND VGND VPWR VPWR sky130_fd_sc_hd__decap_3
X_4411_ _4411_/A VGND VGND VPWR VPWR _8143_/D sky130_fd_sc_hd__buf_1
X_5391_ _5260_/X _5256_/X _5634_/S VGND VGND VPWR VPWR _5391_/X sky130_fd_sc_hd__mux2_2
XTAP_TAPCELL_ROW_74_1222 VGND VPWR sky130_fd_sc_hd__tapvpwrvgnd_1
X_7130_ _7130_/A VGND VGND VPWR VPWR _7130_/Y sky130_fd_sc_hd__bufinv_8
X_4342_ _7898_/B _4342_/B VGND VGND VPWR VPWR _4343_/A sky130_fd_sc_hd__and2_2
XFILLER_113_433 VGND VGND VPWR VPWR sky130_fd_sc_hd__decap_3
XFILLER_113_455 VGND VGND VPWR VPWR sky130_fd_sc_hd__fill_1
XFILLER_98_133 VGND VGND VPWR VPWR sky130_fd_sc_hd__decap_3
XFILLER_98_144 VGND VGND VPWR VPWR sky130_fd_sc_hd__decap_3
X_7061_ _6531_/X _7060_/X _6240_/X _6817_/X _5182_/A _7745_/A VGND VGND VPWR VPWR
+ _7061_/X sky130_fd_sc_hd__mux4_2
X_4273_ _4273_/A VGND VGND VPWR VPWR _8074_/D sky130_fd_sc_hd__buf_1
XFILLER_101_617 VGND VGND VPWR VPWR sky130_fd_sc_hd__decap_3
XFILLER_101_639 VGND VGND VPWR VPWR sky130_fd_sc_hd__decap_3
XFILLER_113_499 VGND VGND VPWR VPWR sky130_fd_sc_hd__decap_3
XFILLER_86_306 VGND VGND VPWR VPWR sky130_fd_sc_hd__fill_2
XFILLER_98_177 VGND VGND VPWR VPWR sky130_fd_sc_hd__decap_3
X_6012_ _6097_/A _6022_/B _6380_/S VGND VGND VPWR VPWR _6012_/X sky130_fd_sc_hd__mux2_2
.ends
